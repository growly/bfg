* Anonymous `circuit.Package`
* Generated by `vlsirtools.SpiceNetlister`
*

.SUBCKT Sky130SplitBuffer
+ A P X VPWR VGND VPB VNB
* No parameters

xpfet_1
+ Xb A VPWR VPB
+ sky130_fd_pr__pfet_01v8_hvt
+ l='150n' w='1000n'

xnfet_1
+ Xb A VGND VNB
+ sky130_fd_pr__nfet_01v8
+ l='150n' w='600n'

xpfet_2a
+ X Xb VPWR VPB
+ sky130_fd_pr__pfet_01v8_hvt
+ l='150n' w='1000n'

xnfet_2a
+ X Xb VGND VNB
+ sky130_fd_pr__nfet_01v8
+ l='150n' w='600n'

xpfet_2b
+ X Xb VPWR VPB
+ sky130_fd_pr__pfet_01v8_hvt
+ l='150n' w='1000n'

xnfet_2b
+ X Xb VGND VNB
+ sky130_fd_pr__nfet_01v8
+ l='150n' w='600n'

xpfet_0a
+ P A VPWR VPB
+ sky130_fd_pr__pfet_01v8_hvt
+ l='150n' w='1000n'

xnfet_0a
+ P A VGND VNB
+ sky130_fd_pr__nfet_01v8
+ l='150n' w='600n'

xpfet_0b
+ P A VPWR VPB
+ sky130_fd_pr__pfet_01v8_hvt
+ l='150n' w='1000n'

xnfet_0b
+ P A VGND VNB
+ sky130_fd_pr__nfet_01v8
+ l='150n' w='600n'

.ENDS
