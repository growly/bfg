.param s1s2_pfet_width=900m
.param s1s2_nfet_width=510m

.param s0_pfet_width=760m
.param s0_nfet_width=440m

.param mux_nfet_width=580m
.param mux_pfet_width=460m
.param reg_out_nfet_width=640m
.param reg_out_pfet_width=540m
