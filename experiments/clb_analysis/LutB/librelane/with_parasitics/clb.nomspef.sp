** SPICE netlist generated by bigspicy.py at Thu Apr 16 22:06:23 2026 UTC
.SUBCKT clb
+ VSS VGND VPWR addr[0] addr[1] addr[2] addr[3] clk mux q scan_clk scan_en scan_in scan_out x
** replacing XFILLER_12_54 with the contents of sky130_fd_sc_hd__decap_3
** [instance X0 of sky130_fd_pr__pfet_01v8_hvt, params={'w': '870000u', 'l': '590000u'} connections=['d: [connection X0/d =>[signal: VPWR w=1]]', 'g: [connection X0/g =>[signal: VGND w=1]]', 's: [connection X0/s =>[signal: VPWR w=1]]', 'b: [connection X0/b =>[signal: VPB w=1]]']]
X_XFILLER_12_54_0 VPWR VGND VPWR VPWR sky130_fd_pr__pfet_01v8_hvt w=870000u l=590000u
** [instance X1 of sky130_fd_pr__nfet_01v8, params={'w': '550000u', 'l': '590000u'} connections=['d: [connection X1/d =>[signal: VGND w=1]]', 'g: [connection X1/g =>[signal: VPWR w=1]]', 's: [connection X1/s =>[signal: VGND w=1]]', 'b: [connection X1/b =>[signal: VNB w=1]]']]
X_XFILLER_12_54_1 VGND VPWR VGND VGND sky130_fd_pr__nfet_01v8 w=550000u l=590000u

** replacing XFILLER_12_32 with the contents of sky130_fd_sc_hd__decap_3
** [instance X0 of sky130_fd_pr__pfet_01v8_hvt, params={'w': '870000u', 'l': '590000u'} connections=['d: [connection X0/d =>[signal: VPWR w=1]]', 'g: [connection X0/g =>[signal: VGND w=1]]', 's: [connection X0/s =>[signal: VPWR w=1]]', 'b: [connection X0/b =>[signal: VPB w=1]]']]
X_XFILLER_12_32_0 VPWR VGND VPWR VPWR sky130_fd_pr__pfet_01v8_hvt w=870000u l=590000u
** [instance X1 of sky130_fd_pr__nfet_01v8, params={'w': '550000u', 'l': '590000u'} connections=['d: [connection X1/d =>[signal: VGND w=1]]', 'g: [connection X1/g =>[signal: VPWR w=1]]', 's: [connection X1/s =>[signal: VGND w=1]]', 'b: [connection X1/b =>[signal: VNB w=1]]']]
X_XFILLER_12_32_1 VGND VPWR VGND VGND sky130_fd_pr__nfet_01v8 w=550000u l=590000u

** replacing X_49_ with the contents of sky130_fd_sc_hd__mux2_1
** [instance X0 of sky130_fd_pr__pfet_01v8_hvt, params={'w': '420000u', 'l': '150000u'} connections=['d: [connection X0/d =>[signal: VPWR w=1]]', 'g: [connection X0/g =>[signal: S w=1]]', 's: [connection X0/s =>[signal: a_218_374# w=1]]', 'b: [connection X0/b =>[signal: VPB w=1]]']]
X_X_49__0 VPWR _53_/S X_49__a_218_374# VPWR sky130_fd_pr__pfet_01v8_hvt w=420000u l=150000u
** [instance X1 of sky130_fd_pr__nfet_01v8, params={'w': '420000u', 'l': '150000u'} connections=['d: [connection X1/d =>[signal: a_76_199# w=1]]', 'g: [connection X1/g =>[signal: A0 w=1]]', 's: [connection X1/s =>[signal: a_439_47# w=1]]', 'b: [connection X1/b =>[signal: VNB w=1]]']]
X_X_49__1 X_49__a_76_199# _49_/A0 X_49__a_439_47# VGND sky130_fd_pr__nfet_01v8 w=420000u l=150000u
** [instance X2 of sky130_fd_pr__pfet_01v8_hvt, params={'w': '420000u', 'l': '150000u'} connections=['d: [connection X2/d =>[signal: a_535_374# w=1]]', 'g: [connection X2/g =>[signal: a_505_21# w=1]]', 's: [connection X2/s =>[signal: VPWR w=1]]', 'b: [connection X2/b =>[signal: VPB w=1]]']]
X_X_49__2 X_49__a_535_374# X_49__a_505_21# VPWR VPWR sky130_fd_pr__pfet_01v8_hvt w=420000u l=150000u
** [instance X3 of sky130_fd_pr__pfet_01v8_hvt, params={'w': '420000u', 'l': '150000u'} connections=['d: [connection X3/d =>[signal: VPWR w=1]]', 'g: [connection X3/g =>[signal: S w=1]]', 's: [connection X3/s =>[signal: a_505_21# w=1]]', 'b: [connection X3/b =>[signal: VPB w=1]]']]
X_X_49__3 VPWR _53_/S X_49__a_505_21# VPWR sky130_fd_pr__pfet_01v8_hvt w=420000u l=150000u
** [instance X4 of sky130_fd_pr__pfet_01v8_hvt, params={'w': '420000u', 'l': '150000u'} connections=['d: [connection X4/d =>[signal: a_76_199# w=1]]', 'g: [connection X4/g =>[signal: A1 w=1]]', 's: [connection X4/s =>[signal: a_535_374# w=1]]', 'b: [connection X4/b =>[signal: VPB w=1]]']]
X_X_49__4 X_49__a_76_199# _68_/Q X_49__a_535_374# VPWR sky130_fd_pr__pfet_01v8_hvt w=420000u l=150000u
** [instance X5 of sky130_fd_pr__nfet_01v8, params={'w': '420000u', 'l': '150000u'} connections=['d: [connection X5/d =>[signal: a_218_47# w=1]]', 'g: [connection X5/g =>[signal: A1 w=1]]', 's: [connection X5/s =>[signal: a_76_199# w=1]]', 'b: [connection X5/b =>[signal: VNB w=1]]']]
X_X_49__5 X_49__a_218_47# _68_/Q X_49__a_76_199# VGND sky130_fd_pr__nfet_01v8 w=420000u l=150000u
** [instance X6 of sky130_fd_pr__pfet_01v8_hvt, params={'w': '420000u', 'l': '150000u'} connections=['d: [connection X6/d =>[signal: a_218_374# w=1]]', 'g: [connection X6/g =>[signal: A0 w=1]]', 's: [connection X6/s =>[signal: a_76_199# w=1]]', 'b: [connection X6/b =>[signal: VPB w=1]]']]
X_X_49__6 X_49__a_218_374# _49_/A0 X_49__a_76_199# VPWR sky130_fd_pr__pfet_01v8_hvt w=420000u l=150000u
** [instance X7 of sky130_fd_pr__nfet_01v8, params={'w': '650000u', 'l': '150000u'} connections=['d: [connection X7/d =>[signal: X w=1]]', 'g: [connection X7/g =>[signal: a_76_199# w=1]]', 's: [connection X7/s =>[signal: VGND w=1]]', 'b: [connection X7/b =>[signal: VNB w=1]]']]
X_X_49__7 _49_/X X_49__a_76_199# VGND VGND sky130_fd_pr__nfet_01v8 w=650000u l=150000u
** [instance X8 of sky130_fd_pr__pfet_01v8_hvt, params={'w': '1e+06u', 'l': '150000u'} connections=['d: [connection X8/d =>[signal: X w=1]]', 'g: [connection X8/g =>[signal: a_76_199# w=1]]', 's: [connection X8/s =>[signal: VPWR w=1]]', 'b: [connection X8/b =>[signal: VPB w=1]]']]
X_X_49__8 _49_/X X_49__a_76_199# VPWR VPWR sky130_fd_pr__pfet_01v8_hvt w=1e+06u l=150000u
** [instance X9 of sky130_fd_pr__nfet_01v8, params={'w': '420000u', 'l': '150000u'} connections=['d: [connection X9/d =>[signal: VGND w=1]]', 'g: [connection X9/g =>[signal: S w=1]]', 's: [connection X9/s =>[signal: a_218_47# w=1]]', 'b: [connection X9/b =>[signal: VNB w=1]]']]
X_X_49__9 VGND _53_/S X_49__a_218_47# VGND sky130_fd_pr__nfet_01v8 w=420000u l=150000u
** [instance X10 of sky130_fd_pr__nfet_01v8, params={'w': '420000u', 'l': '150000u'} connections=['d: [connection X10/d =>[signal: VGND w=1]]', 'g: [connection X10/g =>[signal: S w=1]]', 's: [connection X10/s =>[signal: a_505_21# w=1]]', 'b: [connection X10/b =>[signal: VNB w=1]]']]
X_X_49__10 VGND _53_/S X_49__a_505_21# VGND sky130_fd_pr__nfet_01v8 w=420000u l=150000u
** [instance X11 of sky130_fd_pr__nfet_01v8, params={'w': '420000u', 'l': '150000u'} connections=['d: [connection X11/d =>[signal: a_439_47# w=1]]', 'g: [connection X11/g =>[signal: a_505_21# w=1]]', 's: [connection X11/s =>[signal: VGND w=1]]', 'b: [connection X11/b =>[signal: VNB w=1]]']]
X_X_49__11 X_49__a_439_47# X_49__a_505_21# VGND VGND sky130_fd_pr__nfet_01v8 w=420000u l=150000u

** replacing X_66_ with the contents of sky130_fd_sc_hd__dfxtp_2
** [instance X0 of sky130_fd_pr__pfet_01v8_hvt, params={'w': '420000u', 'l': '150000u'} connections=['d: [connection X0/d =>[signal: a_891_413# w=1]]', 'g: [connection X0/g =>[signal: a_193_47# w=1]]', 's: [connection X0/s =>[signal: a_975_413# w=1]]', 'b: [connection X0/b =>[signal: VPB w=1]]']]
X_X_66__0 X_66__a_891_413# X_66__a_193_47# X_66__a_975_413# VPWR sky130_fd_pr__pfet_01v8_hvt w=420000u l=150000u
** [instance X1 of sky130_fd_pr__nfet_01v8, params={'w': '650000u', 'l': '150000u'} connections=['d: [connection X1/d =>[signal: a_1059_315# w=1]]', 'g: [connection X1/g =>[signal: a_891_413# w=1]]', 's: [connection X1/s =>[signal: VGND w=1]]', 'b: [connection X1/b =>[signal: VNB w=1]]']]
X_X_66__1 X_66__a_1059_315# X_66__a_891_413# VGND VGND sky130_fd_pr__nfet_01v8 w=650000u l=150000u
** [instance X2 of sky130_fd_pr__pfet_01v8_hvt, params={'w': '420000u', 'l': '150000u'} connections=['d: [connection X2/d =>[signal: a_466_413# w=1]]', 'g: [connection X2/g =>[signal: a_27_47# w=1]]', 's: [connection X2/s =>[signal: a_561_413# w=1]]', 'b: [connection X2/b =>[signal: VPB w=1]]']]
X_X_66__2 X_66__a_466_413# X_66__a_27_47# X_66__a_561_413# VPWR sky130_fd_pr__pfet_01v8_hvt w=420000u l=150000u
** [instance X3 of sky130_fd_pr__pfet_01v8_hvt, params={'w': '420000u', 'l': '150000u'} connections=['d: [connection X3/d =>[signal: a_634_159# w=1]]', 'g: [connection X3/g =>[signal: a_27_47# w=1]]', 's: [connection X3/s =>[signal: a_891_413# w=1]]', 'b: [connection X3/b =>[signal: VPB w=1]]']]
X_X_66__3 X_66__a_634_159# X_66__a_27_47# X_66__a_891_413# VPWR sky130_fd_pr__pfet_01v8_hvt w=420000u l=150000u
** [instance X4 of sky130_fd_pr__pfet_01v8_hvt, params={'w': '420000u', 'l': '150000u'} connections=['d: [connection X4/d =>[signal: a_381_47# w=1]]', 'g: [connection X4/g =>[signal: a_193_47# w=1]]', 's: [connection X4/s =>[signal: a_466_413# w=1]]', 'b: [connection X4/b =>[signal: VPB w=1]]']]
X_X_66__4 X_66__a_381_47# X_66__a_193_47# X_66__a_466_413# VPWR sky130_fd_pr__pfet_01v8_hvt w=420000u l=150000u
** [instance X5 of sky130_fd_pr__pfet_01v8_hvt, params={'w': '420000u', 'l': '150000u'} connections=['d: [connection X5/d =>[signal: VPWR w=1]]', 'g: [connection X5/g =>[signal: D w=1]]', 's: [connection X5/s =>[signal: a_381_47# w=1]]', 'b: [connection X5/b =>[signal: VPB w=1]]']]
X_X_66__5 VPWR _66_/D X_66__a_381_47# VPWR sky130_fd_pr__pfet_01v8_hvt w=420000u l=150000u
** [instance X6 of sky130_fd_pr__pfet_01v8_hvt, params={'w': '750000u', 'l': '150000u'} connections=['d: [connection X6/d =>[signal: VPWR w=1]]', 'g: [connection X6/g =>[signal: a_466_413# w=1]]', 's: [connection X6/s =>[signal: a_634_159# w=1]]', 'b: [connection X6/b =>[signal: VPB w=1]]']]
X_X_66__6 VPWR X_66__a_466_413# X_66__a_634_159# VPWR sky130_fd_pr__pfet_01v8_hvt w=750000u l=150000u
** [instance X7 of sky130_fd_pr__nfet_01v8, params={'w': '640000u', 'l': '150000u'} connections=['d: [connection X7/d =>[signal: VGND w=1]]', 'g: [connection X7/g =>[signal: a_466_413# w=1]]', 's: [connection X7/s =>[signal: a_634_159# w=1]]', 'b: [connection X7/b =>[signal: VNB w=1]]']]
X_X_66__7 VGND X_66__a_466_413# X_66__a_634_159# VGND sky130_fd_pr__nfet_01v8 w=640000u l=150000u
** [instance X8 of sky130_fd_pr__nfet_01v8, params={'w': '420000u', 'l': '150000u'} connections=['d: [connection X8/d =>[signal: a_1017_47# w=1]]', 'g: [connection X8/g =>[signal: a_1059_315# w=1]]', 's: [connection X8/s =>[signal: VGND w=1]]', 'b: [connection X8/b =>[signal: VNB w=1]]']]
X_X_66__8 X_66__a_1017_47# X_66__a_1059_315# VGND VGND sky130_fd_pr__nfet_01v8 w=420000u l=150000u
** [instance X9 of sky130_fd_pr__pfet_01v8_hvt, params={'w': '1e+06u', 'l': '150000u'} connections=['d: [connection X9/d =>[signal: a_1059_315# w=1]]', 'g: [connection X9/g =>[signal: a_891_413# w=1]]', 's: [connection X9/s =>[signal: VPWR w=1]]', 'b: [connection X9/b =>[signal: VPB w=1]]']]
X_X_66__9 X_66__a_1059_315# X_66__a_891_413# VPWR VPWR sky130_fd_pr__pfet_01v8_hvt w=1e+06u l=150000u
** [instance X10 of sky130_fd_pr__pfet_01v8_hvt, params={'w': '1e+06u', 'l': '150000u'} connections=['d: [connection X10/d =>[signal: Q w=1]]', 'g: [connection X10/g =>[signal: a_1059_315# w=1]]', 's: [connection X10/s =>[signal: VPWR w=1]]', 'b: [connection X10/b =>[signal: VPB w=1]]']]
X_X_66__10 _66_/Q X_66__a_1059_315# VPWR VPWR sky130_fd_pr__pfet_01v8_hvt w=1e+06u l=150000u
** [instance X11 of sky130_fd_pr__pfet_01v8_hvt, params={'w': '420000u', 'l': '150000u'} connections=['d: [connection X11/d =>[signal: a_561_413# w=1]]', 'g: [connection X11/g =>[signal: a_634_159# w=1]]', 's: [connection X11/s =>[signal: VPWR w=1]]', 'b: [connection X11/b =>[signal: VPB w=1]]']]
X_X_66__11 X_66__a_561_413# X_66__a_634_159# VPWR VPWR sky130_fd_pr__pfet_01v8_hvt w=420000u l=150000u
** [instance X12 of sky130_fd_pr__pfet_01v8_hvt, params={'w': '1e+06u', 'l': '150000u'} connections=['d: [connection X12/d =>[signal: VPWR w=1]]', 'g: [connection X12/g =>[signal: a_1059_315# w=1]]', 's: [connection X12/s =>[signal: Q w=1]]', 'b: [connection X12/b =>[signal: VPB w=1]]']]
X_X_66__12 VPWR X_66__a_1059_315# _66_/Q VPWR sky130_fd_pr__pfet_01v8_hvt w=1e+06u l=150000u
** [instance X13 of sky130_fd_pr__nfet_01v8, params={'w': '360000u', 'l': '150000u'} connections=['d: [connection X13/d =>[signal: a_891_413# w=1]]', 'g: [connection X13/g =>[signal: a_27_47# w=1]]', 's: [connection X13/s =>[signal: a_1017_47# w=1]]', 'b: [connection X13/b =>[signal: VNB w=1]]']]
X_X_66__13 X_66__a_891_413# X_66__a_27_47# X_66__a_1017_47# VGND sky130_fd_pr__nfet_01v8 w=360000u l=150000u
** [instance X14 of sky130_fd_pr__nfet_01v8, params={'w': '360000u', 'l': '150000u'} connections=['d: [connection X14/d =>[signal: a_634_159# w=1]]', 'g: [connection X14/g =>[signal: a_193_47# w=1]]', 's: [connection X14/s =>[signal: a_891_413# w=1]]', 'b: [connection X14/b =>[signal: VNB w=1]]']]
X_X_66__14 X_66__a_634_159# X_66__a_193_47# X_66__a_891_413# VGND sky130_fd_pr__nfet_01v8 w=360000u l=150000u
** [instance X15 of sky130_fd_pr__nfet_01v8, params={'w': '420000u', 'l': '150000u'} connections=['d: [connection X15/d =>[signal: a_592_47# w=1]]', 'g: [connection X15/g =>[signal: a_634_159# w=1]]', 's: [connection X15/s =>[signal: VGND w=1]]', 'b: [connection X15/b =>[signal: VNB w=1]]']]
X_X_66__15 X_66__a_592_47# X_66__a_634_159# VGND VGND sky130_fd_pr__nfet_01v8 w=420000u l=150000u
** [instance X16 of sky130_fd_pr__nfet_01v8, params={'w': '360000u', 'l': '150000u'} connections=['d: [connection X16/d =>[signal: a_466_413# w=1]]', 'g: [connection X16/g =>[signal: a_193_47# w=1]]', 's: [connection X16/s =>[signal: a_592_47# w=1]]', 'b: [connection X16/b =>[signal: VNB w=1]]']]
X_X_66__16 X_66__a_466_413# X_66__a_193_47# X_66__a_592_47# VGND sky130_fd_pr__nfet_01v8 w=360000u l=150000u
** [instance X17 of sky130_fd_pr__nfet_01v8, params={'w': '420000u', 'l': '150000u'} connections=['d: [connection X17/d =>[signal: VGND w=1]]', 'g: [connection X17/g =>[signal: a_27_47# w=1]]', 's: [connection X17/s =>[signal: a_193_47# w=1]]', 'b: [connection X17/b =>[signal: VNB w=1]]']]
X_X_66__17 VGND X_66__a_27_47# X_66__a_193_47# VGND sky130_fd_pr__nfet_01v8 w=420000u l=150000u
** [instance X18 of sky130_fd_pr__nfet_01v8, params={'w': '360000u', 'l': '150000u'} connections=['d: [connection X18/d =>[signal: a_381_47# w=1]]', 'g: [connection X18/g =>[signal: a_27_47# w=1]]', 's: [connection X18/s =>[signal: a_466_413# w=1]]', 'b: [connection X18/b =>[signal: VNB w=1]]']]
X_X_66__18 X_66__a_381_47# X_66__a_27_47# X_66__a_466_413# VGND sky130_fd_pr__nfet_01v8 w=360000u l=150000u
** [instance X19 of sky130_fd_pr__nfet_01v8, params={'w': '420000u', 'l': '150000u'} connections=['d: [connection X19/d =>[signal: a_27_47# w=1]]', 'g: [connection X19/g =>[signal: CLK w=1]]', 's: [connection X19/s =>[signal: VGND w=1]]', 'b: [connection X19/b =>[signal: VNB w=1]]']]
X_X_66__19 X_66__a_27_47# _76_/CLK VGND VGND sky130_fd_pr__nfet_01v8 w=420000u l=150000u
** [instance X20 of sky130_fd_pr__pfet_01v8_hvt, params={'w': '640000u', 'l': '150000u'} connections=['d: [connection X20/d =>[signal: a_27_47# w=1]]', 'g: [connection X20/g =>[signal: CLK w=1]]', 's: [connection X20/s =>[signal: VPWR w=1]]', 'b: [connection X20/b =>[signal: VPB w=1]]']]
X_X_66__20 X_66__a_27_47# _76_/CLK VPWR VPWR sky130_fd_pr__pfet_01v8_hvt w=640000u l=150000u
** [instance X21 of sky130_fd_pr__nfet_01v8, params={'w': '650000u', 'l': '150000u'} connections=['d: [connection X21/d =>[signal: Q w=1]]', 'g: [connection X21/g =>[signal: a_1059_315# w=1]]', 's: [connection X21/s =>[signal: VGND w=1]]', 'b: [connection X21/b =>[signal: VNB w=1]]']]
X_X_66__21 _66_/Q X_66__a_1059_315# VGND VGND sky130_fd_pr__nfet_01v8 w=650000u l=150000u
** [instance X22 of sky130_fd_pr__pfet_01v8_hvt, params={'w': '640000u', 'l': '150000u'} connections=['d: [connection X22/d =>[signal: VPWR w=1]]', 'g: [connection X22/g =>[signal: a_27_47# w=1]]', 's: [connection X22/s =>[signal: a_193_47# w=1]]', 'b: [connection X22/b =>[signal: VPB w=1]]']]
X_X_66__22 VPWR X_66__a_27_47# X_66__a_193_47# VPWR sky130_fd_pr__pfet_01v8_hvt w=640000u l=150000u
** [instance X23 of sky130_fd_pr__nfet_01v8, params={'w': '420000u', 'l': '150000u'} connections=['d: [connection X23/d =>[signal: VGND w=1]]', 'g: [connection X23/g =>[signal: D w=1]]', 's: [connection X23/s =>[signal: a_381_47# w=1]]', 'b: [connection X23/b =>[signal: VNB w=1]]']]
X_X_66__23 VGND _66_/D X_66__a_381_47# VGND sky130_fd_pr__nfet_01v8 w=420000u l=150000u
** [instance X24 of sky130_fd_pr__pfet_01v8_hvt, params={'w': '420000u', 'l': '150000u'} connections=['d: [connection X24/d =>[signal: a_975_413# w=1]]', 'g: [connection X24/g =>[signal: a_1059_315# w=1]]', 's: [connection X24/s =>[signal: VPWR w=1]]', 'b: [connection X24/b =>[signal: VPB w=1]]']]
X_X_66__24 X_66__a_975_413# X_66__a_1059_315# VPWR VPWR sky130_fd_pr__pfet_01v8_hvt w=420000u l=150000u
** [instance X25 of sky130_fd_pr__nfet_01v8, params={'w': '650000u', 'l': '150000u'} connections=['d: [connection X25/d =>[signal: VGND w=1]]', 'g: [connection X25/g =>[signal: a_1059_315# w=1]]', 's: [connection X25/s =>[signal: Q w=1]]', 'b: [connection X25/b =>[signal: VNB w=1]]']]
X_X_66__25 VGND X_66__a_1059_315# _66_/Q VGND sky130_fd_pr__nfet_01v8 w=650000u l=150000u

** replacing XFILLER_6_78 with the contents of sky130_fd_sc_hd__decap_3
** [instance X0 of sky130_fd_pr__pfet_01v8_hvt, params={'w': '870000u', 'l': '590000u'} connections=['d: [connection X0/d =>[signal: VPWR w=1]]', 'g: [connection X0/g =>[signal: VGND w=1]]', 's: [connection X0/s =>[signal: VPWR w=1]]', 'b: [connection X0/b =>[signal: VPB w=1]]']]
X_XFILLER_6_78_0 VPWR VGND VPWR VPWR sky130_fd_pr__pfet_01v8_hvt w=870000u l=590000u
** [instance X1 of sky130_fd_pr__nfet_01v8, params={'w': '550000u', 'l': '590000u'} connections=['d: [connection X1/d =>[signal: VGND w=1]]', 'g: [connection X1/g =>[signal: VPWR w=1]]', 's: [connection X1/s =>[signal: VGND w=1]]', 'b: [connection X1/b =>[signal: VNB w=1]]']]
X_XFILLER_6_78_1 VGND VPWR VGND VGND sky130_fd_pr__nfet_01v8 w=550000u l=590000u

** replacing Xhold30 with the contents of sky130_fd_sc_hd__dlygate4sd3_1
** [instance X0 of sky130_fd_pr__nfet_01v8, params={'w': '420000u', 'l': '500000u'} connections=['d: [connection X0/d =>[signal: a_391_47# w=1]]', 'g: [connection X0/g =>[signal: a_285_47# w=1]]', 's: [connection X0/s =>[signal: VGND w=1]]', 'b: [connection X0/b =>[signal: VNB w=1]]']]
X_Xhold30_0 Xhold30_a_391_47# Xhold30_a_285_47# VGND VGND sky130_fd_pr__nfet_01v8 w=420000u l=500000u
** [instance X1 of sky130_fd_pr__pfet_01v8_hvt, params={'w': '420000u', 'l': '500000u'} connections=['d: [connection X1/d =>[signal: VPWR w=1]]', 'g: [connection X1/g =>[signal: a_49_47# w=1]]', 's: [connection X1/s =>[signal: a_285_47# w=1]]', 'b: [connection X1/b =>[signal: VPB w=1]]']]
X_Xhold30_1 VPWR Xhold30_a_49_47# Xhold30_a_285_47# VPWR sky130_fd_pr__pfet_01v8_hvt w=420000u l=500000u
** [instance X2 of sky130_fd_pr__nfet_01v8, params={'w': '420000u', 'l': '150000u'} connections=['d: [connection X2/d =>[signal: a_49_47# w=1]]', 'g: [connection X2/g =>[signal: A w=1]]', 's: [connection X2/s =>[signal: VGND w=1]]', 'b: [connection X2/b =>[signal: VNB w=1]]']]
X_Xhold30_2 Xhold30_a_49_47# _72_/Q VGND VGND sky130_fd_pr__nfet_01v8 w=420000u l=150000u
** [instance X3 of sky130_fd_pr__pfet_01v8_hvt, params={'w': '1e+06u', 'l': '150000u'} connections=['d: [connection X3/d =>[signal: VPWR w=1]]', 'g: [connection X3/g =>[signal: a_391_47# w=1]]', 's: [connection X3/s =>[signal: X w=1]]', 'b: [connection X3/b =>[signal: VPB w=1]]']]
X_Xhold30_3 VPWR Xhold30_a_391_47# _54_/A0 VPWR sky130_fd_pr__pfet_01v8_hvt w=1e+06u l=150000u
** [instance X4 of sky130_fd_pr__nfet_01v8, params={'w': '650000u', 'l': '150000u'} connections=['d: [connection X4/d =>[signal: VGND w=1]]', 'g: [connection X4/g =>[signal: a_391_47# w=1]]', 's: [connection X4/s =>[signal: X w=1]]', 'b: [connection X4/b =>[signal: VNB w=1]]']]
X_Xhold30_4 VGND Xhold30_a_391_47# _54_/A0 VGND sky130_fd_pr__nfet_01v8 w=650000u l=150000u
** [instance X5 of sky130_fd_pr__nfet_01v8, params={'w': '420000u', 'l': '500000u'} connections=['d: [connection X5/d =>[signal: VGND w=1]]', 'g: [connection X5/g =>[signal: a_49_47# w=1]]', 's: [connection X5/s =>[signal: a_285_47# w=1]]', 'b: [connection X5/b =>[signal: VNB w=1]]']]
X_Xhold30_5 VGND Xhold30_a_49_47# Xhold30_a_285_47# VGND sky130_fd_pr__nfet_01v8 w=420000u l=500000u
** [instance X6 of sky130_fd_pr__pfet_01v8_hvt, params={'w': '420000u', 'l': '500000u'} connections=['d: [connection X6/d =>[signal: a_391_47# w=1]]', 'g: [connection X6/g =>[signal: a_285_47# w=1]]', 's: [connection X6/s =>[signal: VPWR w=1]]', 'b: [connection X6/b =>[signal: VPB w=1]]']]
X_Xhold30_6 Xhold30_a_391_47# Xhold30_a_285_47# VPWR VPWR sky130_fd_pr__pfet_01v8_hvt w=420000u l=500000u
** [instance X7 of sky130_fd_pr__pfet_01v8_hvt, params={'w': '420000u', 'l': '150000u'} connections=['d: [connection X7/d =>[signal: a_49_47# w=1]]', 'g: [connection X7/g =>[signal: A w=1]]', 's: [connection X7/s =>[signal: VPWR w=1]]', 'b: [connection X7/b =>[signal: VPB w=1]]']]
X_Xhold30_7 Xhold30_a_49_47# _72_/Q VPWR VPWR sky130_fd_pr__pfet_01v8_hvt w=420000u l=150000u

** replacing XTAP_TAPCELL_ROW_5_34 with the contents of sky130_fd_sc_hd__tapvpwrvgnd_1

** replacing XFILLER_3_35 with the contents of sky130_fd_sc_hd__fill_1

** replacing XPHY_EDGE_ROW_12_Right_12 with the contents of sky130_fd_sc_hd__decap_3
** [instance X0 of sky130_fd_pr__pfet_01v8_hvt, params={'w': '870000u', 'l': '590000u'} connections=['d: [connection X0/d =>[signal: VPWR w=1]]', 'g: [connection X0/g =>[signal: VGND w=1]]', 's: [connection X0/s =>[signal: VPWR w=1]]', 'b: [connection X0/b =>[signal: VPB w=1]]']]
X_XPHY_EDGE_ROW_12_Right_12_0 VPWR VGND VPWR VPWR sky130_fd_pr__pfet_01v8_hvt w=870000u l=590000u
** [instance X1 of sky130_fd_pr__nfet_01v8, params={'w': '550000u', 'l': '590000u'} connections=['d: [connection X1/d =>[signal: VGND w=1]]', 'g: [connection X1/g =>[signal: VPWR w=1]]', 's: [connection X1/s =>[signal: VGND w=1]]', 'b: [connection X1/b =>[signal: VNB w=1]]']]
X_XPHY_EDGE_ROW_12_Right_12_1 VGND VPWR VGND VGND sky130_fd_pr__nfet_01v8 w=550000u l=590000u

** replacing X_65_ with the contents of sky130_fd_sc_hd__dfxtp_2
** [instance X0 of sky130_fd_pr__pfet_01v8_hvt, params={'w': '420000u', 'l': '150000u'} connections=['d: [connection X0/d =>[signal: a_891_413# w=1]]', 'g: [connection X0/g =>[signal: a_193_47# w=1]]', 's: [connection X0/s =>[signal: a_975_413# w=1]]', 'b: [connection X0/b =>[signal: VPB w=1]]']]
X_X_65__0 X_65__a_891_413# X_65__a_193_47# X_65__a_975_413# VPWR sky130_fd_pr__pfet_01v8_hvt w=420000u l=150000u
** [instance X1 of sky130_fd_pr__nfet_01v8, params={'w': '650000u', 'l': '150000u'} connections=['d: [connection X1/d =>[signal: a_1059_315# w=1]]', 'g: [connection X1/g =>[signal: a_891_413# w=1]]', 's: [connection X1/s =>[signal: VGND w=1]]', 'b: [connection X1/b =>[signal: VNB w=1]]']]
X_X_65__1 X_65__a_1059_315# X_65__a_891_413# VGND VGND sky130_fd_pr__nfet_01v8 w=650000u l=150000u
** [instance X2 of sky130_fd_pr__pfet_01v8_hvt, params={'w': '420000u', 'l': '150000u'} connections=['d: [connection X2/d =>[signal: a_466_413# w=1]]', 'g: [connection X2/g =>[signal: a_27_47# w=1]]', 's: [connection X2/s =>[signal: a_561_413# w=1]]', 'b: [connection X2/b =>[signal: VPB w=1]]']]
X_X_65__2 X_65__a_466_413# X_65__a_27_47# X_65__a_561_413# VPWR sky130_fd_pr__pfet_01v8_hvt w=420000u l=150000u
** [instance X3 of sky130_fd_pr__pfet_01v8_hvt, params={'w': '420000u', 'l': '150000u'} connections=['d: [connection X3/d =>[signal: a_634_159# w=1]]', 'g: [connection X3/g =>[signal: a_27_47# w=1]]', 's: [connection X3/s =>[signal: a_891_413# w=1]]', 'b: [connection X3/b =>[signal: VPB w=1]]']]
X_X_65__3 X_65__a_634_159# X_65__a_27_47# X_65__a_891_413# VPWR sky130_fd_pr__pfet_01v8_hvt w=420000u l=150000u
** [instance X4 of sky130_fd_pr__pfet_01v8_hvt, params={'w': '420000u', 'l': '150000u'} connections=['d: [connection X4/d =>[signal: a_381_47# w=1]]', 'g: [connection X4/g =>[signal: a_193_47# w=1]]', 's: [connection X4/s =>[signal: a_466_413# w=1]]', 'b: [connection X4/b =>[signal: VPB w=1]]']]
X_X_65__4 X_65__a_381_47# X_65__a_193_47# X_65__a_466_413# VPWR sky130_fd_pr__pfet_01v8_hvt w=420000u l=150000u
** [instance X5 of sky130_fd_pr__pfet_01v8_hvt, params={'w': '420000u', 'l': '150000u'} connections=['d: [connection X5/d =>[signal: VPWR w=1]]', 'g: [connection X5/g =>[signal: D w=1]]', 's: [connection X5/s =>[signal: a_381_47# w=1]]', 'b: [connection X5/b =>[signal: VPB w=1]]']]
X_X_65__5 VPWR _65_/D X_65__a_381_47# VPWR sky130_fd_pr__pfet_01v8_hvt w=420000u l=150000u
** [instance X6 of sky130_fd_pr__pfet_01v8_hvt, params={'w': '750000u', 'l': '150000u'} connections=['d: [connection X6/d =>[signal: VPWR w=1]]', 'g: [connection X6/g =>[signal: a_466_413# w=1]]', 's: [connection X6/s =>[signal: a_634_159# w=1]]', 'b: [connection X6/b =>[signal: VPB w=1]]']]
X_X_65__6 VPWR X_65__a_466_413# X_65__a_634_159# VPWR sky130_fd_pr__pfet_01v8_hvt w=750000u l=150000u
** [instance X7 of sky130_fd_pr__nfet_01v8, params={'w': '640000u', 'l': '150000u'} connections=['d: [connection X7/d =>[signal: VGND w=1]]', 'g: [connection X7/g =>[signal: a_466_413# w=1]]', 's: [connection X7/s =>[signal: a_634_159# w=1]]', 'b: [connection X7/b =>[signal: VNB w=1]]']]
X_X_65__7 VGND X_65__a_466_413# X_65__a_634_159# VGND sky130_fd_pr__nfet_01v8 w=640000u l=150000u
** [instance X8 of sky130_fd_pr__nfet_01v8, params={'w': '420000u', 'l': '150000u'} connections=['d: [connection X8/d =>[signal: a_1017_47# w=1]]', 'g: [connection X8/g =>[signal: a_1059_315# w=1]]', 's: [connection X8/s =>[signal: VGND w=1]]', 'b: [connection X8/b =>[signal: VNB w=1]]']]
X_X_65__8 X_65__a_1017_47# X_65__a_1059_315# VGND VGND sky130_fd_pr__nfet_01v8 w=420000u l=150000u
** [instance X9 of sky130_fd_pr__pfet_01v8_hvt, params={'w': '1e+06u', 'l': '150000u'} connections=['d: [connection X9/d =>[signal: a_1059_315# w=1]]', 'g: [connection X9/g =>[signal: a_891_413# w=1]]', 's: [connection X9/s =>[signal: VPWR w=1]]', 'b: [connection X9/b =>[signal: VPB w=1]]']]
X_X_65__9 X_65__a_1059_315# X_65__a_891_413# VPWR VPWR sky130_fd_pr__pfet_01v8_hvt w=1e+06u l=150000u
** [instance X10 of sky130_fd_pr__pfet_01v8_hvt, params={'w': '1e+06u', 'l': '150000u'} connections=['d: [connection X10/d =>[signal: Q w=1]]', 'g: [connection X10/g =>[signal: a_1059_315# w=1]]', 's: [connection X10/s =>[signal: VPWR w=1]]', 'b: [connection X10/b =>[signal: VPB w=1]]']]
X_X_65__10 _65_/Q X_65__a_1059_315# VPWR VPWR sky130_fd_pr__pfet_01v8_hvt w=1e+06u l=150000u
** [instance X11 of sky130_fd_pr__pfet_01v8_hvt, params={'w': '420000u', 'l': '150000u'} connections=['d: [connection X11/d =>[signal: a_561_413# w=1]]', 'g: [connection X11/g =>[signal: a_634_159# w=1]]', 's: [connection X11/s =>[signal: VPWR w=1]]', 'b: [connection X11/b =>[signal: VPB w=1]]']]
X_X_65__11 X_65__a_561_413# X_65__a_634_159# VPWR VPWR sky130_fd_pr__pfet_01v8_hvt w=420000u l=150000u
** [instance X12 of sky130_fd_pr__pfet_01v8_hvt, params={'w': '1e+06u', 'l': '150000u'} connections=['d: [connection X12/d =>[signal: VPWR w=1]]', 'g: [connection X12/g =>[signal: a_1059_315# w=1]]', 's: [connection X12/s =>[signal: Q w=1]]', 'b: [connection X12/b =>[signal: VPB w=1]]']]
X_X_65__12 VPWR X_65__a_1059_315# _65_/Q VPWR sky130_fd_pr__pfet_01v8_hvt w=1e+06u l=150000u
** [instance X13 of sky130_fd_pr__nfet_01v8, params={'w': '360000u', 'l': '150000u'} connections=['d: [connection X13/d =>[signal: a_891_413# w=1]]', 'g: [connection X13/g =>[signal: a_27_47# w=1]]', 's: [connection X13/s =>[signal: a_1017_47# w=1]]', 'b: [connection X13/b =>[signal: VNB w=1]]']]
X_X_65__13 X_65__a_891_413# X_65__a_27_47# X_65__a_1017_47# VGND sky130_fd_pr__nfet_01v8 w=360000u l=150000u
** [instance X14 of sky130_fd_pr__nfet_01v8, params={'w': '360000u', 'l': '150000u'} connections=['d: [connection X14/d =>[signal: a_634_159# w=1]]', 'g: [connection X14/g =>[signal: a_193_47# w=1]]', 's: [connection X14/s =>[signal: a_891_413# w=1]]', 'b: [connection X14/b =>[signal: VNB w=1]]']]
X_X_65__14 X_65__a_634_159# X_65__a_193_47# X_65__a_891_413# VGND sky130_fd_pr__nfet_01v8 w=360000u l=150000u
** [instance X15 of sky130_fd_pr__nfet_01v8, params={'w': '420000u', 'l': '150000u'} connections=['d: [connection X15/d =>[signal: a_592_47# w=1]]', 'g: [connection X15/g =>[signal: a_634_159# w=1]]', 's: [connection X15/s =>[signal: VGND w=1]]', 'b: [connection X15/b =>[signal: VNB w=1]]']]
X_X_65__15 X_65__a_592_47# X_65__a_634_159# VGND VGND sky130_fd_pr__nfet_01v8 w=420000u l=150000u
** [instance X16 of sky130_fd_pr__nfet_01v8, params={'w': '360000u', 'l': '150000u'} connections=['d: [connection X16/d =>[signal: a_466_413# w=1]]', 'g: [connection X16/g =>[signal: a_193_47# w=1]]', 's: [connection X16/s =>[signal: a_592_47# w=1]]', 'b: [connection X16/b =>[signal: VNB w=1]]']]
X_X_65__16 X_65__a_466_413# X_65__a_193_47# X_65__a_592_47# VGND sky130_fd_pr__nfet_01v8 w=360000u l=150000u
** [instance X17 of sky130_fd_pr__nfet_01v8, params={'w': '420000u', 'l': '150000u'} connections=['d: [connection X17/d =>[signal: VGND w=1]]', 'g: [connection X17/g =>[signal: a_27_47# w=1]]', 's: [connection X17/s =>[signal: a_193_47# w=1]]', 'b: [connection X17/b =>[signal: VNB w=1]]']]
X_X_65__17 VGND X_65__a_27_47# X_65__a_193_47# VGND sky130_fd_pr__nfet_01v8 w=420000u l=150000u
** [instance X18 of sky130_fd_pr__nfet_01v8, params={'w': '360000u', 'l': '150000u'} connections=['d: [connection X18/d =>[signal: a_381_47# w=1]]', 'g: [connection X18/g =>[signal: a_27_47# w=1]]', 's: [connection X18/s =>[signal: a_466_413# w=1]]', 'b: [connection X18/b =>[signal: VNB w=1]]']]
X_X_65__18 X_65__a_381_47# X_65__a_27_47# X_65__a_466_413# VGND sky130_fd_pr__nfet_01v8 w=360000u l=150000u
** [instance X19 of sky130_fd_pr__nfet_01v8, params={'w': '420000u', 'l': '150000u'} connections=['d: [connection X19/d =>[signal: a_27_47# w=1]]', 'g: [connection X19/g =>[signal: CLK w=1]]', 's: [connection X19/s =>[signal: VGND w=1]]', 'b: [connection X19/b =>[signal: VNB w=1]]']]
X_X_65__19 X_65__a_27_47# _71_/CLK VGND VGND sky130_fd_pr__nfet_01v8 w=420000u l=150000u
** [instance X20 of sky130_fd_pr__pfet_01v8_hvt, params={'w': '640000u', 'l': '150000u'} connections=['d: [connection X20/d =>[signal: a_27_47# w=1]]', 'g: [connection X20/g =>[signal: CLK w=1]]', 's: [connection X20/s =>[signal: VPWR w=1]]', 'b: [connection X20/b =>[signal: VPB w=1]]']]
X_X_65__20 X_65__a_27_47# _71_/CLK VPWR VPWR sky130_fd_pr__pfet_01v8_hvt w=640000u l=150000u
** [instance X21 of sky130_fd_pr__nfet_01v8, params={'w': '650000u', 'l': '150000u'} connections=['d: [connection X21/d =>[signal: Q w=1]]', 'g: [connection X21/g =>[signal: a_1059_315# w=1]]', 's: [connection X21/s =>[signal: VGND w=1]]', 'b: [connection X21/b =>[signal: VNB w=1]]']]
X_X_65__21 _65_/Q X_65__a_1059_315# VGND VGND sky130_fd_pr__nfet_01v8 w=650000u l=150000u
** [instance X22 of sky130_fd_pr__pfet_01v8_hvt, params={'w': '640000u', 'l': '150000u'} connections=['d: [connection X22/d =>[signal: VPWR w=1]]', 'g: [connection X22/g =>[signal: a_27_47# w=1]]', 's: [connection X22/s =>[signal: a_193_47# w=1]]', 'b: [connection X22/b =>[signal: VPB w=1]]']]
X_X_65__22 VPWR X_65__a_27_47# X_65__a_193_47# VPWR sky130_fd_pr__pfet_01v8_hvt w=640000u l=150000u
** [instance X23 of sky130_fd_pr__nfet_01v8, params={'w': '420000u', 'l': '150000u'} connections=['d: [connection X23/d =>[signal: VGND w=1]]', 'g: [connection X23/g =>[signal: D w=1]]', 's: [connection X23/s =>[signal: a_381_47# w=1]]', 'b: [connection X23/b =>[signal: VNB w=1]]']]
X_X_65__23 VGND _65_/D X_65__a_381_47# VGND sky130_fd_pr__nfet_01v8 w=420000u l=150000u
** [instance X24 of sky130_fd_pr__pfet_01v8_hvt, params={'w': '420000u', 'l': '150000u'} connections=['d: [connection X24/d =>[signal: a_975_413# w=1]]', 'g: [connection X24/g =>[signal: a_1059_315# w=1]]', 's: [connection X24/s =>[signal: VPWR w=1]]', 'b: [connection X24/b =>[signal: VPB w=1]]']]
X_X_65__24 X_65__a_975_413# X_65__a_1059_315# VPWR VPWR sky130_fd_pr__pfet_01v8_hvt w=420000u l=150000u
** [instance X25 of sky130_fd_pr__nfet_01v8, params={'w': '650000u', 'l': '150000u'} connections=['d: [connection X25/d =>[signal: VGND w=1]]', 'g: [connection X25/g =>[signal: a_1059_315# w=1]]', 's: [connection X25/s =>[signal: Q w=1]]', 'b: [connection X25/b =>[signal: VNB w=1]]']]
X_X_65__25 VGND X_65__a_1059_315# _65_/Q VGND sky130_fd_pr__nfet_01v8 w=650000u l=150000u

** replacing XPHY_EDGE_ROW_12_Left_26 with the contents of sky130_fd_sc_hd__decap_3
** [instance X0 of sky130_fd_pr__pfet_01v8_hvt, params={'w': '870000u', 'l': '590000u'} connections=['d: [connection X0/d =>[signal: VPWR w=1]]', 'g: [connection X0/g =>[signal: VGND w=1]]', 's: [connection X0/s =>[signal: VPWR w=1]]', 'b: [connection X0/b =>[signal: VPB w=1]]']]
X_XPHY_EDGE_ROW_12_Left_26_0 VPWR VGND VPWR VPWR sky130_fd_pr__pfet_01v8_hvt w=870000u l=590000u
** [instance X1 of sky130_fd_pr__nfet_01v8, params={'w': '550000u', 'l': '590000u'} connections=['d: [connection X1/d =>[signal: VGND w=1]]', 'g: [connection X1/g =>[signal: VPWR w=1]]', 's: [connection X1/s =>[signal: VGND w=1]]', 'b: [connection X1/b =>[signal: VNB w=1]]']]
X_XPHY_EDGE_ROW_12_Left_26_1 VGND VPWR VGND VGND sky130_fd_pr__nfet_01v8 w=550000u l=590000u

** replacing X_48_ with the contents of sky130_fd_sc_hd__mux2_1
** [instance X0 of sky130_fd_pr__pfet_01v8_hvt, params={'w': '420000u', 'l': '150000u'} connections=['d: [connection X0/d =>[signal: VPWR w=1]]', 'g: [connection X0/g =>[signal: S w=1]]', 's: [connection X0/s =>[signal: a_218_374# w=1]]', 'b: [connection X0/b =>[signal: VPB w=1]]']]
X_X_48__0 VPWR _53_/S X_48__a_218_374# VPWR sky130_fd_pr__pfet_01v8_hvt w=420000u l=150000u
** [instance X1 of sky130_fd_pr__nfet_01v8, params={'w': '420000u', 'l': '150000u'} connections=['d: [connection X1/d =>[signal: a_76_199# w=1]]', 'g: [connection X1/g =>[signal: A0 w=1]]', 's: [connection X1/s =>[signal: a_439_47# w=1]]', 'b: [connection X1/b =>[signal: VNB w=1]]']]
X_X_48__1 X_48__a_76_199# _48_/A0 X_48__a_439_47# VGND sky130_fd_pr__nfet_01v8 w=420000u l=150000u
** [instance X2 of sky130_fd_pr__pfet_01v8_hvt, params={'w': '420000u', 'l': '150000u'} connections=['d: [connection X2/d =>[signal: a_535_374# w=1]]', 'g: [connection X2/g =>[signal: a_505_21# w=1]]', 's: [connection X2/s =>[signal: VPWR w=1]]', 'b: [connection X2/b =>[signal: VPB w=1]]']]
X_X_48__2 X_48__a_535_374# X_48__a_505_21# VPWR VPWR sky130_fd_pr__pfet_01v8_hvt w=420000u l=150000u
** [instance X3 of sky130_fd_pr__pfet_01v8_hvt, params={'w': '420000u', 'l': '150000u'} connections=['d: [connection X3/d =>[signal: VPWR w=1]]', 'g: [connection X3/g =>[signal: S w=1]]', 's: [connection X3/s =>[signal: a_505_21# w=1]]', 'b: [connection X3/b =>[signal: VPB w=1]]']]
X_X_48__3 VPWR _53_/S X_48__a_505_21# VPWR sky130_fd_pr__pfet_01v8_hvt w=420000u l=150000u
** [instance X4 of sky130_fd_pr__pfet_01v8_hvt, params={'w': '420000u', 'l': '150000u'} connections=['d: [connection X4/d =>[signal: a_76_199# w=1]]', 'g: [connection X4/g =>[signal: A1 w=1]]', 's: [connection X4/s =>[signal: a_535_374# w=1]]', 'b: [connection X4/b =>[signal: VPB w=1]]']]
X_X_48__4 X_48__a_76_199# _49_/A0 X_48__a_535_374# VPWR sky130_fd_pr__pfet_01v8_hvt w=420000u l=150000u
** [instance X5 of sky130_fd_pr__nfet_01v8, params={'w': '420000u', 'l': '150000u'} connections=['d: [connection X5/d =>[signal: a_218_47# w=1]]', 'g: [connection X5/g =>[signal: A1 w=1]]', 's: [connection X5/s =>[signal: a_76_199# w=1]]', 'b: [connection X5/b =>[signal: VNB w=1]]']]
X_X_48__5 X_48__a_218_47# _49_/A0 X_48__a_76_199# VGND sky130_fd_pr__nfet_01v8 w=420000u l=150000u
** [instance X6 of sky130_fd_pr__pfet_01v8_hvt, params={'w': '420000u', 'l': '150000u'} connections=['d: [connection X6/d =>[signal: a_218_374# w=1]]', 'g: [connection X6/g =>[signal: A0 w=1]]', 's: [connection X6/s =>[signal: a_76_199# w=1]]', 'b: [connection X6/b =>[signal: VPB w=1]]']]
X_X_48__6 X_48__a_218_374# _48_/A0 X_48__a_76_199# VPWR sky130_fd_pr__pfet_01v8_hvt w=420000u l=150000u
** [instance X7 of sky130_fd_pr__nfet_01v8, params={'w': '650000u', 'l': '150000u'} connections=['d: [connection X7/d =>[signal: X w=1]]', 'g: [connection X7/g =>[signal: a_76_199# w=1]]', 's: [connection X7/s =>[signal: VGND w=1]]', 'b: [connection X7/b =>[signal: VNB w=1]]']]
X_X_48__7 _66_/D X_48__a_76_199# VGND VGND sky130_fd_pr__nfet_01v8 w=650000u l=150000u
** [instance X8 of sky130_fd_pr__pfet_01v8_hvt, params={'w': '1e+06u', 'l': '150000u'} connections=['d: [connection X8/d =>[signal: X w=1]]', 'g: [connection X8/g =>[signal: a_76_199# w=1]]', 's: [connection X8/s =>[signal: VPWR w=1]]', 'b: [connection X8/b =>[signal: VPB w=1]]']]
X_X_48__8 _66_/D X_48__a_76_199# VPWR VPWR sky130_fd_pr__pfet_01v8_hvt w=1e+06u l=150000u
** [instance X9 of sky130_fd_pr__nfet_01v8, params={'w': '420000u', 'l': '150000u'} connections=['d: [connection X9/d =>[signal: VGND w=1]]', 'g: [connection X9/g =>[signal: S w=1]]', 's: [connection X9/s =>[signal: a_218_47# w=1]]', 'b: [connection X9/b =>[signal: VNB w=1]]']]
X_X_48__9 VGND _53_/S X_48__a_218_47# VGND sky130_fd_pr__nfet_01v8 w=420000u l=150000u
** [instance X10 of sky130_fd_pr__nfet_01v8, params={'w': '420000u', 'l': '150000u'} connections=['d: [connection X10/d =>[signal: VGND w=1]]', 'g: [connection X10/g =>[signal: S w=1]]', 's: [connection X10/s =>[signal: a_505_21# w=1]]', 'b: [connection X10/b =>[signal: VNB w=1]]']]
X_X_48__10 VGND _53_/S X_48__a_505_21# VGND sky130_fd_pr__nfet_01v8 w=420000u l=150000u
** [instance X11 of sky130_fd_pr__nfet_01v8, params={'w': '420000u', 'l': '150000u'} connections=['d: [connection X11/d =>[signal: a_439_47# w=1]]', 'g: [connection X11/g =>[signal: a_505_21# w=1]]', 's: [connection X11/s =>[signal: VGND w=1]]', 'b: [connection X11/b =>[signal: VNB w=1]]']]
X_X_48__11 X_48__a_439_47# X_48__a_505_21# VGND VGND sky130_fd_pr__nfet_01v8 w=420000u l=150000u

** replacing Xoutput10 with the contents of sky130_fd_sc_hd__clkdlybuf4s25_1
** [instance X0 of sky130_fd_pr__pfet_01v8_hvt, params={'w': '820000u', 'l': '250000u'} connections=['d: [connection X0/d =>[signal: a_355_47# w=1]]', 'g: [connection X0/g =>[signal: a_244_47# w=1]]', 's: [connection X0/s =>[signal: VPWR w=1]]', 'b: [connection X0/b =>[signal: VPB w=1]]']]
X_Xoutput10_0 Xoutput10_a_355_47# Xoutput10_a_244_47# VPWR VPWR sky130_fd_pr__pfet_01v8_hvt w=820000u l=250000u
** [instance X1 of sky130_fd_pr__pfet_01v8_hvt, params={'w': '820000u', 'l': '250000u'} connections=['d: [connection X1/d =>[signal: VPWR w=1]]', 'g: [connection X1/g =>[signal: a_27_47# w=1]]', 's: [connection X1/s =>[signal: a_244_47# w=1]]', 'b: [connection X1/b =>[signal: VPB w=1]]']]
X_Xoutput10_1 VPWR Xoutput10_a_27_47# Xoutput10_a_244_47# VPWR sky130_fd_pr__pfet_01v8_hvt w=820000u l=250000u
** [instance X2 of sky130_fd_pr__pfet_01v8_hvt, params={'w': '1e+06u', 'l': '150000u'} connections=['d: [connection X2/d =>[signal: VPWR w=1]]', 'g: [connection X2/g =>[signal: a_355_47# w=1]]', 's: [connection X2/s =>[signal: X w=1]]', 'b: [connection X2/b =>[signal: VPB w=1]]']]
X_Xoutput10_2 VPWR Xoutput10_a_355_47# q VPWR sky130_fd_pr__pfet_01v8_hvt w=1e+06u l=150000u
** [instance X3 of sky130_fd_pr__pfet_01v8_hvt, params={'w': '1e+06u', 'l': '150000u'} connections=['d: [connection X3/d =>[signal: a_27_47# w=1]]', 'g: [connection X3/g =>[signal: A w=1]]', 's: [connection X3/s =>[signal: VPWR w=1]]', 'b: [connection X3/b =>[signal: VPB w=1]]']]
X_Xoutput10_3 Xoutput10_a_27_47# _77_/Q VPWR VPWR sky130_fd_pr__pfet_01v8_hvt w=1e+06u l=150000u
** [instance X4 of sky130_fd_pr__nfet_01v8, params={'w': '650000u', 'l': '250000u'} connections=['d: [connection X4/d =>[signal: a_355_47# w=1]]', 'g: [connection X4/g =>[signal: a_244_47# w=1]]', 's: [connection X4/s =>[signal: VGND w=1]]', 'b: [connection X4/b =>[signal: VNB w=1]]']]
X_Xoutput10_4 Xoutput10_a_355_47# Xoutput10_a_244_47# VGND VGND sky130_fd_pr__nfet_01v8 w=650000u l=250000u
** [instance X5 of sky130_fd_pr__nfet_01v8, params={'w': '650000u', 'l': '250000u'} connections=['d: [connection X5/d =>[signal: VGND w=1]]', 'g: [connection X5/g =>[signal: a_27_47# w=1]]', 's: [connection X5/s =>[signal: a_244_47# w=1]]', 'b: [connection X5/b =>[signal: VNB w=1]]']]
X_Xoutput10_5 VGND Xoutput10_a_27_47# Xoutput10_a_244_47# VGND sky130_fd_pr__nfet_01v8 w=650000u l=250000u
** [instance X6 of sky130_fd_pr__nfet_01v8, params={'w': '420000u', 'l': '150000u'} connections=['d: [connection X6/d =>[signal: VGND w=1]]', 'g: [connection X6/g =>[signal: a_355_47# w=1]]', 's: [connection X6/s =>[signal: X w=1]]', 'b: [connection X6/b =>[signal: VNB w=1]]']]
X_Xoutput10_6 VGND Xoutput10_a_355_47# q VGND sky130_fd_pr__nfet_01v8 w=420000u l=150000u
** [instance X7 of sky130_fd_pr__nfet_01v8, params={'w': '420000u', 'l': '150000u'} connections=['d: [connection X7/d =>[signal: a_27_47# w=1]]', 'g: [connection X7/g =>[signal: A w=1]]', 's: [connection X7/s =>[signal: VGND w=1]]', 'b: [connection X7/b =>[signal: VNB w=1]]']]
X_Xoutput10_7 Xoutput10_a_27_47# _77_/Q VGND VGND sky130_fd_pr__nfet_01v8 w=420000u l=150000u

** replacing Xhold20 with the contents of sky130_fd_sc_hd__dlygate4sd3_1
** [instance X0 of sky130_fd_pr__nfet_01v8, params={'w': '420000u', 'l': '500000u'} connections=['d: [connection X0/d =>[signal: a_391_47# w=1]]', 'g: [connection X0/g =>[signal: a_285_47# w=1]]', 's: [connection X0/s =>[signal: VGND w=1]]', 'b: [connection X0/b =>[signal: VNB w=1]]']]
X_Xhold20_0 Xhold20_a_391_47# Xhold20_a_285_47# VGND VGND sky130_fd_pr__nfet_01v8 w=420000u l=500000u
** [instance X1 of sky130_fd_pr__pfet_01v8_hvt, params={'w': '420000u', 'l': '500000u'} connections=['d: [connection X1/d =>[signal: VPWR w=1]]', 'g: [connection X1/g =>[signal: a_49_47# w=1]]', 's: [connection X1/s =>[signal: a_285_47# w=1]]', 'b: [connection X1/b =>[signal: VPB w=1]]']]
X_Xhold20_1 VPWR Xhold20_a_49_47# Xhold20_a_285_47# VPWR sky130_fd_pr__pfet_01v8_hvt w=420000u l=500000u
** [instance X2 of sky130_fd_pr__nfet_01v8, params={'w': '420000u', 'l': '150000u'} connections=['d: [connection X2/d =>[signal: a_49_47# w=1]]', 'g: [connection X2/g =>[signal: A w=1]]', 's: [connection X2/s =>[signal: VGND w=1]]', 'b: [connection X2/b =>[signal: VNB w=1]]']]
X_Xhold20_2 Xhold20_a_49_47# _61_/Q VGND VGND sky130_fd_pr__nfet_01v8 w=420000u l=150000u
** [instance X3 of sky130_fd_pr__pfet_01v8_hvt, params={'w': '1e+06u', 'l': '150000u'} connections=['d: [connection X3/d =>[signal: VPWR w=1]]', 'g: [connection X3/g =>[signal: a_391_47# w=1]]', 's: [connection X3/s =>[signal: X w=1]]', 'b: [connection X3/b =>[signal: VPB w=1]]']]
X_Xhold20_3 VPWR Xhold20_a_391_47# _43_/A0 VPWR sky130_fd_pr__pfet_01v8_hvt w=1e+06u l=150000u
** [instance X4 of sky130_fd_pr__nfet_01v8, params={'w': '650000u', 'l': '150000u'} connections=['d: [connection X4/d =>[signal: VGND w=1]]', 'g: [connection X4/g =>[signal: a_391_47# w=1]]', 's: [connection X4/s =>[signal: X w=1]]', 'b: [connection X4/b =>[signal: VNB w=1]]']]
X_Xhold20_4 VGND Xhold20_a_391_47# _43_/A0 VGND sky130_fd_pr__nfet_01v8 w=650000u l=150000u
** [instance X5 of sky130_fd_pr__nfet_01v8, params={'w': '420000u', 'l': '500000u'} connections=['d: [connection X5/d =>[signal: VGND w=1]]', 'g: [connection X5/g =>[signal: a_49_47# w=1]]', 's: [connection X5/s =>[signal: a_285_47# w=1]]', 'b: [connection X5/b =>[signal: VNB w=1]]']]
X_Xhold20_5 VGND Xhold20_a_49_47# Xhold20_a_285_47# VGND sky130_fd_pr__nfet_01v8 w=420000u l=500000u
** [instance X6 of sky130_fd_pr__pfet_01v8_hvt, params={'w': '420000u', 'l': '500000u'} connections=['d: [connection X6/d =>[signal: a_391_47# w=1]]', 'g: [connection X6/g =>[signal: a_285_47# w=1]]', 's: [connection X6/s =>[signal: VPWR w=1]]', 'b: [connection X6/b =>[signal: VPB w=1]]']]
X_Xhold20_6 Xhold20_a_391_47# Xhold20_a_285_47# VPWR VPWR sky130_fd_pr__pfet_01v8_hvt w=420000u l=500000u
** [instance X7 of sky130_fd_pr__pfet_01v8_hvt, params={'w': '420000u', 'l': '150000u'} connections=['d: [connection X7/d =>[signal: a_49_47# w=1]]', 'g: [connection X7/g =>[signal: A w=1]]', 's: [connection X7/s =>[signal: VPWR w=1]]', 'b: [connection X7/b =>[signal: VPB w=1]]']]
X_Xhold20_7 Xhold20_a_49_47# _61_/Q VPWR VPWR sky130_fd_pr__pfet_01v8_hvt w=420000u l=150000u

** replacing Xhold31 with the contents of sky130_fd_sc_hd__dlygate4sd3_1
** [instance X0 of sky130_fd_pr__nfet_01v8, params={'w': '420000u', 'l': '500000u'} connections=['d: [connection X0/d =>[signal: a_391_47# w=1]]', 'g: [connection X0/g =>[signal: a_285_47# w=1]]', 's: [connection X0/s =>[signal: VGND w=1]]', 'b: [connection X0/b =>[signal: VNB w=1]]']]
X_Xhold31_0 Xhold31_a_391_47# Xhold31_a_285_47# VGND VGND sky130_fd_pr__nfet_01v8 w=420000u l=500000u
** [instance X1 of sky130_fd_pr__pfet_01v8_hvt, params={'w': '420000u', 'l': '500000u'} connections=['d: [connection X1/d =>[signal: VPWR w=1]]', 'g: [connection X1/g =>[signal: a_49_47# w=1]]', 's: [connection X1/s =>[signal: a_285_47# w=1]]', 'b: [connection X1/b =>[signal: VPB w=1]]']]
X_Xhold31_1 VPWR Xhold31_a_49_47# Xhold31_a_285_47# VPWR sky130_fd_pr__pfet_01v8_hvt w=420000u l=500000u
** [instance X2 of sky130_fd_pr__nfet_01v8, params={'w': '420000u', 'l': '150000u'} connections=['d: [connection X2/d =>[signal: a_49_47# w=1]]', 'g: [connection X2/g =>[signal: A w=1]]', 's: [connection X2/s =>[signal: VGND w=1]]', 'b: [connection X2/b =>[signal: VNB w=1]]']]
X_Xhold31_2 Xhold31_a_49_47# _65_/Q VGND VGND sky130_fd_pr__nfet_01v8 w=420000u l=150000u
** [instance X3 of sky130_fd_pr__pfet_01v8_hvt, params={'w': '1e+06u', 'l': '150000u'} connections=['d: [connection X3/d =>[signal: VPWR w=1]]', 'g: [connection X3/g =>[signal: a_391_47# w=1]]', 's: [connection X3/s =>[signal: X w=1]]', 'b: [connection X3/b =>[signal: VPB w=1]]']]
X_Xhold31_3 VPWR Xhold31_a_391_47# _47_/A0 VPWR sky130_fd_pr__pfet_01v8_hvt w=1e+06u l=150000u
** [instance X4 of sky130_fd_pr__nfet_01v8, params={'w': '650000u', 'l': '150000u'} connections=['d: [connection X4/d =>[signal: VGND w=1]]', 'g: [connection X4/g =>[signal: a_391_47# w=1]]', 's: [connection X4/s =>[signal: X w=1]]', 'b: [connection X4/b =>[signal: VNB w=1]]']]
X_Xhold31_4 VGND Xhold31_a_391_47# _47_/A0 VGND sky130_fd_pr__nfet_01v8 w=650000u l=150000u
** [instance X5 of sky130_fd_pr__nfet_01v8, params={'w': '420000u', 'l': '500000u'} connections=['d: [connection X5/d =>[signal: VGND w=1]]', 'g: [connection X5/g =>[signal: a_49_47# w=1]]', 's: [connection X5/s =>[signal: a_285_47# w=1]]', 'b: [connection X5/b =>[signal: VNB w=1]]']]
X_Xhold31_5 VGND Xhold31_a_49_47# Xhold31_a_285_47# VGND sky130_fd_pr__nfet_01v8 w=420000u l=500000u
** [instance X6 of sky130_fd_pr__pfet_01v8_hvt, params={'w': '420000u', 'l': '500000u'} connections=['d: [connection X6/d =>[signal: a_391_47# w=1]]', 'g: [connection X6/g =>[signal: a_285_47# w=1]]', 's: [connection X6/s =>[signal: VPWR w=1]]', 'b: [connection X6/b =>[signal: VPB w=1]]']]
X_Xhold31_6 Xhold31_a_391_47# Xhold31_a_285_47# VPWR VPWR sky130_fd_pr__pfet_01v8_hvt w=420000u l=500000u
** [instance X7 of sky130_fd_pr__pfet_01v8_hvt, params={'w': '420000u', 'l': '150000u'} connections=['d: [connection X7/d =>[signal: a_49_47# w=1]]', 'g: [connection X7/g =>[signal: A w=1]]', 's: [connection X7/s =>[signal: VPWR w=1]]', 'b: [connection X7/b =>[signal: VPB w=1]]']]
X_Xhold31_7 Xhold31_a_49_47# _65_/Q VPWR VPWR sky130_fd_pr__pfet_01v8_hvt w=420000u l=150000u

** replacing XPHY_EDGE_ROW_6_Right_6 with the contents of sky130_fd_sc_hd__decap_3
** [instance X0 of sky130_fd_pr__pfet_01v8_hvt, params={'w': '870000u', 'l': '590000u'} connections=['d: [connection X0/d =>[signal: VPWR w=1]]', 'g: [connection X0/g =>[signal: VGND w=1]]', 's: [connection X0/s =>[signal: VPWR w=1]]', 'b: [connection X0/b =>[signal: VPB w=1]]']]
X_XPHY_EDGE_ROW_6_Right_6_0 VPWR VGND VPWR VPWR sky130_fd_pr__pfet_01v8_hvt w=870000u l=590000u
** [instance X1 of sky130_fd_pr__nfet_01v8, params={'w': '550000u', 'l': '590000u'} connections=['d: [connection X1/d =>[signal: VGND w=1]]', 'g: [connection X1/g =>[signal: VPWR w=1]]', 's: [connection X1/s =>[signal: VGND w=1]]', 'b: [connection X1/b =>[signal: VNB w=1]]']]
X_XPHY_EDGE_ROW_6_Right_6_1 VGND VPWR VGND VGND sky130_fd_pr__nfet_01v8 w=550000u l=590000u

** replacing XFILLER_12_23 with the contents of sky130_fd_sc_hd__decap_3
** [instance X0 of sky130_fd_pr__pfet_01v8_hvt, params={'w': '870000u', 'l': '590000u'} connections=['d: [connection X0/d =>[signal: VPWR w=1]]', 'g: [connection X0/g =>[signal: VGND w=1]]', 's: [connection X0/s =>[signal: VPWR w=1]]', 'b: [connection X0/b =>[signal: VPB w=1]]']]
X_XFILLER_12_23_0 VPWR VGND VPWR VPWR sky130_fd_pr__pfet_01v8_hvt w=870000u l=590000u
** [instance X1 of sky130_fd_pr__nfet_01v8, params={'w': '550000u', 'l': '590000u'} connections=['d: [connection X1/d =>[signal: VGND w=1]]', 'g: [connection X1/g =>[signal: VPWR w=1]]', 's: [connection X1/s =>[signal: VGND w=1]]', 'b: [connection X1/b =>[signal: VNB w=1]]']]
X_XFILLER_12_23_1 VGND VPWR VGND VGND sky130_fd_pr__nfet_01v8 w=550000u l=590000u

** replacing XPHY_EDGE_ROW_0_Left_14 with the contents of sky130_fd_sc_hd__decap_3
** [instance X0 of sky130_fd_pr__pfet_01v8_hvt, params={'w': '870000u', 'l': '590000u'} connections=['d: [connection X0/d =>[signal: VPWR w=1]]', 'g: [connection X0/g =>[signal: VGND w=1]]', 's: [connection X0/s =>[signal: VPWR w=1]]', 'b: [connection X0/b =>[signal: VPB w=1]]']]
X_XPHY_EDGE_ROW_0_Left_14_0 VPWR VGND VPWR VPWR sky130_fd_pr__pfet_01v8_hvt w=870000u l=590000u
** [instance X1 of sky130_fd_pr__nfet_01v8, params={'w': '550000u', 'l': '590000u'} connections=['d: [connection X1/d =>[signal: VGND w=1]]', 'g: [connection X1/g =>[signal: VPWR w=1]]', 's: [connection X1/s =>[signal: VGND w=1]]', 'b: [connection X1/b =>[signal: VNB w=1]]']]
X_XPHY_EDGE_ROW_0_Left_14_1 VGND VPWR VGND VGND sky130_fd_pr__nfet_01v8 w=550000u l=590000u

** replacing XFILLER_5_6 with the contents of sky130_fd_sc_hd__fill_2

** replacing X_64_ with the contents of sky130_fd_sc_hd__dfxtp_2
** [instance X0 of sky130_fd_pr__pfet_01v8_hvt, params={'w': '420000u', 'l': '150000u'} connections=['d: [connection X0/d =>[signal: a_891_413# w=1]]', 'g: [connection X0/g =>[signal: a_193_47# w=1]]', 's: [connection X0/s =>[signal: a_975_413# w=1]]', 'b: [connection X0/b =>[signal: VPB w=1]]']]
X_X_64__0 X_64__a_891_413# X_64__a_193_47# X_64__a_975_413# VPWR sky130_fd_pr__pfet_01v8_hvt w=420000u l=150000u
** [instance X1 of sky130_fd_pr__nfet_01v8, params={'w': '650000u', 'l': '150000u'} connections=['d: [connection X1/d =>[signal: a_1059_315# w=1]]', 'g: [connection X1/g =>[signal: a_891_413# w=1]]', 's: [connection X1/s =>[signal: VGND w=1]]', 'b: [connection X1/b =>[signal: VNB w=1]]']]
X_X_64__1 X_64__a_1059_315# X_64__a_891_413# VGND VGND sky130_fd_pr__nfet_01v8 w=650000u l=150000u
** [instance X2 of sky130_fd_pr__pfet_01v8_hvt, params={'w': '420000u', 'l': '150000u'} connections=['d: [connection X2/d =>[signal: a_466_413# w=1]]', 'g: [connection X2/g =>[signal: a_27_47# w=1]]', 's: [connection X2/s =>[signal: a_561_413# w=1]]', 'b: [connection X2/b =>[signal: VPB w=1]]']]
X_X_64__2 X_64__a_466_413# X_64__a_27_47# X_64__a_561_413# VPWR sky130_fd_pr__pfet_01v8_hvt w=420000u l=150000u
** [instance X3 of sky130_fd_pr__pfet_01v8_hvt, params={'w': '420000u', 'l': '150000u'} connections=['d: [connection X3/d =>[signal: a_634_159# w=1]]', 'g: [connection X3/g =>[signal: a_27_47# w=1]]', 's: [connection X3/s =>[signal: a_891_413# w=1]]', 'b: [connection X3/b =>[signal: VPB w=1]]']]
X_X_64__3 X_64__a_634_159# X_64__a_27_47# X_64__a_891_413# VPWR sky130_fd_pr__pfet_01v8_hvt w=420000u l=150000u
** [instance X4 of sky130_fd_pr__pfet_01v8_hvt, params={'w': '420000u', 'l': '150000u'} connections=['d: [connection X4/d =>[signal: a_381_47# w=1]]', 'g: [connection X4/g =>[signal: a_193_47# w=1]]', 's: [connection X4/s =>[signal: a_466_413# w=1]]', 'b: [connection X4/b =>[signal: VPB w=1]]']]
X_X_64__4 X_64__a_381_47# X_64__a_193_47# X_64__a_466_413# VPWR sky130_fd_pr__pfet_01v8_hvt w=420000u l=150000u
** [instance X5 of sky130_fd_pr__pfet_01v8_hvt, params={'w': '420000u', 'l': '150000u'} connections=['d: [connection X5/d =>[signal: VPWR w=1]]', 'g: [connection X5/g =>[signal: D w=1]]', 's: [connection X5/s =>[signal: a_381_47# w=1]]', 'b: [connection X5/b =>[signal: VPB w=1]]']]
X_X_64__5 VPWR _64_/D X_64__a_381_47# VPWR sky130_fd_pr__pfet_01v8_hvt w=420000u l=150000u
** [instance X6 of sky130_fd_pr__pfet_01v8_hvt, params={'w': '750000u', 'l': '150000u'} connections=['d: [connection X6/d =>[signal: VPWR w=1]]', 'g: [connection X6/g =>[signal: a_466_413# w=1]]', 's: [connection X6/s =>[signal: a_634_159# w=1]]', 'b: [connection X6/b =>[signal: VPB w=1]]']]
X_X_64__6 VPWR X_64__a_466_413# X_64__a_634_159# VPWR sky130_fd_pr__pfet_01v8_hvt w=750000u l=150000u
** [instance X7 of sky130_fd_pr__nfet_01v8, params={'w': '640000u', 'l': '150000u'} connections=['d: [connection X7/d =>[signal: VGND w=1]]', 'g: [connection X7/g =>[signal: a_466_413# w=1]]', 's: [connection X7/s =>[signal: a_634_159# w=1]]', 'b: [connection X7/b =>[signal: VNB w=1]]']]
X_X_64__7 VGND X_64__a_466_413# X_64__a_634_159# VGND sky130_fd_pr__nfet_01v8 w=640000u l=150000u
** [instance X8 of sky130_fd_pr__nfet_01v8, params={'w': '420000u', 'l': '150000u'} connections=['d: [connection X8/d =>[signal: a_1017_47# w=1]]', 'g: [connection X8/g =>[signal: a_1059_315# w=1]]', 's: [connection X8/s =>[signal: VGND w=1]]', 'b: [connection X8/b =>[signal: VNB w=1]]']]
X_X_64__8 X_64__a_1017_47# X_64__a_1059_315# VGND VGND sky130_fd_pr__nfet_01v8 w=420000u l=150000u
** [instance X9 of sky130_fd_pr__pfet_01v8_hvt, params={'w': '1e+06u', 'l': '150000u'} connections=['d: [connection X9/d =>[signal: a_1059_315# w=1]]', 'g: [connection X9/g =>[signal: a_891_413# w=1]]', 's: [connection X9/s =>[signal: VPWR w=1]]', 'b: [connection X9/b =>[signal: VPB w=1]]']]
X_X_64__9 X_64__a_1059_315# X_64__a_891_413# VPWR VPWR sky130_fd_pr__pfet_01v8_hvt w=1e+06u l=150000u
** [instance X10 of sky130_fd_pr__pfet_01v8_hvt, params={'w': '1e+06u', 'l': '150000u'} connections=['d: [connection X10/d =>[signal: Q w=1]]', 'g: [connection X10/g =>[signal: a_1059_315# w=1]]', 's: [connection X10/s =>[signal: VPWR w=1]]', 'b: [connection X10/b =>[signal: VPB w=1]]']]
X_X_64__10 _64_/Q X_64__a_1059_315# VPWR VPWR sky130_fd_pr__pfet_01v8_hvt w=1e+06u l=150000u
** [instance X11 of sky130_fd_pr__pfet_01v8_hvt, params={'w': '420000u', 'l': '150000u'} connections=['d: [connection X11/d =>[signal: a_561_413# w=1]]', 'g: [connection X11/g =>[signal: a_634_159# w=1]]', 's: [connection X11/s =>[signal: VPWR w=1]]', 'b: [connection X11/b =>[signal: VPB w=1]]']]
X_X_64__11 X_64__a_561_413# X_64__a_634_159# VPWR VPWR sky130_fd_pr__pfet_01v8_hvt w=420000u l=150000u
** [instance X12 of sky130_fd_pr__pfet_01v8_hvt, params={'w': '1e+06u', 'l': '150000u'} connections=['d: [connection X12/d =>[signal: VPWR w=1]]', 'g: [connection X12/g =>[signal: a_1059_315# w=1]]', 's: [connection X12/s =>[signal: Q w=1]]', 'b: [connection X12/b =>[signal: VPB w=1]]']]
X_X_64__12 VPWR X_64__a_1059_315# _64_/Q VPWR sky130_fd_pr__pfet_01v8_hvt w=1e+06u l=150000u
** [instance X13 of sky130_fd_pr__nfet_01v8, params={'w': '360000u', 'l': '150000u'} connections=['d: [connection X13/d =>[signal: a_891_413# w=1]]', 'g: [connection X13/g =>[signal: a_27_47# w=1]]', 's: [connection X13/s =>[signal: a_1017_47# w=1]]', 'b: [connection X13/b =>[signal: VNB w=1]]']]
X_X_64__13 X_64__a_891_413# X_64__a_27_47# X_64__a_1017_47# VGND sky130_fd_pr__nfet_01v8 w=360000u l=150000u
** [instance X14 of sky130_fd_pr__nfet_01v8, params={'w': '360000u', 'l': '150000u'} connections=['d: [connection X14/d =>[signal: a_634_159# w=1]]', 'g: [connection X14/g =>[signal: a_193_47# w=1]]', 's: [connection X14/s =>[signal: a_891_413# w=1]]', 'b: [connection X14/b =>[signal: VNB w=1]]']]
X_X_64__14 X_64__a_634_159# X_64__a_193_47# X_64__a_891_413# VGND sky130_fd_pr__nfet_01v8 w=360000u l=150000u
** [instance X15 of sky130_fd_pr__nfet_01v8, params={'w': '420000u', 'l': '150000u'} connections=['d: [connection X15/d =>[signal: a_592_47# w=1]]', 'g: [connection X15/g =>[signal: a_634_159# w=1]]', 's: [connection X15/s =>[signal: VGND w=1]]', 'b: [connection X15/b =>[signal: VNB w=1]]']]
X_X_64__15 X_64__a_592_47# X_64__a_634_159# VGND VGND sky130_fd_pr__nfet_01v8 w=420000u l=150000u
** [instance X16 of sky130_fd_pr__nfet_01v8, params={'w': '360000u', 'l': '150000u'} connections=['d: [connection X16/d =>[signal: a_466_413# w=1]]', 'g: [connection X16/g =>[signal: a_193_47# w=1]]', 's: [connection X16/s =>[signal: a_592_47# w=1]]', 'b: [connection X16/b =>[signal: VNB w=1]]']]
X_X_64__16 X_64__a_466_413# X_64__a_193_47# X_64__a_592_47# VGND sky130_fd_pr__nfet_01v8 w=360000u l=150000u
** [instance X17 of sky130_fd_pr__nfet_01v8, params={'w': '420000u', 'l': '150000u'} connections=['d: [connection X17/d =>[signal: VGND w=1]]', 'g: [connection X17/g =>[signal: a_27_47# w=1]]', 's: [connection X17/s =>[signal: a_193_47# w=1]]', 'b: [connection X17/b =>[signal: VNB w=1]]']]
X_X_64__17 VGND X_64__a_27_47# X_64__a_193_47# VGND sky130_fd_pr__nfet_01v8 w=420000u l=150000u
** [instance X18 of sky130_fd_pr__nfet_01v8, params={'w': '360000u', 'l': '150000u'} connections=['d: [connection X18/d =>[signal: a_381_47# w=1]]', 'g: [connection X18/g =>[signal: a_27_47# w=1]]', 's: [connection X18/s =>[signal: a_466_413# w=1]]', 'b: [connection X18/b =>[signal: VNB w=1]]']]
X_X_64__18 X_64__a_381_47# X_64__a_27_47# X_64__a_466_413# VGND sky130_fd_pr__nfet_01v8 w=360000u l=150000u
** [instance X19 of sky130_fd_pr__nfet_01v8, params={'w': '420000u', 'l': '150000u'} connections=['d: [connection X19/d =>[signal: a_27_47# w=1]]', 'g: [connection X19/g =>[signal: CLK w=1]]', 's: [connection X19/s =>[signal: VGND w=1]]', 'b: [connection X19/b =>[signal: VNB w=1]]']]
X_X_64__19 X_64__a_27_47# _71_/CLK VGND VGND sky130_fd_pr__nfet_01v8 w=420000u l=150000u
** [instance X20 of sky130_fd_pr__pfet_01v8_hvt, params={'w': '640000u', 'l': '150000u'} connections=['d: [connection X20/d =>[signal: a_27_47# w=1]]', 'g: [connection X20/g =>[signal: CLK w=1]]', 's: [connection X20/s =>[signal: VPWR w=1]]', 'b: [connection X20/b =>[signal: VPB w=1]]']]
X_X_64__20 X_64__a_27_47# _71_/CLK VPWR VPWR sky130_fd_pr__pfet_01v8_hvt w=640000u l=150000u
** [instance X21 of sky130_fd_pr__nfet_01v8, params={'w': '650000u', 'l': '150000u'} connections=['d: [connection X21/d =>[signal: Q w=1]]', 'g: [connection X21/g =>[signal: a_1059_315# w=1]]', 's: [connection X21/s =>[signal: VGND w=1]]', 'b: [connection X21/b =>[signal: VNB w=1]]']]
X_X_64__21 _64_/Q X_64__a_1059_315# VGND VGND sky130_fd_pr__nfet_01v8 w=650000u l=150000u
** [instance X22 of sky130_fd_pr__pfet_01v8_hvt, params={'w': '640000u', 'l': '150000u'} connections=['d: [connection X22/d =>[signal: VPWR w=1]]', 'g: [connection X22/g =>[signal: a_27_47# w=1]]', 's: [connection X22/s =>[signal: a_193_47# w=1]]', 'b: [connection X22/b =>[signal: VPB w=1]]']]
X_X_64__22 VPWR X_64__a_27_47# X_64__a_193_47# VPWR sky130_fd_pr__pfet_01v8_hvt w=640000u l=150000u
** [instance X23 of sky130_fd_pr__nfet_01v8, params={'w': '420000u', 'l': '150000u'} connections=['d: [connection X23/d =>[signal: VGND w=1]]', 'g: [connection X23/g =>[signal: D w=1]]', 's: [connection X23/s =>[signal: a_381_47# w=1]]', 'b: [connection X23/b =>[signal: VNB w=1]]']]
X_X_64__23 VGND _64_/D X_64__a_381_47# VGND sky130_fd_pr__nfet_01v8 w=420000u l=150000u
** [instance X24 of sky130_fd_pr__pfet_01v8_hvt, params={'w': '420000u', 'l': '150000u'} connections=['d: [connection X24/d =>[signal: a_975_413# w=1]]', 'g: [connection X24/g =>[signal: a_1059_315# w=1]]', 's: [connection X24/s =>[signal: VPWR w=1]]', 'b: [connection X24/b =>[signal: VPB w=1]]']]
X_X_64__24 X_64__a_975_413# X_64__a_1059_315# VPWR VPWR sky130_fd_pr__pfet_01v8_hvt w=420000u l=150000u
** [instance X25 of sky130_fd_pr__nfet_01v8, params={'w': '650000u', 'l': '150000u'} connections=['d: [connection X25/d =>[signal: VGND w=1]]', 'g: [connection X25/g =>[signal: a_1059_315# w=1]]', 's: [connection X25/s =>[signal: Q w=1]]', 'b: [connection X25/b =>[signal: VNB w=1]]']]
X_X_64__25 VGND X_64__a_1059_315# _64_/Q VGND sky130_fd_pr__nfet_01v8 w=650000u l=150000u

** replacing XFILLER_3_3 with the contents of sky130_fd_sc_hd__decap_3
** [instance X0 of sky130_fd_pr__pfet_01v8_hvt, params={'w': '870000u', 'l': '590000u'} connections=['d: [connection X0/d =>[signal: VPWR w=1]]', 'g: [connection X0/g =>[signal: VGND w=1]]', 's: [connection X0/s =>[signal: VPWR w=1]]', 'b: [connection X0/b =>[signal: VPB w=1]]']]
X_XFILLER_3_3_0 VPWR VGND VPWR VPWR sky130_fd_pr__pfet_01v8_hvt w=870000u l=590000u
** [instance X1 of sky130_fd_pr__nfet_01v8, params={'w': '550000u', 'l': '590000u'} connections=['d: [connection X1/d =>[signal: VGND w=1]]', 'g: [connection X1/g =>[signal: VPWR w=1]]', 's: [connection X1/s =>[signal: VGND w=1]]', 'b: [connection X1/b =>[signal: VNB w=1]]']]
X_XFILLER_3_3_1 VGND VPWR VGND VGND sky130_fd_pr__nfet_01v8 w=550000u l=590000u

** replacing X_47_ with the contents of sky130_fd_sc_hd__mux2_1
** [instance X0 of sky130_fd_pr__pfet_01v8_hvt, params={'w': '420000u', 'l': '150000u'} connections=['d: [connection X0/d =>[signal: VPWR w=1]]', 'g: [connection X0/g =>[signal: S w=1]]', 's: [connection X0/s =>[signal: a_218_374# w=1]]', 'b: [connection X0/b =>[signal: VPB w=1]]']]
X_X_47__0 VPWR _53_/S X_47__a_218_374# VPWR sky130_fd_pr__pfet_01v8_hvt w=420000u l=150000u
** [instance X1 of sky130_fd_pr__nfet_01v8, params={'w': '420000u', 'l': '150000u'} connections=['d: [connection X1/d =>[signal: a_76_199# w=1]]', 'g: [connection X1/g =>[signal: A0 w=1]]', 's: [connection X1/s =>[signal: a_439_47# w=1]]', 'b: [connection X1/b =>[signal: VNB w=1]]']]
X_X_47__1 X_47__a_76_199# _47_/A0 X_47__a_439_47# VGND sky130_fd_pr__nfet_01v8 w=420000u l=150000u
** [instance X2 of sky130_fd_pr__pfet_01v8_hvt, params={'w': '420000u', 'l': '150000u'} connections=['d: [connection X2/d =>[signal: a_535_374# w=1]]', 'g: [connection X2/g =>[signal: a_505_21# w=1]]', 's: [connection X2/s =>[signal: VPWR w=1]]', 'b: [connection X2/b =>[signal: VPB w=1]]']]
X_X_47__2 X_47__a_535_374# X_47__a_505_21# VPWR VPWR sky130_fd_pr__pfet_01v8_hvt w=420000u l=150000u
** [instance X3 of sky130_fd_pr__pfet_01v8_hvt, params={'w': '420000u', 'l': '150000u'} connections=['d: [connection X3/d =>[signal: VPWR w=1]]', 'g: [connection X3/g =>[signal: S w=1]]', 's: [connection X3/s =>[signal: a_505_21# w=1]]', 'b: [connection X3/b =>[signal: VPB w=1]]']]
X_X_47__3 VPWR _53_/S X_47__a_505_21# VPWR sky130_fd_pr__pfet_01v8_hvt w=420000u l=150000u
** [instance X4 of sky130_fd_pr__pfet_01v8_hvt, params={'w': '420000u', 'l': '150000u'} connections=['d: [connection X4/d =>[signal: a_76_199# w=1]]', 'g: [connection X4/g =>[signal: A1 w=1]]', 's: [connection X4/s =>[signal: a_535_374# w=1]]', 'b: [connection X4/b =>[signal: VPB w=1]]']]
X_X_47__4 X_47__a_76_199# _48_/A0 X_47__a_535_374# VPWR sky130_fd_pr__pfet_01v8_hvt w=420000u l=150000u
** [instance X5 of sky130_fd_pr__nfet_01v8, params={'w': '420000u', 'l': '150000u'} connections=['d: [connection X5/d =>[signal: a_218_47# w=1]]', 'g: [connection X5/g =>[signal: A1 w=1]]', 's: [connection X5/s =>[signal: a_76_199# w=1]]', 'b: [connection X5/b =>[signal: VNB w=1]]']]
X_X_47__5 X_47__a_218_47# _48_/A0 X_47__a_76_199# VGND sky130_fd_pr__nfet_01v8 w=420000u l=150000u
** [instance X6 of sky130_fd_pr__pfet_01v8_hvt, params={'w': '420000u', 'l': '150000u'} connections=['d: [connection X6/d =>[signal: a_218_374# w=1]]', 'g: [connection X6/g =>[signal: A0 w=1]]', 's: [connection X6/s =>[signal: a_76_199# w=1]]', 'b: [connection X6/b =>[signal: VPB w=1]]']]
X_X_47__6 X_47__a_218_374# _47_/A0 X_47__a_76_199# VPWR sky130_fd_pr__pfet_01v8_hvt w=420000u l=150000u
** [instance X7 of sky130_fd_pr__nfet_01v8, params={'w': '650000u', 'l': '150000u'} connections=['d: [connection X7/d =>[signal: X w=1]]', 'g: [connection X7/g =>[signal: a_76_199# w=1]]', 's: [connection X7/s =>[signal: VGND w=1]]', 'b: [connection X7/b =>[signal: VNB w=1]]']]
X_X_47__7 _65_/D X_47__a_76_199# VGND VGND sky130_fd_pr__nfet_01v8 w=650000u l=150000u
** [instance X8 of sky130_fd_pr__pfet_01v8_hvt, params={'w': '1e+06u', 'l': '150000u'} connections=['d: [connection X8/d =>[signal: X w=1]]', 'g: [connection X8/g =>[signal: a_76_199# w=1]]', 's: [connection X8/s =>[signal: VPWR w=1]]', 'b: [connection X8/b =>[signal: VPB w=1]]']]
X_X_47__8 _65_/D X_47__a_76_199# VPWR VPWR sky130_fd_pr__pfet_01v8_hvt w=1e+06u l=150000u
** [instance X9 of sky130_fd_pr__nfet_01v8, params={'w': '420000u', 'l': '150000u'} connections=['d: [connection X9/d =>[signal: VGND w=1]]', 'g: [connection X9/g =>[signal: S w=1]]', 's: [connection X9/s =>[signal: a_218_47# w=1]]', 'b: [connection X9/b =>[signal: VNB w=1]]']]
X_X_47__9 VGND _53_/S X_47__a_218_47# VGND sky130_fd_pr__nfet_01v8 w=420000u l=150000u
** [instance X10 of sky130_fd_pr__nfet_01v8, params={'w': '420000u', 'l': '150000u'} connections=['d: [connection X10/d =>[signal: VGND w=1]]', 'g: [connection X10/g =>[signal: S w=1]]', 's: [connection X10/s =>[signal: a_505_21# w=1]]', 'b: [connection X10/b =>[signal: VNB w=1]]']]
X_X_47__10 VGND _53_/S X_47__a_505_21# VGND sky130_fd_pr__nfet_01v8 w=420000u l=150000u
** [instance X11 of sky130_fd_pr__nfet_01v8, params={'w': '420000u', 'l': '150000u'} connections=['d: [connection X11/d =>[signal: a_439_47# w=1]]', 'g: [connection X11/g =>[signal: a_505_21# w=1]]', 's: [connection X11/s =>[signal: VGND w=1]]', 'b: [connection X11/b =>[signal: VNB w=1]]']]
X_X_47__11 X_47__a_439_47# X_47__a_505_21# VGND VGND sky130_fd_pr__nfet_01v8 w=420000u l=150000u

** replacing Xhold21 with the contents of sky130_fd_sc_hd__dlygate4sd3_1
** [instance X0 of sky130_fd_pr__nfet_01v8, params={'w': '420000u', 'l': '500000u'} connections=['d: [connection X0/d =>[signal: a_391_47# w=1]]', 'g: [connection X0/g =>[signal: a_285_47# w=1]]', 's: [connection X0/s =>[signal: VGND w=1]]', 'b: [connection X0/b =>[signal: VNB w=1]]']]
X_Xhold21_0 Xhold21_a_391_47# Xhold21_a_285_47# VGND VGND sky130_fd_pr__nfet_01v8 w=420000u l=500000u
** [instance X1 of sky130_fd_pr__pfet_01v8_hvt, params={'w': '420000u', 'l': '500000u'} connections=['d: [connection X1/d =>[signal: VPWR w=1]]', 'g: [connection X1/g =>[signal: a_49_47# w=1]]', 's: [connection X1/s =>[signal: a_285_47# w=1]]', 'b: [connection X1/b =>[signal: VPB w=1]]']]
X_Xhold21_1 VPWR Xhold21_a_49_47# Xhold21_a_285_47# VPWR sky130_fd_pr__pfet_01v8_hvt w=420000u l=500000u
** [instance X2 of sky130_fd_pr__nfet_01v8, params={'w': '420000u', 'l': '150000u'} connections=['d: [connection X2/d =>[signal: a_49_47# w=1]]', 'g: [connection X2/g =>[signal: A w=1]]', 's: [connection X2/s =>[signal: VGND w=1]]', 'b: [connection X2/b =>[signal: VNB w=1]]']]
X_Xhold21_2 Xhold21_a_49_47# _43_/X VGND VGND sky130_fd_pr__nfet_01v8 w=420000u l=150000u
** [instance X3 of sky130_fd_pr__pfet_01v8_hvt, params={'w': '1e+06u', 'l': '150000u'} connections=['d: [connection X3/d =>[signal: VPWR w=1]]', 'g: [connection X3/g =>[signal: a_391_47# w=1]]', 's: [connection X3/s =>[signal: X w=1]]', 'b: [connection X3/b =>[signal: VPB w=1]]']]
X_Xhold21_3 VPWR Xhold21_a_391_47# _61_/D VPWR sky130_fd_pr__pfet_01v8_hvt w=1e+06u l=150000u
** [instance X4 of sky130_fd_pr__nfet_01v8, params={'w': '650000u', 'l': '150000u'} connections=['d: [connection X4/d =>[signal: VGND w=1]]', 'g: [connection X4/g =>[signal: a_391_47# w=1]]', 's: [connection X4/s =>[signal: X w=1]]', 'b: [connection X4/b =>[signal: VNB w=1]]']]
X_Xhold21_4 VGND Xhold21_a_391_47# _61_/D VGND sky130_fd_pr__nfet_01v8 w=650000u l=150000u
** [instance X5 of sky130_fd_pr__nfet_01v8, params={'w': '420000u', 'l': '500000u'} connections=['d: [connection X5/d =>[signal: VGND w=1]]', 'g: [connection X5/g =>[signal: a_49_47# w=1]]', 's: [connection X5/s =>[signal: a_285_47# w=1]]', 'b: [connection X5/b =>[signal: VNB w=1]]']]
X_Xhold21_5 VGND Xhold21_a_49_47# Xhold21_a_285_47# VGND sky130_fd_pr__nfet_01v8 w=420000u l=500000u
** [instance X6 of sky130_fd_pr__pfet_01v8_hvt, params={'w': '420000u', 'l': '500000u'} connections=['d: [connection X6/d =>[signal: a_391_47# w=1]]', 'g: [connection X6/g =>[signal: a_285_47# w=1]]', 's: [connection X6/s =>[signal: VPWR w=1]]', 'b: [connection X6/b =>[signal: VPB w=1]]']]
X_Xhold21_6 Xhold21_a_391_47# Xhold21_a_285_47# VPWR VPWR sky130_fd_pr__pfet_01v8_hvt w=420000u l=500000u
** [instance X7 of sky130_fd_pr__pfet_01v8_hvt, params={'w': '420000u', 'l': '150000u'} connections=['d: [connection X7/d =>[signal: a_49_47# w=1]]', 'g: [connection X7/g =>[signal: A w=1]]', 's: [connection X7/s =>[signal: VPWR w=1]]', 'b: [connection X7/b =>[signal: VPB w=1]]']]
X_Xhold21_7 Xhold21_a_49_47# _43_/X VPWR VPWR sky130_fd_pr__pfet_01v8_hvt w=420000u l=150000u

** replacing Xhold32 with the contents of sky130_fd_sc_hd__dlygate4sd3_1
** [instance X0 of sky130_fd_pr__nfet_01v8, params={'w': '420000u', 'l': '500000u'} connections=['d: [connection X0/d =>[signal: a_391_47# w=1]]', 'g: [connection X0/g =>[signal: a_285_47# w=1]]', 's: [connection X0/s =>[signal: VGND w=1]]', 'b: [connection X0/b =>[signal: VNB w=1]]']]
X_Xhold32_0 Xhold32_a_391_47# Xhold32_a_285_47# VGND VGND sky130_fd_pr__nfet_01v8 w=420000u l=500000u
** [instance X1 of sky130_fd_pr__pfet_01v8_hvt, params={'w': '420000u', 'l': '500000u'} connections=['d: [connection X1/d =>[signal: VPWR w=1]]', 'g: [connection X1/g =>[signal: a_49_47# w=1]]', 's: [connection X1/s =>[signal: a_285_47# w=1]]', 'b: [connection X1/b =>[signal: VPB w=1]]']]
X_Xhold32_1 VPWR Xhold32_a_49_47# Xhold32_a_285_47# VPWR sky130_fd_pr__pfet_01v8_hvt w=420000u l=500000u
** [instance X2 of sky130_fd_pr__nfet_01v8, params={'w': '420000u', 'l': '150000u'} connections=['d: [connection X2/d =>[signal: a_49_47# w=1]]', 'g: [connection X2/g =>[signal: A w=1]]', 's: [connection X2/s =>[signal: VGND w=1]]', 'b: [connection X2/b =>[signal: VNB w=1]]']]
X_Xhold32_2 Xhold32_a_49_47# _74_/Q VGND VGND sky130_fd_pr__nfet_01v8 w=420000u l=150000u
** [instance X3 of sky130_fd_pr__pfet_01v8_hvt, params={'w': '1e+06u', 'l': '150000u'} connections=['d: [connection X3/d =>[signal: VPWR w=1]]', 'g: [connection X3/g =>[signal: a_391_47# w=1]]', 's: [connection X3/s =>[signal: X w=1]]', 'b: [connection X3/b =>[signal: VPB w=1]]']]
X_Xhold32_3 VPWR Xhold32_a_391_47# _56_/A0 VPWR sky130_fd_pr__pfet_01v8_hvt w=1e+06u l=150000u
** [instance X4 of sky130_fd_pr__nfet_01v8, params={'w': '650000u', 'l': '150000u'} connections=['d: [connection X4/d =>[signal: VGND w=1]]', 'g: [connection X4/g =>[signal: a_391_47# w=1]]', 's: [connection X4/s =>[signal: X w=1]]', 'b: [connection X4/b =>[signal: VNB w=1]]']]
X_Xhold32_4 VGND Xhold32_a_391_47# _56_/A0 VGND sky130_fd_pr__nfet_01v8 w=650000u l=150000u
** [instance X5 of sky130_fd_pr__nfet_01v8, params={'w': '420000u', 'l': '500000u'} connections=['d: [connection X5/d =>[signal: VGND w=1]]', 'g: [connection X5/g =>[signal: a_49_47# w=1]]', 's: [connection X5/s =>[signal: a_285_47# w=1]]', 'b: [connection X5/b =>[signal: VNB w=1]]']]
X_Xhold32_5 VGND Xhold32_a_49_47# Xhold32_a_285_47# VGND sky130_fd_pr__nfet_01v8 w=420000u l=500000u
** [instance X6 of sky130_fd_pr__pfet_01v8_hvt, params={'w': '420000u', 'l': '500000u'} connections=['d: [connection X6/d =>[signal: a_391_47# w=1]]', 'g: [connection X6/g =>[signal: a_285_47# w=1]]', 's: [connection X6/s =>[signal: VPWR w=1]]', 'b: [connection X6/b =>[signal: VPB w=1]]']]
X_Xhold32_6 Xhold32_a_391_47# Xhold32_a_285_47# VPWR VPWR sky130_fd_pr__pfet_01v8_hvt w=420000u l=500000u
** [instance X7 of sky130_fd_pr__pfet_01v8_hvt, params={'w': '420000u', 'l': '150000u'} connections=['d: [connection X7/d =>[signal: a_49_47# w=1]]', 'g: [connection X7/g =>[signal: A w=1]]', 's: [connection X7/s =>[signal: VPWR w=1]]', 'b: [connection X7/b =>[signal: VPB w=1]]']]
X_Xhold32_7 Xhold32_a_49_47# _74_/Q VPWR VPWR sky130_fd_pr__pfet_01v8_hvt w=420000u l=150000u

** replacing Xoutput11 with the contents of sky130_fd_sc_hd__clkdlybuf4s25_1
** [instance X0 of sky130_fd_pr__pfet_01v8_hvt, params={'w': '820000u', 'l': '250000u'} connections=['d: [connection X0/d =>[signal: a_355_47# w=1]]', 'g: [connection X0/g =>[signal: a_244_47# w=1]]', 's: [connection X0/s =>[signal: VPWR w=1]]', 'b: [connection X0/b =>[signal: VPB w=1]]']]
X_Xoutput11_0 Xoutput11_a_355_47# Xoutput11_a_244_47# VPWR VPWR sky130_fd_pr__pfet_01v8_hvt w=820000u l=250000u
** [instance X1 of sky130_fd_pr__pfet_01v8_hvt, params={'w': '820000u', 'l': '250000u'} connections=['d: [connection X1/d =>[signal: VPWR w=1]]', 'g: [connection X1/g =>[signal: a_27_47# w=1]]', 's: [connection X1/s =>[signal: a_244_47# w=1]]', 'b: [connection X1/b =>[signal: VPB w=1]]']]
X_Xoutput11_1 VPWR Xoutput11_a_27_47# Xoutput11_a_244_47# VPWR sky130_fd_pr__pfet_01v8_hvt w=820000u l=250000u
** [instance X2 of sky130_fd_pr__pfet_01v8_hvt, params={'w': '1e+06u', 'l': '150000u'} connections=['d: [connection X2/d =>[signal: VPWR w=1]]', 'g: [connection X2/g =>[signal: a_355_47# w=1]]', 's: [connection X2/s =>[signal: X w=1]]', 'b: [connection X2/b =>[signal: VPB w=1]]']]
X_Xoutput11_2 VPWR Xoutput11_a_355_47# scan_out VPWR sky130_fd_pr__pfet_01v8_hvt w=1e+06u l=150000u
** [instance X3 of sky130_fd_pr__pfet_01v8_hvt, params={'w': '1e+06u', 'l': '150000u'} connections=['d: [connection X3/d =>[signal: a_27_47# w=1]]', 'g: [connection X3/g =>[signal: A w=1]]', 's: [connection X3/s =>[signal: VPWR w=1]]', 'b: [connection X3/b =>[signal: VPB w=1]]']]
X_Xoutput11_3 Xoutput11_a_27_47# _76_/Q VPWR VPWR sky130_fd_pr__pfet_01v8_hvt w=1e+06u l=150000u
** [instance X4 of sky130_fd_pr__nfet_01v8, params={'w': '650000u', 'l': '250000u'} connections=['d: [connection X4/d =>[signal: a_355_47# w=1]]', 'g: [connection X4/g =>[signal: a_244_47# w=1]]', 's: [connection X4/s =>[signal: VGND w=1]]', 'b: [connection X4/b =>[signal: VNB w=1]]']]
X_Xoutput11_4 Xoutput11_a_355_47# Xoutput11_a_244_47# VGND VGND sky130_fd_pr__nfet_01v8 w=650000u l=250000u
** [instance X5 of sky130_fd_pr__nfet_01v8, params={'w': '650000u', 'l': '250000u'} connections=['d: [connection X5/d =>[signal: VGND w=1]]', 'g: [connection X5/g =>[signal: a_27_47# w=1]]', 's: [connection X5/s =>[signal: a_244_47# w=1]]', 'b: [connection X5/b =>[signal: VNB w=1]]']]
X_Xoutput11_5 VGND Xoutput11_a_27_47# Xoutput11_a_244_47# VGND sky130_fd_pr__nfet_01v8 w=650000u l=250000u
** [instance X6 of sky130_fd_pr__nfet_01v8, params={'w': '420000u', 'l': '150000u'} connections=['d: [connection X6/d =>[signal: VGND w=1]]', 'g: [connection X6/g =>[signal: a_355_47# w=1]]', 's: [connection X6/s =>[signal: X w=1]]', 'b: [connection X6/b =>[signal: VNB w=1]]']]
X_Xoutput11_6 VGND Xoutput11_a_355_47# scan_out VGND sky130_fd_pr__nfet_01v8 w=420000u l=150000u
** [instance X7 of sky130_fd_pr__nfet_01v8, params={'w': '420000u', 'l': '150000u'} connections=['d: [connection X7/d =>[signal: a_27_47# w=1]]', 'g: [connection X7/g =>[signal: A w=1]]', 's: [connection X7/s =>[signal: VGND w=1]]', 'b: [connection X7/b =>[signal: VNB w=1]]']]
X_Xoutput11_7 Xoutput11_a_27_47# _76_/Q VGND VGND sky130_fd_pr__nfet_01v8 w=420000u l=150000u

** replacing Xoutput9 with the contents of sky130_fd_sc_hd__clkdlybuf4s25_1
** [instance X0 of sky130_fd_pr__pfet_01v8_hvt, params={'w': '820000u', 'l': '250000u'} connections=['d: [connection X0/d =>[signal: a_355_47# w=1]]', 'g: [connection X0/g =>[signal: a_244_47# w=1]]', 's: [connection X0/s =>[signal: VPWR w=1]]', 'b: [connection X0/b =>[signal: VPB w=1]]']]
X_Xoutput9_0 Xoutput9_a_355_47# Xoutput9_a_244_47# VPWR VPWR sky130_fd_pr__pfet_01v8_hvt w=820000u l=250000u
** [instance X1 of sky130_fd_pr__pfet_01v8_hvt, params={'w': '820000u', 'l': '250000u'} connections=['d: [connection X1/d =>[signal: VPWR w=1]]', 'g: [connection X1/g =>[signal: a_27_47# w=1]]', 's: [connection X1/s =>[signal: a_244_47# w=1]]', 'b: [connection X1/b =>[signal: VPB w=1]]']]
X_Xoutput9_1 VPWR Xoutput9_a_27_47# Xoutput9_a_244_47# VPWR sky130_fd_pr__pfet_01v8_hvt w=820000u l=250000u
** [instance X2 of sky130_fd_pr__pfet_01v8_hvt, params={'w': '1e+06u', 'l': '150000u'} connections=['d: [connection X2/d =>[signal: VPWR w=1]]', 'g: [connection X2/g =>[signal: a_355_47# w=1]]', 's: [connection X2/s =>[signal: X w=1]]', 'b: [connection X2/b =>[signal: VPB w=1]]']]
X_Xoutput9_2 VPWR Xoutput9_a_355_47# mux VPWR sky130_fd_pr__pfet_01v8_hvt w=1e+06u l=150000u
** [instance X3 of sky130_fd_pr__pfet_01v8_hvt, params={'w': '1e+06u', 'l': '150000u'} connections=['d: [connection X3/d =>[signal: a_27_47# w=1]]', 'g: [connection X3/g =>[signal: A w=1]]', 's: [connection X3/s =>[signal: VPWR w=1]]', 'b: [connection X3/b =>[signal: VPB w=1]]']]
X_Xoutput9_3 Xoutput9_a_27_47# _40_/X VPWR VPWR sky130_fd_pr__pfet_01v8_hvt w=1e+06u l=150000u
** [instance X4 of sky130_fd_pr__nfet_01v8, params={'w': '650000u', 'l': '250000u'} connections=['d: [connection X4/d =>[signal: a_355_47# w=1]]', 'g: [connection X4/g =>[signal: a_244_47# w=1]]', 's: [connection X4/s =>[signal: VGND w=1]]', 'b: [connection X4/b =>[signal: VNB w=1]]']]
X_Xoutput9_4 Xoutput9_a_355_47# Xoutput9_a_244_47# VGND VGND sky130_fd_pr__nfet_01v8 w=650000u l=250000u
** [instance X5 of sky130_fd_pr__nfet_01v8, params={'w': '650000u', 'l': '250000u'} connections=['d: [connection X5/d =>[signal: VGND w=1]]', 'g: [connection X5/g =>[signal: a_27_47# w=1]]', 's: [connection X5/s =>[signal: a_244_47# w=1]]', 'b: [connection X5/b =>[signal: VNB w=1]]']]
X_Xoutput9_5 VGND Xoutput9_a_27_47# Xoutput9_a_244_47# VGND sky130_fd_pr__nfet_01v8 w=650000u l=250000u
** [instance X6 of sky130_fd_pr__nfet_01v8, params={'w': '420000u', 'l': '150000u'} connections=['d: [connection X6/d =>[signal: VGND w=1]]', 'g: [connection X6/g =>[signal: a_355_47# w=1]]', 's: [connection X6/s =>[signal: X w=1]]', 'b: [connection X6/b =>[signal: VNB w=1]]']]
X_Xoutput9_6 VGND Xoutput9_a_355_47# mux VGND sky130_fd_pr__nfet_01v8 w=420000u l=150000u
** [instance X7 of sky130_fd_pr__nfet_01v8, params={'w': '420000u', 'l': '150000u'} connections=['d: [connection X7/d =>[signal: a_27_47# w=1]]', 'g: [connection X7/g =>[signal: A w=1]]', 's: [connection X7/s =>[signal: VGND w=1]]', 'b: [connection X7/b =>[signal: VNB w=1]]']]
X_Xoutput9_7 Xoutput9_a_27_47# _40_/X VGND VGND sky130_fd_pr__nfet_01v8 w=420000u l=150000u

** replacing XFILLER_12_57 with the contents of sky130_fd_sc_hd__fill_1

** replacing X_63_ with the contents of sky130_fd_sc_hd__dfxtp_2
** [instance X0 of sky130_fd_pr__pfet_01v8_hvt, params={'w': '420000u', 'l': '150000u'} connections=['d: [connection X0/d =>[signal: a_891_413# w=1]]', 'g: [connection X0/g =>[signal: a_193_47# w=1]]', 's: [connection X0/s =>[signal: a_975_413# w=1]]', 'b: [connection X0/b =>[signal: VPB w=1]]']]
X_X_63__0 X_63__a_891_413# X_63__a_193_47# X_63__a_975_413# VPWR sky130_fd_pr__pfet_01v8_hvt w=420000u l=150000u
** [instance X1 of sky130_fd_pr__nfet_01v8, params={'w': '650000u', 'l': '150000u'} connections=['d: [connection X1/d =>[signal: a_1059_315# w=1]]', 'g: [connection X1/g =>[signal: a_891_413# w=1]]', 's: [connection X1/s =>[signal: VGND w=1]]', 'b: [connection X1/b =>[signal: VNB w=1]]']]
X_X_63__1 X_63__a_1059_315# X_63__a_891_413# VGND VGND sky130_fd_pr__nfet_01v8 w=650000u l=150000u
** [instance X2 of sky130_fd_pr__pfet_01v8_hvt, params={'w': '420000u', 'l': '150000u'} connections=['d: [connection X2/d =>[signal: a_466_413# w=1]]', 'g: [connection X2/g =>[signal: a_27_47# w=1]]', 's: [connection X2/s =>[signal: a_561_413# w=1]]', 'b: [connection X2/b =>[signal: VPB w=1]]']]
X_X_63__2 X_63__a_466_413# X_63__a_27_47# X_63__a_561_413# VPWR sky130_fd_pr__pfet_01v8_hvt w=420000u l=150000u
** [instance X3 of sky130_fd_pr__pfet_01v8_hvt, params={'w': '420000u', 'l': '150000u'} connections=['d: [connection X3/d =>[signal: a_634_159# w=1]]', 'g: [connection X3/g =>[signal: a_27_47# w=1]]', 's: [connection X3/s =>[signal: a_891_413# w=1]]', 'b: [connection X3/b =>[signal: VPB w=1]]']]
X_X_63__3 X_63__a_634_159# X_63__a_27_47# X_63__a_891_413# VPWR sky130_fd_pr__pfet_01v8_hvt w=420000u l=150000u
** [instance X4 of sky130_fd_pr__pfet_01v8_hvt, params={'w': '420000u', 'l': '150000u'} connections=['d: [connection X4/d =>[signal: a_381_47# w=1]]', 'g: [connection X4/g =>[signal: a_193_47# w=1]]', 's: [connection X4/s =>[signal: a_466_413# w=1]]', 'b: [connection X4/b =>[signal: VPB w=1]]']]
X_X_63__4 X_63__a_381_47# X_63__a_193_47# X_63__a_466_413# VPWR sky130_fd_pr__pfet_01v8_hvt w=420000u l=150000u
** [instance X5 of sky130_fd_pr__pfet_01v8_hvt, params={'w': '420000u', 'l': '150000u'} connections=['d: [connection X5/d =>[signal: VPWR w=1]]', 'g: [connection X5/g =>[signal: D w=1]]', 's: [connection X5/s =>[signal: a_381_47# w=1]]', 'b: [connection X5/b =>[signal: VPB w=1]]']]
X_X_63__5 VPWR _63_/D X_63__a_381_47# VPWR sky130_fd_pr__pfet_01v8_hvt w=420000u l=150000u
** [instance X6 of sky130_fd_pr__pfet_01v8_hvt, params={'w': '750000u', 'l': '150000u'} connections=['d: [connection X6/d =>[signal: VPWR w=1]]', 'g: [connection X6/g =>[signal: a_466_413# w=1]]', 's: [connection X6/s =>[signal: a_634_159# w=1]]', 'b: [connection X6/b =>[signal: VPB w=1]]']]
X_X_63__6 VPWR X_63__a_466_413# X_63__a_634_159# VPWR sky130_fd_pr__pfet_01v8_hvt w=750000u l=150000u
** [instance X7 of sky130_fd_pr__nfet_01v8, params={'w': '640000u', 'l': '150000u'} connections=['d: [connection X7/d =>[signal: VGND w=1]]', 'g: [connection X7/g =>[signal: a_466_413# w=1]]', 's: [connection X7/s =>[signal: a_634_159# w=1]]', 'b: [connection X7/b =>[signal: VNB w=1]]']]
X_X_63__7 VGND X_63__a_466_413# X_63__a_634_159# VGND sky130_fd_pr__nfet_01v8 w=640000u l=150000u
** [instance X8 of sky130_fd_pr__nfet_01v8, params={'w': '420000u', 'l': '150000u'} connections=['d: [connection X8/d =>[signal: a_1017_47# w=1]]', 'g: [connection X8/g =>[signal: a_1059_315# w=1]]', 's: [connection X8/s =>[signal: VGND w=1]]', 'b: [connection X8/b =>[signal: VNB w=1]]']]
X_X_63__8 X_63__a_1017_47# X_63__a_1059_315# VGND VGND sky130_fd_pr__nfet_01v8 w=420000u l=150000u
** [instance X9 of sky130_fd_pr__pfet_01v8_hvt, params={'w': '1e+06u', 'l': '150000u'} connections=['d: [connection X9/d =>[signal: a_1059_315# w=1]]', 'g: [connection X9/g =>[signal: a_891_413# w=1]]', 's: [connection X9/s =>[signal: VPWR w=1]]', 'b: [connection X9/b =>[signal: VPB w=1]]']]
X_X_63__9 X_63__a_1059_315# X_63__a_891_413# VPWR VPWR sky130_fd_pr__pfet_01v8_hvt w=1e+06u l=150000u
** [instance X10 of sky130_fd_pr__pfet_01v8_hvt, params={'w': '1e+06u', 'l': '150000u'} connections=['d: [connection X10/d =>[signal: Q w=1]]', 'g: [connection X10/g =>[signal: a_1059_315# w=1]]', 's: [connection X10/s =>[signal: VPWR w=1]]', 'b: [connection X10/b =>[signal: VPB w=1]]']]
X_X_63__10 _63_/Q X_63__a_1059_315# VPWR VPWR sky130_fd_pr__pfet_01v8_hvt w=1e+06u l=150000u
** [instance X11 of sky130_fd_pr__pfet_01v8_hvt, params={'w': '420000u', 'l': '150000u'} connections=['d: [connection X11/d =>[signal: a_561_413# w=1]]', 'g: [connection X11/g =>[signal: a_634_159# w=1]]', 's: [connection X11/s =>[signal: VPWR w=1]]', 'b: [connection X11/b =>[signal: VPB w=1]]']]
X_X_63__11 X_63__a_561_413# X_63__a_634_159# VPWR VPWR sky130_fd_pr__pfet_01v8_hvt w=420000u l=150000u
** [instance X12 of sky130_fd_pr__pfet_01v8_hvt, params={'w': '1e+06u', 'l': '150000u'} connections=['d: [connection X12/d =>[signal: VPWR w=1]]', 'g: [connection X12/g =>[signal: a_1059_315# w=1]]', 's: [connection X12/s =>[signal: Q w=1]]', 'b: [connection X12/b =>[signal: VPB w=1]]']]
X_X_63__12 VPWR X_63__a_1059_315# _63_/Q VPWR sky130_fd_pr__pfet_01v8_hvt w=1e+06u l=150000u
** [instance X13 of sky130_fd_pr__nfet_01v8, params={'w': '360000u', 'l': '150000u'} connections=['d: [connection X13/d =>[signal: a_891_413# w=1]]', 'g: [connection X13/g =>[signal: a_27_47# w=1]]', 's: [connection X13/s =>[signal: a_1017_47# w=1]]', 'b: [connection X13/b =>[signal: VNB w=1]]']]
X_X_63__13 X_63__a_891_413# X_63__a_27_47# X_63__a_1017_47# VGND sky130_fd_pr__nfet_01v8 w=360000u l=150000u
** [instance X14 of sky130_fd_pr__nfet_01v8, params={'w': '360000u', 'l': '150000u'} connections=['d: [connection X14/d =>[signal: a_634_159# w=1]]', 'g: [connection X14/g =>[signal: a_193_47# w=1]]', 's: [connection X14/s =>[signal: a_891_413# w=1]]', 'b: [connection X14/b =>[signal: VNB w=1]]']]
X_X_63__14 X_63__a_634_159# X_63__a_193_47# X_63__a_891_413# VGND sky130_fd_pr__nfet_01v8 w=360000u l=150000u
** [instance X15 of sky130_fd_pr__nfet_01v8, params={'w': '420000u', 'l': '150000u'} connections=['d: [connection X15/d =>[signal: a_592_47# w=1]]', 'g: [connection X15/g =>[signal: a_634_159# w=1]]', 's: [connection X15/s =>[signal: VGND w=1]]', 'b: [connection X15/b =>[signal: VNB w=1]]']]
X_X_63__15 X_63__a_592_47# X_63__a_634_159# VGND VGND sky130_fd_pr__nfet_01v8 w=420000u l=150000u
** [instance X16 of sky130_fd_pr__nfet_01v8, params={'w': '360000u', 'l': '150000u'} connections=['d: [connection X16/d =>[signal: a_466_413# w=1]]', 'g: [connection X16/g =>[signal: a_193_47# w=1]]', 's: [connection X16/s =>[signal: a_592_47# w=1]]', 'b: [connection X16/b =>[signal: VNB w=1]]']]
X_X_63__16 X_63__a_466_413# X_63__a_193_47# X_63__a_592_47# VGND sky130_fd_pr__nfet_01v8 w=360000u l=150000u
** [instance X17 of sky130_fd_pr__nfet_01v8, params={'w': '420000u', 'l': '150000u'} connections=['d: [connection X17/d =>[signal: VGND w=1]]', 'g: [connection X17/g =>[signal: a_27_47# w=1]]', 's: [connection X17/s =>[signal: a_193_47# w=1]]', 'b: [connection X17/b =>[signal: VNB w=1]]']]
X_X_63__17 VGND X_63__a_27_47# X_63__a_193_47# VGND sky130_fd_pr__nfet_01v8 w=420000u l=150000u
** [instance X18 of sky130_fd_pr__nfet_01v8, params={'w': '360000u', 'l': '150000u'} connections=['d: [connection X18/d =>[signal: a_381_47# w=1]]', 'g: [connection X18/g =>[signal: a_27_47# w=1]]', 's: [connection X18/s =>[signal: a_466_413# w=1]]', 'b: [connection X18/b =>[signal: VNB w=1]]']]
X_X_63__18 X_63__a_381_47# X_63__a_27_47# X_63__a_466_413# VGND sky130_fd_pr__nfet_01v8 w=360000u l=150000u
** [instance X19 of sky130_fd_pr__nfet_01v8, params={'w': '420000u', 'l': '150000u'} connections=['d: [connection X19/d =>[signal: a_27_47# w=1]]', 'g: [connection X19/g =>[signal: CLK w=1]]', 's: [connection X19/s =>[signal: VGND w=1]]', 'b: [connection X19/b =>[signal: VNB w=1]]']]
X_X_63__19 X_63__a_27_47# _71_/CLK VGND VGND sky130_fd_pr__nfet_01v8 w=420000u l=150000u
** [instance X20 of sky130_fd_pr__pfet_01v8_hvt, params={'w': '640000u', 'l': '150000u'} connections=['d: [connection X20/d =>[signal: a_27_47# w=1]]', 'g: [connection X20/g =>[signal: CLK w=1]]', 's: [connection X20/s =>[signal: VPWR w=1]]', 'b: [connection X20/b =>[signal: VPB w=1]]']]
X_X_63__20 X_63__a_27_47# _71_/CLK VPWR VPWR sky130_fd_pr__pfet_01v8_hvt w=640000u l=150000u
** [instance X21 of sky130_fd_pr__nfet_01v8, params={'w': '650000u', 'l': '150000u'} connections=['d: [connection X21/d =>[signal: Q w=1]]', 'g: [connection X21/g =>[signal: a_1059_315# w=1]]', 's: [connection X21/s =>[signal: VGND w=1]]', 'b: [connection X21/b =>[signal: VNB w=1]]']]
X_X_63__21 _63_/Q X_63__a_1059_315# VGND VGND sky130_fd_pr__nfet_01v8 w=650000u l=150000u
** [instance X22 of sky130_fd_pr__pfet_01v8_hvt, params={'w': '640000u', 'l': '150000u'} connections=['d: [connection X22/d =>[signal: VPWR w=1]]', 'g: [connection X22/g =>[signal: a_27_47# w=1]]', 's: [connection X22/s =>[signal: a_193_47# w=1]]', 'b: [connection X22/b =>[signal: VPB w=1]]']]
X_X_63__22 VPWR X_63__a_27_47# X_63__a_193_47# VPWR sky130_fd_pr__pfet_01v8_hvt w=640000u l=150000u
** [instance X23 of sky130_fd_pr__nfet_01v8, params={'w': '420000u', 'l': '150000u'} connections=['d: [connection X23/d =>[signal: VGND w=1]]', 'g: [connection X23/g =>[signal: D w=1]]', 's: [connection X23/s =>[signal: a_381_47# w=1]]', 'b: [connection X23/b =>[signal: VNB w=1]]']]
X_X_63__23 VGND _63_/D X_63__a_381_47# VGND sky130_fd_pr__nfet_01v8 w=420000u l=150000u
** [instance X24 of sky130_fd_pr__pfet_01v8_hvt, params={'w': '420000u', 'l': '150000u'} connections=['d: [connection X24/d =>[signal: a_975_413# w=1]]', 'g: [connection X24/g =>[signal: a_1059_315# w=1]]', 's: [connection X24/s =>[signal: VPWR w=1]]', 'b: [connection X24/b =>[signal: VPB w=1]]']]
X_X_63__24 X_63__a_975_413# X_63__a_1059_315# VPWR VPWR sky130_fd_pr__pfet_01v8_hvt w=420000u l=150000u
** [instance X25 of sky130_fd_pr__nfet_01v8, params={'w': '650000u', 'l': '150000u'} connections=['d: [connection X25/d =>[signal: VGND w=1]]', 'g: [connection X25/g =>[signal: a_1059_315# w=1]]', 's: [connection X25/s =>[signal: Q w=1]]', 'b: [connection X25/b =>[signal: VNB w=1]]']]
X_X_63__25 VGND X_63__a_1059_315# _63_/Q VGND sky130_fd_pr__nfet_01v8 w=650000u l=150000u

** replacing X_46_ with the contents of sky130_fd_sc_hd__mux2_1
** [instance X0 of sky130_fd_pr__pfet_01v8_hvt, params={'w': '420000u', 'l': '150000u'} connections=['d: [connection X0/d =>[signal: VPWR w=1]]', 'g: [connection X0/g =>[signal: S w=1]]', 's: [connection X0/s =>[signal: a_218_374# w=1]]', 'b: [connection X0/b =>[signal: VPB w=1]]']]
X_X_46__0 VPWR _53_/S X_46__a_218_374# VPWR sky130_fd_pr__pfet_01v8_hvt w=420000u l=150000u
** [instance X1 of sky130_fd_pr__nfet_01v8, params={'w': '420000u', 'l': '150000u'} connections=['d: [connection X1/d =>[signal: a_76_199# w=1]]', 'g: [connection X1/g =>[signal: A0 w=1]]', 's: [connection X1/s =>[signal: a_439_47# w=1]]', 'b: [connection X1/b =>[signal: VNB w=1]]']]
X_X_46__1 X_46__a_76_199# _46_/A0 X_46__a_439_47# VGND sky130_fd_pr__nfet_01v8 w=420000u l=150000u
** [instance X2 of sky130_fd_pr__pfet_01v8_hvt, params={'w': '420000u', 'l': '150000u'} connections=['d: [connection X2/d =>[signal: a_535_374# w=1]]', 'g: [connection X2/g =>[signal: a_505_21# w=1]]', 's: [connection X2/s =>[signal: VPWR w=1]]', 'b: [connection X2/b =>[signal: VPB w=1]]']]
X_X_46__2 X_46__a_535_374# X_46__a_505_21# VPWR VPWR sky130_fd_pr__pfet_01v8_hvt w=420000u l=150000u
** [instance X3 of sky130_fd_pr__pfet_01v8_hvt, params={'w': '420000u', 'l': '150000u'} connections=['d: [connection X3/d =>[signal: VPWR w=1]]', 'g: [connection X3/g =>[signal: S w=1]]', 's: [connection X3/s =>[signal: a_505_21# w=1]]', 'b: [connection X3/b =>[signal: VPB w=1]]']]
X_X_46__3 VPWR _53_/S X_46__a_505_21# VPWR sky130_fd_pr__pfet_01v8_hvt w=420000u l=150000u
** [instance X4 of sky130_fd_pr__pfet_01v8_hvt, params={'w': '420000u', 'l': '150000u'} connections=['d: [connection X4/d =>[signal: a_76_199# w=1]]', 'g: [connection X4/g =>[signal: A1 w=1]]', 's: [connection X4/s =>[signal: a_535_374# w=1]]', 'b: [connection X4/b =>[signal: VPB w=1]]']]
X_X_46__4 X_46__a_76_199# _65_/Q X_46__a_535_374# VPWR sky130_fd_pr__pfet_01v8_hvt w=420000u l=150000u
** [instance X5 of sky130_fd_pr__nfet_01v8, params={'w': '420000u', 'l': '150000u'} connections=['d: [connection X5/d =>[signal: a_218_47# w=1]]', 'g: [connection X5/g =>[signal: A1 w=1]]', 's: [connection X5/s =>[signal: a_76_199# w=1]]', 'b: [connection X5/b =>[signal: VNB w=1]]']]
X_X_46__5 X_46__a_218_47# _65_/Q X_46__a_76_199# VGND sky130_fd_pr__nfet_01v8 w=420000u l=150000u
** [instance X6 of sky130_fd_pr__pfet_01v8_hvt, params={'w': '420000u', 'l': '150000u'} connections=['d: [connection X6/d =>[signal: a_218_374# w=1]]', 'g: [connection X6/g =>[signal: A0 w=1]]', 's: [connection X6/s =>[signal: a_76_199# w=1]]', 'b: [connection X6/b =>[signal: VPB w=1]]']]
X_X_46__6 X_46__a_218_374# _46_/A0 X_46__a_76_199# VPWR sky130_fd_pr__pfet_01v8_hvt w=420000u l=150000u
** [instance X7 of sky130_fd_pr__nfet_01v8, params={'w': '650000u', 'l': '150000u'} connections=['d: [connection X7/d =>[signal: X w=1]]', 'g: [connection X7/g =>[signal: a_76_199# w=1]]', 's: [connection X7/s =>[signal: VGND w=1]]', 'b: [connection X7/b =>[signal: VNB w=1]]']]
X_X_46__7 _46_/X X_46__a_76_199# VGND VGND sky130_fd_pr__nfet_01v8 w=650000u l=150000u
** [instance X8 of sky130_fd_pr__pfet_01v8_hvt, params={'w': '1e+06u', 'l': '150000u'} connections=['d: [connection X8/d =>[signal: X w=1]]', 'g: [connection X8/g =>[signal: a_76_199# w=1]]', 's: [connection X8/s =>[signal: VPWR w=1]]', 'b: [connection X8/b =>[signal: VPB w=1]]']]
X_X_46__8 _46_/X X_46__a_76_199# VPWR VPWR sky130_fd_pr__pfet_01v8_hvt w=1e+06u l=150000u
** [instance X9 of sky130_fd_pr__nfet_01v8, params={'w': '420000u', 'l': '150000u'} connections=['d: [connection X9/d =>[signal: VGND w=1]]', 'g: [connection X9/g =>[signal: S w=1]]', 's: [connection X9/s =>[signal: a_218_47# w=1]]', 'b: [connection X9/b =>[signal: VNB w=1]]']]
X_X_46__9 VGND _53_/S X_46__a_218_47# VGND sky130_fd_pr__nfet_01v8 w=420000u l=150000u
** [instance X10 of sky130_fd_pr__nfet_01v8, params={'w': '420000u', 'l': '150000u'} connections=['d: [connection X10/d =>[signal: VGND w=1]]', 'g: [connection X10/g =>[signal: S w=1]]', 's: [connection X10/s =>[signal: a_505_21# w=1]]', 'b: [connection X10/b =>[signal: VNB w=1]]']]
X_X_46__10 VGND _53_/S X_46__a_505_21# VGND sky130_fd_pr__nfet_01v8 w=420000u l=150000u
** [instance X11 of sky130_fd_pr__nfet_01v8, params={'w': '420000u', 'l': '150000u'} connections=['d: [connection X11/d =>[signal: a_439_47# w=1]]', 'g: [connection X11/g =>[signal: a_505_21# w=1]]', 's: [connection X11/s =>[signal: VGND w=1]]', 'b: [connection X11/b =>[signal: VNB w=1]]']]
X_X_46__11 X_46__a_439_47# X_46__a_505_21# VGND VGND sky130_fd_pr__nfet_01v8 w=420000u l=150000u

** replacing Xhold22 with the contents of sky130_fd_sc_hd__dlygate4sd3_1
** [instance X0 of sky130_fd_pr__nfet_01v8, params={'w': '420000u', 'l': '500000u'} connections=['d: [connection X0/d =>[signal: a_391_47# w=1]]', 'g: [connection X0/g =>[signal: a_285_47# w=1]]', 's: [connection X0/s =>[signal: VGND w=1]]', 'b: [connection X0/b =>[signal: VNB w=1]]']]
X_Xhold22_0 Xhold22_a_391_47# Xhold22_a_285_47# VGND VGND sky130_fd_pr__nfet_01v8 w=420000u l=500000u
** [instance X1 of sky130_fd_pr__pfet_01v8_hvt, params={'w': '420000u', 'l': '500000u'} connections=['d: [connection X1/d =>[signal: VPWR w=1]]', 'g: [connection X1/g =>[signal: a_49_47# w=1]]', 's: [connection X1/s =>[signal: a_285_47# w=1]]', 'b: [connection X1/b =>[signal: VPB w=1]]']]
X_Xhold22_1 VPWR Xhold22_a_49_47# Xhold22_a_285_47# VPWR sky130_fd_pr__pfet_01v8_hvt w=420000u l=500000u
** [instance X2 of sky130_fd_pr__nfet_01v8, params={'w': '420000u', 'l': '150000u'} connections=['d: [connection X2/d =>[signal: a_49_47# w=1]]', 'g: [connection X2/g =>[signal: A w=1]]', 's: [connection X2/s =>[signal: VGND w=1]]', 'b: [connection X2/b =>[signal: VNB w=1]]']]
X_Xhold22_2 Xhold22_a_49_47# _59_/Q VGND VGND sky130_fd_pr__nfet_01v8 w=420000u l=150000u
** [instance X3 of sky130_fd_pr__pfet_01v8_hvt, params={'w': '1e+06u', 'l': '150000u'} connections=['d: [connection X3/d =>[signal: VPWR w=1]]', 'g: [connection X3/g =>[signal: a_391_47# w=1]]', 's: [connection X3/s =>[signal: X w=1]]', 'b: [connection X3/b =>[signal: VPB w=1]]']]
X_Xhold22_3 VPWR Xhold22_a_391_47# _58_/A1 VPWR sky130_fd_pr__pfet_01v8_hvt w=1e+06u l=150000u
** [instance X4 of sky130_fd_pr__nfet_01v8, params={'w': '650000u', 'l': '150000u'} connections=['d: [connection X4/d =>[signal: VGND w=1]]', 'g: [connection X4/g =>[signal: a_391_47# w=1]]', 's: [connection X4/s =>[signal: X w=1]]', 'b: [connection X4/b =>[signal: VNB w=1]]']]
X_Xhold22_4 VGND Xhold22_a_391_47# _58_/A1 VGND sky130_fd_pr__nfet_01v8 w=650000u l=150000u
** [instance X5 of sky130_fd_pr__nfet_01v8, params={'w': '420000u', 'l': '500000u'} connections=['d: [connection X5/d =>[signal: VGND w=1]]', 'g: [connection X5/g =>[signal: a_49_47# w=1]]', 's: [connection X5/s =>[signal: a_285_47# w=1]]', 'b: [connection X5/b =>[signal: VNB w=1]]']]
X_Xhold22_5 VGND Xhold22_a_49_47# Xhold22_a_285_47# VGND sky130_fd_pr__nfet_01v8 w=420000u l=500000u
** [instance X6 of sky130_fd_pr__pfet_01v8_hvt, params={'w': '420000u', 'l': '500000u'} connections=['d: [connection X6/d =>[signal: a_391_47# w=1]]', 'g: [connection X6/g =>[signal: a_285_47# w=1]]', 's: [connection X6/s =>[signal: VPWR w=1]]', 'b: [connection X6/b =>[signal: VPB w=1]]']]
X_Xhold22_6 Xhold22_a_391_47# Xhold22_a_285_47# VPWR VPWR sky130_fd_pr__pfet_01v8_hvt w=420000u l=500000u
** [instance X7 of sky130_fd_pr__pfet_01v8_hvt, params={'w': '420000u', 'l': '150000u'} connections=['d: [connection X7/d =>[signal: a_49_47# w=1]]', 'g: [connection X7/g =>[signal: A w=1]]', 's: [connection X7/s =>[signal: VPWR w=1]]', 'b: [connection X7/b =>[signal: VPB w=1]]']]
X_Xhold22_7 Xhold22_a_49_47# _59_/Q VPWR VPWR sky130_fd_pr__pfet_01v8_hvt w=420000u l=150000u

** replacing Xhold33 with the contents of sky130_fd_sc_hd__dlygate4sd3_1
** [instance X0 of sky130_fd_pr__nfet_01v8, params={'w': '420000u', 'l': '500000u'} connections=['d: [connection X0/d =>[signal: a_391_47# w=1]]', 'g: [connection X0/g =>[signal: a_285_47# w=1]]', 's: [connection X0/s =>[signal: VGND w=1]]', 'b: [connection X0/b =>[signal: VNB w=1]]']]
X_Xhold33_0 Xhold33_a_391_47# Xhold33_a_285_47# VGND VGND sky130_fd_pr__nfet_01v8 w=420000u l=500000u
** [instance X1 of sky130_fd_pr__pfet_01v8_hvt, params={'w': '420000u', 'l': '500000u'} connections=['d: [connection X1/d =>[signal: VPWR w=1]]', 'g: [connection X1/g =>[signal: a_49_47# w=1]]', 's: [connection X1/s =>[signal: a_285_47# w=1]]', 'b: [connection X1/b =>[signal: VPB w=1]]']]
X_Xhold33_1 VPWR Xhold33_a_49_47# Xhold33_a_285_47# VPWR sky130_fd_pr__pfet_01v8_hvt w=420000u l=500000u
** [instance X2 of sky130_fd_pr__nfet_01v8, params={'w': '420000u', 'l': '150000u'} connections=['d: [connection X2/d =>[signal: a_49_47# w=1]]', 'g: [connection X2/g =>[signal: A w=1]]', 's: [connection X2/s =>[signal: VGND w=1]]', 'b: [connection X2/b =>[signal: VNB w=1]]']]
X_Xhold33_2 Xhold33_a_49_47# _70_/Q VGND VGND sky130_fd_pr__nfet_01v8 w=420000u l=150000u
** [instance X3 of sky130_fd_pr__pfet_01v8_hvt, params={'w': '1e+06u', 'l': '150000u'} connections=['d: [connection X3/d =>[signal: VPWR w=1]]', 'g: [connection X3/g =>[signal: a_391_47# w=1]]', 's: [connection X3/s =>[signal: X w=1]]', 'b: [connection X3/b =>[signal: VPB w=1]]']]
X_Xhold33_3 VPWR Xhold33_a_391_47# _52_/A0 VPWR sky130_fd_pr__pfet_01v8_hvt w=1e+06u l=150000u
** [instance X4 of sky130_fd_pr__nfet_01v8, params={'w': '650000u', 'l': '150000u'} connections=['d: [connection X4/d =>[signal: VGND w=1]]', 'g: [connection X4/g =>[signal: a_391_47# w=1]]', 's: [connection X4/s =>[signal: X w=1]]', 'b: [connection X4/b =>[signal: VNB w=1]]']]
X_Xhold33_4 VGND Xhold33_a_391_47# _52_/A0 VGND sky130_fd_pr__nfet_01v8 w=650000u l=150000u
** [instance X5 of sky130_fd_pr__nfet_01v8, params={'w': '420000u', 'l': '500000u'} connections=['d: [connection X5/d =>[signal: VGND w=1]]', 'g: [connection X5/g =>[signal: a_49_47# w=1]]', 's: [connection X5/s =>[signal: a_285_47# w=1]]', 'b: [connection X5/b =>[signal: VNB w=1]]']]
X_Xhold33_5 VGND Xhold33_a_49_47# Xhold33_a_285_47# VGND sky130_fd_pr__nfet_01v8 w=420000u l=500000u
** [instance X6 of sky130_fd_pr__pfet_01v8_hvt, params={'w': '420000u', 'l': '500000u'} connections=['d: [connection X6/d =>[signal: a_391_47# w=1]]', 'g: [connection X6/g =>[signal: a_285_47# w=1]]', 's: [connection X6/s =>[signal: VPWR w=1]]', 'b: [connection X6/b =>[signal: VPB w=1]]']]
X_Xhold33_6 Xhold33_a_391_47# Xhold33_a_285_47# VPWR VPWR sky130_fd_pr__pfet_01v8_hvt w=420000u l=500000u
** [instance X7 of sky130_fd_pr__pfet_01v8_hvt, params={'w': '420000u', 'l': '150000u'} connections=['d: [connection X7/d =>[signal: a_49_47# w=1]]', 'g: [connection X7/g =>[signal: A w=1]]', 's: [connection X7/s =>[signal: VPWR w=1]]', 'b: [connection X7/b =>[signal: VPB w=1]]']]
X_Xhold33_7 Xhold33_a_49_47# _70_/Q VPWR VPWR sky130_fd_pr__pfet_01v8_hvt w=420000u l=150000u

** replacing X_29_ with the contents of sky130_fd_sc_hd__inv_2
** [instance X0 of sky130_fd_pr__nfet_01v8, params={'w': '650000u', 'l': '150000u'} connections=['d: [connection X0/d =>[signal: Y w=1]]', 'g: [connection X0/g =>[signal: A w=1]]', 's: [connection X0/s =>[signal: VGND w=1]]', 'b: [connection X0/b =>[signal: VNB w=1]]']]
X_X_29__0 _29_/Y _37_/S VGND VGND sky130_fd_pr__nfet_01v8 w=650000u l=150000u
** [instance X1 of sky130_fd_pr__pfet_01v8_hvt, params={'w': '1e+06u', 'l': '150000u'} connections=['d: [connection X1/d =>[signal: VPWR w=1]]', 'g: [connection X1/g =>[signal: A w=1]]', 's: [connection X1/s =>[signal: Y w=1]]', 'b: [connection X1/b =>[signal: VPB w=1]]']]
X_X_29__1 VPWR _37_/S _29_/Y VPWR sky130_fd_pr__pfet_01v8_hvt w=1e+06u l=150000u
** [instance X2 of sky130_fd_pr__nfet_01v8, params={'w': '650000u', 'l': '150000u'} connections=['d: [connection X2/d =>[signal: VGND w=1]]', 'g: [connection X2/g =>[signal: A w=1]]', 's: [connection X2/s =>[signal: Y w=1]]', 'b: [connection X2/b =>[signal: VNB w=1]]']]
X_X_29__2 VGND _37_/S _29_/Y VGND sky130_fd_pr__nfet_01v8 w=650000u l=150000u
** [instance X3 of sky130_fd_pr__pfet_01v8_hvt, params={'w': '1e+06u', 'l': '150000u'} connections=['d: [connection X3/d =>[signal: Y w=1]]', 'g: [connection X3/g =>[signal: A w=1]]', 's: [connection X3/s =>[signal: VPWR w=1]]', 'b: [connection X3/b =>[signal: VPB w=1]]']]
X_X_29__3 _29_/Y _37_/S VPWR VPWR sky130_fd_pr__pfet_01v8_hvt w=1e+06u l=150000u

** replacing XFILLER_12_14 with the contents of sky130_fd_sc_hd__fill_1

** replacing XFILLER_7_80 with the contents of sky130_fd_sc_hd__decap_3
** [instance X0 of sky130_fd_pr__pfet_01v8_hvt, params={'w': '870000u', 'l': '590000u'} connections=['d: [connection X0/d =>[signal: VPWR w=1]]', 'g: [connection X0/g =>[signal: VGND w=1]]', 's: [connection X0/s =>[signal: VPWR w=1]]', 'b: [connection X0/b =>[signal: VPB w=1]]']]
X_XFILLER_7_80_0 VPWR VGND VPWR VPWR sky130_fd_pr__pfet_01v8_hvt w=870000u l=590000u
** [instance X1 of sky130_fd_pr__nfet_01v8, params={'w': '550000u', 'l': '590000u'} connections=['d: [connection X1/d =>[signal: VGND w=1]]', 'g: [connection X1/g =>[signal: VPWR w=1]]', 's: [connection X1/s =>[signal: VGND w=1]]', 'b: [connection X1/b =>[signal: VNB w=1]]']]
X_XFILLER_7_80_1 VGND VPWR VGND VGND sky130_fd_pr__nfet_01v8 w=550000u l=590000u

** replacing X_62_ with the contents of sky130_fd_sc_hd__dfxtp_2
** [instance X0 of sky130_fd_pr__pfet_01v8_hvt, params={'w': '420000u', 'l': '150000u'} connections=['d: [connection X0/d =>[signal: a_891_413# w=1]]', 'g: [connection X0/g =>[signal: a_193_47# w=1]]', 's: [connection X0/s =>[signal: a_975_413# w=1]]', 'b: [connection X0/b =>[signal: VPB w=1]]']]
X_X_62__0 X_62__a_891_413# X_62__a_193_47# X_62__a_975_413# VPWR sky130_fd_pr__pfet_01v8_hvt w=420000u l=150000u
** [instance X1 of sky130_fd_pr__nfet_01v8, params={'w': '650000u', 'l': '150000u'} connections=['d: [connection X1/d =>[signal: a_1059_315# w=1]]', 'g: [connection X1/g =>[signal: a_891_413# w=1]]', 's: [connection X1/s =>[signal: VGND w=1]]', 'b: [connection X1/b =>[signal: VNB w=1]]']]
X_X_62__1 X_62__a_1059_315# X_62__a_891_413# VGND VGND sky130_fd_pr__nfet_01v8 w=650000u l=150000u
** [instance X2 of sky130_fd_pr__pfet_01v8_hvt, params={'w': '420000u', 'l': '150000u'} connections=['d: [connection X2/d =>[signal: a_466_413# w=1]]', 'g: [connection X2/g =>[signal: a_27_47# w=1]]', 's: [connection X2/s =>[signal: a_561_413# w=1]]', 'b: [connection X2/b =>[signal: VPB w=1]]']]
X_X_62__2 X_62__a_466_413# X_62__a_27_47# X_62__a_561_413# VPWR sky130_fd_pr__pfet_01v8_hvt w=420000u l=150000u
** [instance X3 of sky130_fd_pr__pfet_01v8_hvt, params={'w': '420000u', 'l': '150000u'} connections=['d: [connection X3/d =>[signal: a_634_159# w=1]]', 'g: [connection X3/g =>[signal: a_27_47# w=1]]', 's: [connection X3/s =>[signal: a_891_413# w=1]]', 'b: [connection X3/b =>[signal: VPB w=1]]']]
X_X_62__3 X_62__a_634_159# X_62__a_27_47# X_62__a_891_413# VPWR sky130_fd_pr__pfet_01v8_hvt w=420000u l=150000u
** [instance X4 of sky130_fd_pr__pfet_01v8_hvt, params={'w': '420000u', 'l': '150000u'} connections=['d: [connection X4/d =>[signal: a_381_47# w=1]]', 'g: [connection X4/g =>[signal: a_193_47# w=1]]', 's: [connection X4/s =>[signal: a_466_413# w=1]]', 'b: [connection X4/b =>[signal: VPB w=1]]']]
X_X_62__4 X_62__a_381_47# X_62__a_193_47# X_62__a_466_413# VPWR sky130_fd_pr__pfet_01v8_hvt w=420000u l=150000u
** [instance X5 of sky130_fd_pr__pfet_01v8_hvt, params={'w': '420000u', 'l': '150000u'} connections=['d: [connection X5/d =>[signal: VPWR w=1]]', 'g: [connection X5/g =>[signal: D w=1]]', 's: [connection X5/s =>[signal: a_381_47# w=1]]', 'b: [connection X5/b =>[signal: VPB w=1]]']]
X_X_62__5 VPWR _62_/D X_62__a_381_47# VPWR sky130_fd_pr__pfet_01v8_hvt w=420000u l=150000u
** [instance X6 of sky130_fd_pr__pfet_01v8_hvt, params={'w': '750000u', 'l': '150000u'} connections=['d: [connection X6/d =>[signal: VPWR w=1]]', 'g: [connection X6/g =>[signal: a_466_413# w=1]]', 's: [connection X6/s =>[signal: a_634_159# w=1]]', 'b: [connection X6/b =>[signal: VPB w=1]]']]
X_X_62__6 VPWR X_62__a_466_413# X_62__a_634_159# VPWR sky130_fd_pr__pfet_01v8_hvt w=750000u l=150000u
** [instance X7 of sky130_fd_pr__nfet_01v8, params={'w': '640000u', 'l': '150000u'} connections=['d: [connection X7/d =>[signal: VGND w=1]]', 'g: [connection X7/g =>[signal: a_466_413# w=1]]', 's: [connection X7/s =>[signal: a_634_159# w=1]]', 'b: [connection X7/b =>[signal: VNB w=1]]']]
X_X_62__7 VGND X_62__a_466_413# X_62__a_634_159# VGND sky130_fd_pr__nfet_01v8 w=640000u l=150000u
** [instance X8 of sky130_fd_pr__nfet_01v8, params={'w': '420000u', 'l': '150000u'} connections=['d: [connection X8/d =>[signal: a_1017_47# w=1]]', 'g: [connection X8/g =>[signal: a_1059_315# w=1]]', 's: [connection X8/s =>[signal: VGND w=1]]', 'b: [connection X8/b =>[signal: VNB w=1]]']]
X_X_62__8 X_62__a_1017_47# X_62__a_1059_315# VGND VGND sky130_fd_pr__nfet_01v8 w=420000u l=150000u
** [instance X9 of sky130_fd_pr__pfet_01v8_hvt, params={'w': '1e+06u', 'l': '150000u'} connections=['d: [connection X9/d =>[signal: a_1059_315# w=1]]', 'g: [connection X9/g =>[signal: a_891_413# w=1]]', 's: [connection X9/s =>[signal: VPWR w=1]]', 'b: [connection X9/b =>[signal: VPB w=1]]']]
X_X_62__9 X_62__a_1059_315# X_62__a_891_413# VPWR VPWR sky130_fd_pr__pfet_01v8_hvt w=1e+06u l=150000u
** [instance X10 of sky130_fd_pr__pfet_01v8_hvt, params={'w': '1e+06u', 'l': '150000u'} connections=['d: [connection X10/d =>[signal: Q w=1]]', 'g: [connection X10/g =>[signal: a_1059_315# w=1]]', 's: [connection X10/s =>[signal: VPWR w=1]]', 'b: [connection X10/b =>[signal: VPB w=1]]']]
X_X_62__10 _62_/Q X_62__a_1059_315# VPWR VPWR sky130_fd_pr__pfet_01v8_hvt w=1e+06u l=150000u
** [instance X11 of sky130_fd_pr__pfet_01v8_hvt, params={'w': '420000u', 'l': '150000u'} connections=['d: [connection X11/d =>[signal: a_561_413# w=1]]', 'g: [connection X11/g =>[signal: a_634_159# w=1]]', 's: [connection X11/s =>[signal: VPWR w=1]]', 'b: [connection X11/b =>[signal: VPB w=1]]']]
X_X_62__11 X_62__a_561_413# X_62__a_634_159# VPWR VPWR sky130_fd_pr__pfet_01v8_hvt w=420000u l=150000u
** [instance X12 of sky130_fd_pr__pfet_01v8_hvt, params={'w': '1e+06u', 'l': '150000u'} connections=['d: [connection X12/d =>[signal: VPWR w=1]]', 'g: [connection X12/g =>[signal: a_1059_315# w=1]]', 's: [connection X12/s =>[signal: Q w=1]]', 'b: [connection X12/b =>[signal: VPB w=1]]']]
X_X_62__12 VPWR X_62__a_1059_315# _62_/Q VPWR sky130_fd_pr__pfet_01v8_hvt w=1e+06u l=150000u
** [instance X13 of sky130_fd_pr__nfet_01v8, params={'w': '360000u', 'l': '150000u'} connections=['d: [connection X13/d =>[signal: a_891_413# w=1]]', 'g: [connection X13/g =>[signal: a_27_47# w=1]]', 's: [connection X13/s =>[signal: a_1017_47# w=1]]', 'b: [connection X13/b =>[signal: VNB w=1]]']]
X_X_62__13 X_62__a_891_413# X_62__a_27_47# X_62__a_1017_47# VGND sky130_fd_pr__nfet_01v8 w=360000u l=150000u
** [instance X14 of sky130_fd_pr__nfet_01v8, params={'w': '360000u', 'l': '150000u'} connections=['d: [connection X14/d =>[signal: a_634_159# w=1]]', 'g: [connection X14/g =>[signal: a_193_47# w=1]]', 's: [connection X14/s =>[signal: a_891_413# w=1]]', 'b: [connection X14/b =>[signal: VNB w=1]]']]
X_X_62__14 X_62__a_634_159# X_62__a_193_47# X_62__a_891_413# VGND sky130_fd_pr__nfet_01v8 w=360000u l=150000u
** [instance X15 of sky130_fd_pr__nfet_01v8, params={'w': '420000u', 'l': '150000u'} connections=['d: [connection X15/d =>[signal: a_592_47# w=1]]', 'g: [connection X15/g =>[signal: a_634_159# w=1]]', 's: [connection X15/s =>[signal: VGND w=1]]', 'b: [connection X15/b =>[signal: VNB w=1]]']]
X_X_62__15 X_62__a_592_47# X_62__a_634_159# VGND VGND sky130_fd_pr__nfet_01v8 w=420000u l=150000u
** [instance X16 of sky130_fd_pr__nfet_01v8, params={'w': '360000u', 'l': '150000u'} connections=['d: [connection X16/d =>[signal: a_466_413# w=1]]', 'g: [connection X16/g =>[signal: a_193_47# w=1]]', 's: [connection X16/s =>[signal: a_592_47# w=1]]', 'b: [connection X16/b =>[signal: VNB w=1]]']]
X_X_62__16 X_62__a_466_413# X_62__a_193_47# X_62__a_592_47# VGND sky130_fd_pr__nfet_01v8 w=360000u l=150000u
** [instance X17 of sky130_fd_pr__nfet_01v8, params={'w': '420000u', 'l': '150000u'} connections=['d: [connection X17/d =>[signal: VGND w=1]]', 'g: [connection X17/g =>[signal: a_27_47# w=1]]', 's: [connection X17/s =>[signal: a_193_47# w=1]]', 'b: [connection X17/b =>[signal: VNB w=1]]']]
X_X_62__17 VGND X_62__a_27_47# X_62__a_193_47# VGND sky130_fd_pr__nfet_01v8 w=420000u l=150000u
** [instance X18 of sky130_fd_pr__nfet_01v8, params={'w': '360000u', 'l': '150000u'} connections=['d: [connection X18/d =>[signal: a_381_47# w=1]]', 'g: [connection X18/g =>[signal: a_27_47# w=1]]', 's: [connection X18/s =>[signal: a_466_413# w=1]]', 'b: [connection X18/b =>[signal: VNB w=1]]']]
X_X_62__18 X_62__a_381_47# X_62__a_27_47# X_62__a_466_413# VGND sky130_fd_pr__nfet_01v8 w=360000u l=150000u
** [instance X19 of sky130_fd_pr__nfet_01v8, params={'w': '420000u', 'l': '150000u'} connections=['d: [connection X19/d =>[signal: a_27_47# w=1]]', 'g: [connection X19/g =>[signal: CLK w=1]]', 's: [connection X19/s =>[signal: VGND w=1]]', 'b: [connection X19/b =>[signal: VNB w=1]]']]
X_X_62__19 X_62__a_27_47# _71_/CLK VGND VGND sky130_fd_pr__nfet_01v8 w=420000u l=150000u
** [instance X20 of sky130_fd_pr__pfet_01v8_hvt, params={'w': '640000u', 'l': '150000u'} connections=['d: [connection X20/d =>[signal: a_27_47# w=1]]', 'g: [connection X20/g =>[signal: CLK w=1]]', 's: [connection X20/s =>[signal: VPWR w=1]]', 'b: [connection X20/b =>[signal: VPB w=1]]']]
X_X_62__20 X_62__a_27_47# _71_/CLK VPWR VPWR sky130_fd_pr__pfet_01v8_hvt w=640000u l=150000u
** [instance X21 of sky130_fd_pr__nfet_01v8, params={'w': '650000u', 'l': '150000u'} connections=['d: [connection X21/d =>[signal: Q w=1]]', 'g: [connection X21/g =>[signal: a_1059_315# w=1]]', 's: [connection X21/s =>[signal: VGND w=1]]', 'b: [connection X21/b =>[signal: VNB w=1]]']]
X_X_62__21 _62_/Q X_62__a_1059_315# VGND VGND sky130_fd_pr__nfet_01v8 w=650000u l=150000u
** [instance X22 of sky130_fd_pr__pfet_01v8_hvt, params={'w': '640000u', 'l': '150000u'} connections=['d: [connection X22/d =>[signal: VPWR w=1]]', 'g: [connection X22/g =>[signal: a_27_47# w=1]]', 's: [connection X22/s =>[signal: a_193_47# w=1]]', 'b: [connection X22/b =>[signal: VPB w=1]]']]
X_X_62__22 VPWR X_62__a_27_47# X_62__a_193_47# VPWR sky130_fd_pr__pfet_01v8_hvt w=640000u l=150000u
** [instance X23 of sky130_fd_pr__nfet_01v8, params={'w': '420000u', 'l': '150000u'} connections=['d: [connection X23/d =>[signal: VGND w=1]]', 'g: [connection X23/g =>[signal: D w=1]]', 's: [connection X23/s =>[signal: a_381_47# w=1]]', 'b: [connection X23/b =>[signal: VNB w=1]]']]
X_X_62__23 VGND _62_/D X_62__a_381_47# VGND sky130_fd_pr__nfet_01v8 w=420000u l=150000u
** [instance X24 of sky130_fd_pr__pfet_01v8_hvt, params={'w': '420000u', 'l': '150000u'} connections=['d: [connection X24/d =>[signal: a_975_413# w=1]]', 'g: [connection X24/g =>[signal: a_1059_315# w=1]]', 's: [connection X24/s =>[signal: VPWR w=1]]', 'b: [connection X24/b =>[signal: VPB w=1]]']]
X_X_62__24 X_62__a_975_413# X_62__a_1059_315# VPWR VPWR sky130_fd_pr__pfet_01v8_hvt w=420000u l=150000u
** [instance X25 of sky130_fd_pr__nfet_01v8, params={'w': '650000u', 'l': '150000u'} connections=['d: [connection X25/d =>[signal: VGND w=1]]', 'g: [connection X25/g =>[signal: a_1059_315# w=1]]', 's: [connection X25/s =>[signal: Q w=1]]', 'b: [connection X25/b =>[signal: VNB w=1]]']]
X_X_62__25 VGND X_62__a_1059_315# _62_/Q VGND sky130_fd_pr__nfet_01v8 w=650000u l=150000u

** replacing XTAP_TAPCELL_ROW_8_37 with the contents of sky130_fd_sc_hd__tapvpwrvgnd_1

** replacing Xhold23 with the contents of sky130_fd_sc_hd__dlygate4sd3_1
** [instance X0 of sky130_fd_pr__nfet_01v8, params={'w': '420000u', 'l': '500000u'} connections=['d: [connection X0/d =>[signal: a_391_47# w=1]]', 'g: [connection X0/g =>[signal: a_285_47# w=1]]', 's: [connection X0/s =>[signal: VGND w=1]]', 'b: [connection X0/b =>[signal: VNB w=1]]']]
X_Xhold23_0 Xhold23_a_391_47# Xhold23_a_285_47# VGND VGND sky130_fd_pr__nfet_01v8 w=420000u l=500000u
** [instance X1 of sky130_fd_pr__pfet_01v8_hvt, params={'w': '420000u', 'l': '500000u'} connections=['d: [connection X1/d =>[signal: VPWR w=1]]', 'g: [connection X1/g =>[signal: a_49_47# w=1]]', 's: [connection X1/s =>[signal: a_285_47# w=1]]', 'b: [connection X1/b =>[signal: VPB w=1]]']]
X_Xhold23_1 VPWR Xhold23_a_49_47# Xhold23_a_285_47# VPWR sky130_fd_pr__pfet_01v8_hvt w=420000u l=500000u
** [instance X2 of sky130_fd_pr__nfet_01v8, params={'w': '420000u', 'l': '150000u'} connections=['d: [connection X2/d =>[signal: a_49_47# w=1]]', 'g: [connection X2/g =>[signal: A w=1]]', 's: [connection X2/s =>[signal: VGND w=1]]', 'b: [connection X2/b =>[signal: VNB w=1]]']]
X_Xhold23_2 Xhold23_a_49_47# _63_/Q VGND VGND sky130_fd_pr__nfet_01v8 w=420000u l=150000u
** [instance X3 of sky130_fd_pr__pfet_01v8_hvt, params={'w': '1e+06u', 'l': '150000u'} connections=['d: [connection X3/d =>[signal: VPWR w=1]]', 'g: [connection X3/g =>[signal: a_391_47# w=1]]', 's: [connection X3/s =>[signal: X w=1]]', 'b: [connection X3/b =>[signal: VPB w=1]]']]
X_Xhold23_3 VPWR Xhold23_a_391_47# _45_/A0 VPWR sky130_fd_pr__pfet_01v8_hvt w=1e+06u l=150000u
** [instance X4 of sky130_fd_pr__nfet_01v8, params={'w': '650000u', 'l': '150000u'} connections=['d: [connection X4/d =>[signal: VGND w=1]]', 'g: [connection X4/g =>[signal: a_391_47# w=1]]', 's: [connection X4/s =>[signal: X w=1]]', 'b: [connection X4/b =>[signal: VNB w=1]]']]
X_Xhold23_4 VGND Xhold23_a_391_47# _45_/A0 VGND sky130_fd_pr__nfet_01v8 w=650000u l=150000u
** [instance X5 of sky130_fd_pr__nfet_01v8, params={'w': '420000u', 'l': '500000u'} connections=['d: [connection X5/d =>[signal: VGND w=1]]', 'g: [connection X5/g =>[signal: a_49_47# w=1]]', 's: [connection X5/s =>[signal: a_285_47# w=1]]', 'b: [connection X5/b =>[signal: VNB w=1]]']]
X_Xhold23_5 VGND Xhold23_a_49_47# Xhold23_a_285_47# VGND sky130_fd_pr__nfet_01v8 w=420000u l=500000u
** [instance X6 of sky130_fd_pr__pfet_01v8_hvt, params={'w': '420000u', 'l': '500000u'} connections=['d: [connection X6/d =>[signal: a_391_47# w=1]]', 'g: [connection X6/g =>[signal: a_285_47# w=1]]', 's: [connection X6/s =>[signal: VPWR w=1]]', 'b: [connection X6/b =>[signal: VPB w=1]]']]
X_Xhold23_6 Xhold23_a_391_47# Xhold23_a_285_47# VPWR VPWR sky130_fd_pr__pfet_01v8_hvt w=420000u l=500000u
** [instance X7 of sky130_fd_pr__pfet_01v8_hvt, params={'w': '420000u', 'l': '150000u'} connections=['d: [connection X7/d =>[signal: a_49_47# w=1]]', 'g: [connection X7/g =>[signal: A w=1]]', 's: [connection X7/s =>[signal: VPWR w=1]]', 'b: [connection X7/b =>[signal: VPB w=1]]']]
X_Xhold23_7 Xhold23_a_49_47# _63_/Q VPWR VPWR sky130_fd_pr__pfet_01v8_hvt w=420000u l=150000u

** replacing X_45_ with the contents of sky130_fd_sc_hd__mux2_1
** [instance X0 of sky130_fd_pr__pfet_01v8_hvt, params={'w': '420000u', 'l': '150000u'} connections=['d: [connection X0/d =>[signal: VPWR w=1]]', 'g: [connection X0/g =>[signal: S w=1]]', 's: [connection X0/s =>[signal: a_218_374# w=1]]', 'b: [connection X0/b =>[signal: VPB w=1]]']]
X_X_45__0 VPWR _53_/S X_45__a_218_374# VPWR sky130_fd_pr__pfet_01v8_hvt w=420000u l=150000u
** [instance X1 of sky130_fd_pr__nfet_01v8, params={'w': '420000u', 'l': '150000u'} connections=['d: [connection X1/d =>[signal: a_76_199# w=1]]', 'g: [connection X1/g =>[signal: A0 w=1]]', 's: [connection X1/s =>[signal: a_439_47# w=1]]', 'b: [connection X1/b =>[signal: VNB w=1]]']]
X_X_45__1 X_45__a_76_199# _45_/A0 X_45__a_439_47# VGND sky130_fd_pr__nfet_01v8 w=420000u l=150000u
** [instance X2 of sky130_fd_pr__pfet_01v8_hvt, params={'w': '420000u', 'l': '150000u'} connections=['d: [connection X2/d =>[signal: a_535_374# w=1]]', 'g: [connection X2/g =>[signal: a_505_21# w=1]]', 's: [connection X2/s =>[signal: VPWR w=1]]', 'b: [connection X2/b =>[signal: VPB w=1]]']]
X_X_45__2 X_45__a_535_374# X_45__a_505_21# VPWR VPWR sky130_fd_pr__pfet_01v8_hvt w=420000u l=150000u
** [instance X3 of sky130_fd_pr__pfet_01v8_hvt, params={'w': '420000u', 'l': '150000u'} connections=['d: [connection X3/d =>[signal: VPWR w=1]]', 'g: [connection X3/g =>[signal: S w=1]]', 's: [connection X3/s =>[signal: a_505_21# w=1]]', 'b: [connection X3/b =>[signal: VPB w=1]]']]
X_X_45__3 VPWR _53_/S X_45__a_505_21# VPWR sky130_fd_pr__pfet_01v8_hvt w=420000u l=150000u
** [instance X4 of sky130_fd_pr__pfet_01v8_hvt, params={'w': '420000u', 'l': '150000u'} connections=['d: [connection X4/d =>[signal: a_76_199# w=1]]', 'g: [connection X4/g =>[signal: A1 w=1]]', 's: [connection X4/s =>[signal: a_535_374# w=1]]', 'b: [connection X4/b =>[signal: VPB w=1]]']]
X_X_45__4 X_45__a_76_199# _46_/A0 X_45__a_535_374# VPWR sky130_fd_pr__pfet_01v8_hvt w=420000u l=150000u
** [instance X5 of sky130_fd_pr__nfet_01v8, params={'w': '420000u', 'l': '150000u'} connections=['d: [connection X5/d =>[signal: a_218_47# w=1]]', 'g: [connection X5/g =>[signal: A1 w=1]]', 's: [connection X5/s =>[signal: a_76_199# w=1]]', 'b: [connection X5/b =>[signal: VNB w=1]]']]
X_X_45__5 X_45__a_218_47# _46_/A0 X_45__a_76_199# VGND sky130_fd_pr__nfet_01v8 w=420000u l=150000u
** [instance X6 of sky130_fd_pr__pfet_01v8_hvt, params={'w': '420000u', 'l': '150000u'} connections=['d: [connection X6/d =>[signal: a_218_374# w=1]]', 'g: [connection X6/g =>[signal: A0 w=1]]', 's: [connection X6/s =>[signal: a_76_199# w=1]]', 'b: [connection X6/b =>[signal: VPB w=1]]']]
X_X_45__6 X_45__a_218_374# _45_/A0 X_45__a_76_199# VPWR sky130_fd_pr__pfet_01v8_hvt w=420000u l=150000u
** [instance X7 of sky130_fd_pr__nfet_01v8, params={'w': '650000u', 'l': '150000u'} connections=['d: [connection X7/d =>[signal: X w=1]]', 'g: [connection X7/g =>[signal: a_76_199# w=1]]', 's: [connection X7/s =>[signal: VGND w=1]]', 'b: [connection X7/b =>[signal: VNB w=1]]']]
X_X_45__7 _63_/D X_45__a_76_199# VGND VGND sky130_fd_pr__nfet_01v8 w=650000u l=150000u
** [instance X8 of sky130_fd_pr__pfet_01v8_hvt, params={'w': '1e+06u', 'l': '150000u'} connections=['d: [connection X8/d =>[signal: X w=1]]', 'g: [connection X8/g =>[signal: a_76_199# w=1]]', 's: [connection X8/s =>[signal: VPWR w=1]]', 'b: [connection X8/b =>[signal: VPB w=1]]']]
X_X_45__8 _63_/D X_45__a_76_199# VPWR VPWR sky130_fd_pr__pfet_01v8_hvt w=1e+06u l=150000u
** [instance X9 of sky130_fd_pr__nfet_01v8, params={'w': '420000u', 'l': '150000u'} connections=['d: [connection X9/d =>[signal: VGND w=1]]', 'g: [connection X9/g =>[signal: S w=1]]', 's: [connection X9/s =>[signal: a_218_47# w=1]]', 'b: [connection X9/b =>[signal: VNB w=1]]']]
X_X_45__9 VGND _53_/S X_45__a_218_47# VGND sky130_fd_pr__nfet_01v8 w=420000u l=150000u
** [instance X10 of sky130_fd_pr__nfet_01v8, params={'w': '420000u', 'l': '150000u'} connections=['d: [connection X10/d =>[signal: VGND w=1]]', 'g: [connection X10/g =>[signal: S w=1]]', 's: [connection X10/s =>[signal: a_505_21# w=1]]', 'b: [connection X10/b =>[signal: VNB w=1]]']]
X_X_45__10 VGND _53_/S X_45__a_505_21# VGND sky130_fd_pr__nfet_01v8 w=420000u l=150000u
** [instance X11 of sky130_fd_pr__nfet_01v8, params={'w': '420000u', 'l': '150000u'} connections=['d: [connection X11/d =>[signal: a_439_47# w=1]]', 'g: [connection X11/g =>[signal: a_505_21# w=1]]', 's: [connection X11/s =>[signal: VGND w=1]]', 'b: [connection X11/b =>[signal: VNB w=1]]']]
X_X_45__11 X_45__a_439_47# X_45__a_505_21# VGND VGND sky130_fd_pr__nfet_01v8 w=420000u l=150000u

** replacing Xhold34 with the contents of sky130_fd_sc_hd__dlygate4sd3_1
** [instance X0 of sky130_fd_pr__nfet_01v8, params={'w': '420000u', 'l': '500000u'} connections=['d: [connection X0/d =>[signal: a_391_47# w=1]]', 'g: [connection X0/g =>[signal: a_285_47# w=1]]', 's: [connection X0/s =>[signal: VGND w=1]]', 'b: [connection X0/b =>[signal: VNB w=1]]']]
X_Xhold34_0 Xhold34_a_391_47# Xhold34_a_285_47# VGND VGND sky130_fd_pr__nfet_01v8 w=420000u l=500000u
** [instance X1 of sky130_fd_pr__pfet_01v8_hvt, params={'w': '420000u', 'l': '500000u'} connections=['d: [connection X1/d =>[signal: VPWR w=1]]', 'g: [connection X1/g =>[signal: a_49_47# w=1]]', 's: [connection X1/s =>[signal: a_285_47# w=1]]', 'b: [connection X1/b =>[signal: VPB w=1]]']]
X_Xhold34_1 VPWR Xhold34_a_49_47# Xhold34_a_285_47# VPWR sky130_fd_pr__pfet_01v8_hvt w=420000u l=500000u
** [instance X2 of sky130_fd_pr__nfet_01v8, params={'w': '420000u', 'l': '150000u'} connections=['d: [connection X2/d =>[signal: a_49_47# w=1]]', 'g: [connection X2/g =>[signal: A w=1]]', 's: [connection X2/s =>[signal: VGND w=1]]', 'b: [connection X2/b =>[signal: VNB w=1]]']]
X_Xhold34_2 Xhold34_a_49_47# _52_/X VGND VGND sky130_fd_pr__nfet_01v8 w=420000u l=150000u
** [instance X3 of sky130_fd_pr__pfet_01v8_hvt, params={'w': '1e+06u', 'l': '150000u'} connections=['d: [connection X3/d =>[signal: VPWR w=1]]', 'g: [connection X3/g =>[signal: a_391_47# w=1]]', 's: [connection X3/s =>[signal: X w=1]]', 'b: [connection X3/b =>[signal: VPB w=1]]']]
X_Xhold34_3 VPWR Xhold34_a_391_47# _70_/D VPWR sky130_fd_pr__pfet_01v8_hvt w=1e+06u l=150000u
** [instance X4 of sky130_fd_pr__nfet_01v8, params={'w': '650000u', 'l': '150000u'} connections=['d: [connection X4/d =>[signal: VGND w=1]]', 'g: [connection X4/g =>[signal: a_391_47# w=1]]', 's: [connection X4/s =>[signal: X w=1]]', 'b: [connection X4/b =>[signal: VNB w=1]]']]
X_Xhold34_4 VGND Xhold34_a_391_47# _70_/D VGND sky130_fd_pr__nfet_01v8 w=650000u l=150000u
** [instance X5 of sky130_fd_pr__nfet_01v8, params={'w': '420000u', 'l': '500000u'} connections=['d: [connection X5/d =>[signal: VGND w=1]]', 'g: [connection X5/g =>[signal: a_49_47# w=1]]', 's: [connection X5/s =>[signal: a_285_47# w=1]]', 'b: [connection X5/b =>[signal: VNB w=1]]']]
X_Xhold34_5 VGND Xhold34_a_49_47# Xhold34_a_285_47# VGND sky130_fd_pr__nfet_01v8 w=420000u l=500000u
** [instance X6 of sky130_fd_pr__pfet_01v8_hvt, params={'w': '420000u', 'l': '500000u'} connections=['d: [connection X6/d =>[signal: a_391_47# w=1]]', 'g: [connection X6/g =>[signal: a_285_47# w=1]]', 's: [connection X6/s =>[signal: VPWR w=1]]', 'b: [connection X6/b =>[signal: VPB w=1]]']]
X_Xhold34_6 Xhold34_a_391_47# Xhold34_a_285_47# VPWR VPWR sky130_fd_pr__pfet_01v8_hvt w=420000u l=500000u
** [instance X7 of sky130_fd_pr__pfet_01v8_hvt, params={'w': '420000u', 'l': '150000u'} connections=['d: [connection X7/d =>[signal: a_49_47# w=1]]', 'g: [connection X7/g =>[signal: A w=1]]', 's: [connection X7/s =>[signal: VPWR w=1]]', 'b: [connection X7/b =>[signal: VPB w=1]]']]
X_Xhold34_7 Xhold34_a_49_47# _52_/X VPWR VPWR sky130_fd_pr__pfet_01v8_hvt w=420000u l=150000u

** replacing XFILLER_1_82 with the contents of sky130_fd_sc_hd__fill_1

** replacing XFILLER_6_27 with the contents of sky130_fd_sc_hd__fill_1

** replacing XFILLER_6_38 with the contents of sky130_fd_sc_hd__decap_3
** [instance X0 of sky130_fd_pr__pfet_01v8_hvt, params={'w': '870000u', 'l': '590000u'} connections=['d: [connection X0/d =>[signal: VPWR w=1]]', 'g: [connection X0/g =>[signal: VGND w=1]]', 's: [connection X0/s =>[signal: VPWR w=1]]', 'b: [connection X0/b =>[signal: VPB w=1]]']]
X_XFILLER_6_38_0 VPWR VGND VPWR VPWR sky130_fd_pr__pfet_01v8_hvt w=870000u l=590000u
** [instance X1 of sky130_fd_pr__nfet_01v8, params={'w': '550000u', 'l': '590000u'} connections=['d: [connection X1/d =>[signal: VGND w=1]]', 'g: [connection X1/g =>[signal: VPWR w=1]]', 's: [connection X1/s =>[signal: VGND w=1]]', 'b: [connection X1/b =>[signal: VNB w=1]]']]
X_XFILLER_6_38_1 VGND VPWR VGND VGND sky130_fd_pr__nfet_01v8 w=550000u l=590000u

** replacing XFILLER_12_26 with the contents of sky130_fd_sc_hd__fill_2

** replacing X_61_ with the contents of sky130_fd_sc_hd__dfxtp_2
** [instance X0 of sky130_fd_pr__pfet_01v8_hvt, params={'w': '420000u', 'l': '150000u'} connections=['d: [connection X0/d =>[signal: a_891_413# w=1]]', 'g: [connection X0/g =>[signal: a_193_47# w=1]]', 's: [connection X0/s =>[signal: a_975_413# w=1]]', 'b: [connection X0/b =>[signal: VPB w=1]]']]
X_X_61__0 X_61__a_891_413# X_61__a_193_47# X_61__a_975_413# VPWR sky130_fd_pr__pfet_01v8_hvt w=420000u l=150000u
** [instance X1 of sky130_fd_pr__nfet_01v8, params={'w': '650000u', 'l': '150000u'} connections=['d: [connection X1/d =>[signal: a_1059_315# w=1]]', 'g: [connection X1/g =>[signal: a_891_413# w=1]]', 's: [connection X1/s =>[signal: VGND w=1]]', 'b: [connection X1/b =>[signal: VNB w=1]]']]
X_X_61__1 X_61__a_1059_315# X_61__a_891_413# VGND VGND sky130_fd_pr__nfet_01v8 w=650000u l=150000u
** [instance X2 of sky130_fd_pr__pfet_01v8_hvt, params={'w': '420000u', 'l': '150000u'} connections=['d: [connection X2/d =>[signal: a_466_413# w=1]]', 'g: [connection X2/g =>[signal: a_27_47# w=1]]', 's: [connection X2/s =>[signal: a_561_413# w=1]]', 'b: [connection X2/b =>[signal: VPB w=1]]']]
X_X_61__2 X_61__a_466_413# X_61__a_27_47# X_61__a_561_413# VPWR sky130_fd_pr__pfet_01v8_hvt w=420000u l=150000u
** [instance X3 of sky130_fd_pr__pfet_01v8_hvt, params={'w': '420000u', 'l': '150000u'} connections=['d: [connection X3/d =>[signal: a_634_159# w=1]]', 'g: [connection X3/g =>[signal: a_27_47# w=1]]', 's: [connection X3/s =>[signal: a_891_413# w=1]]', 'b: [connection X3/b =>[signal: VPB w=1]]']]
X_X_61__3 X_61__a_634_159# X_61__a_27_47# X_61__a_891_413# VPWR sky130_fd_pr__pfet_01v8_hvt w=420000u l=150000u
** [instance X4 of sky130_fd_pr__pfet_01v8_hvt, params={'w': '420000u', 'l': '150000u'} connections=['d: [connection X4/d =>[signal: a_381_47# w=1]]', 'g: [connection X4/g =>[signal: a_193_47# w=1]]', 's: [connection X4/s =>[signal: a_466_413# w=1]]', 'b: [connection X4/b =>[signal: VPB w=1]]']]
X_X_61__4 X_61__a_381_47# X_61__a_193_47# X_61__a_466_413# VPWR sky130_fd_pr__pfet_01v8_hvt w=420000u l=150000u
** [instance X5 of sky130_fd_pr__pfet_01v8_hvt, params={'w': '420000u', 'l': '150000u'} connections=['d: [connection X5/d =>[signal: VPWR w=1]]', 'g: [connection X5/g =>[signal: D w=1]]', 's: [connection X5/s =>[signal: a_381_47# w=1]]', 'b: [connection X5/b =>[signal: VPB w=1]]']]
X_X_61__5 VPWR _61_/D X_61__a_381_47# VPWR sky130_fd_pr__pfet_01v8_hvt w=420000u l=150000u
** [instance X6 of sky130_fd_pr__pfet_01v8_hvt, params={'w': '750000u', 'l': '150000u'} connections=['d: [connection X6/d =>[signal: VPWR w=1]]', 'g: [connection X6/g =>[signal: a_466_413# w=1]]', 's: [connection X6/s =>[signal: a_634_159# w=1]]', 'b: [connection X6/b =>[signal: VPB w=1]]']]
X_X_61__6 VPWR X_61__a_466_413# X_61__a_634_159# VPWR sky130_fd_pr__pfet_01v8_hvt w=750000u l=150000u
** [instance X7 of sky130_fd_pr__nfet_01v8, params={'w': '640000u', 'l': '150000u'} connections=['d: [connection X7/d =>[signal: VGND w=1]]', 'g: [connection X7/g =>[signal: a_466_413# w=1]]', 's: [connection X7/s =>[signal: a_634_159# w=1]]', 'b: [connection X7/b =>[signal: VNB w=1]]']]
X_X_61__7 VGND X_61__a_466_413# X_61__a_634_159# VGND sky130_fd_pr__nfet_01v8 w=640000u l=150000u
** [instance X8 of sky130_fd_pr__nfet_01v8, params={'w': '420000u', 'l': '150000u'} connections=['d: [connection X8/d =>[signal: a_1017_47# w=1]]', 'g: [connection X8/g =>[signal: a_1059_315# w=1]]', 's: [connection X8/s =>[signal: VGND w=1]]', 'b: [connection X8/b =>[signal: VNB w=1]]']]
X_X_61__8 X_61__a_1017_47# X_61__a_1059_315# VGND VGND sky130_fd_pr__nfet_01v8 w=420000u l=150000u
** [instance X9 of sky130_fd_pr__pfet_01v8_hvt, params={'w': '1e+06u', 'l': '150000u'} connections=['d: [connection X9/d =>[signal: a_1059_315# w=1]]', 'g: [connection X9/g =>[signal: a_891_413# w=1]]', 's: [connection X9/s =>[signal: VPWR w=1]]', 'b: [connection X9/b =>[signal: VPB w=1]]']]
X_X_61__9 X_61__a_1059_315# X_61__a_891_413# VPWR VPWR sky130_fd_pr__pfet_01v8_hvt w=1e+06u l=150000u
** [instance X10 of sky130_fd_pr__pfet_01v8_hvt, params={'w': '1e+06u', 'l': '150000u'} connections=['d: [connection X10/d =>[signal: Q w=1]]', 'g: [connection X10/g =>[signal: a_1059_315# w=1]]', 's: [connection X10/s =>[signal: VPWR w=1]]', 'b: [connection X10/b =>[signal: VPB w=1]]']]
X_X_61__10 _61_/Q X_61__a_1059_315# VPWR VPWR sky130_fd_pr__pfet_01v8_hvt w=1e+06u l=150000u
** [instance X11 of sky130_fd_pr__pfet_01v8_hvt, params={'w': '420000u', 'l': '150000u'} connections=['d: [connection X11/d =>[signal: a_561_413# w=1]]', 'g: [connection X11/g =>[signal: a_634_159# w=1]]', 's: [connection X11/s =>[signal: VPWR w=1]]', 'b: [connection X11/b =>[signal: VPB w=1]]']]
X_X_61__11 X_61__a_561_413# X_61__a_634_159# VPWR VPWR sky130_fd_pr__pfet_01v8_hvt w=420000u l=150000u
** [instance X12 of sky130_fd_pr__pfet_01v8_hvt, params={'w': '1e+06u', 'l': '150000u'} connections=['d: [connection X12/d =>[signal: VPWR w=1]]', 'g: [connection X12/g =>[signal: a_1059_315# w=1]]', 's: [connection X12/s =>[signal: Q w=1]]', 'b: [connection X12/b =>[signal: VPB w=1]]']]
X_X_61__12 VPWR X_61__a_1059_315# _61_/Q VPWR sky130_fd_pr__pfet_01v8_hvt w=1e+06u l=150000u
** [instance X13 of sky130_fd_pr__nfet_01v8, params={'w': '360000u', 'l': '150000u'} connections=['d: [connection X13/d =>[signal: a_891_413# w=1]]', 'g: [connection X13/g =>[signal: a_27_47# w=1]]', 's: [connection X13/s =>[signal: a_1017_47# w=1]]', 'b: [connection X13/b =>[signal: VNB w=1]]']]
X_X_61__13 X_61__a_891_413# X_61__a_27_47# X_61__a_1017_47# VGND sky130_fd_pr__nfet_01v8 w=360000u l=150000u
** [instance X14 of sky130_fd_pr__nfet_01v8, params={'w': '360000u', 'l': '150000u'} connections=['d: [connection X14/d =>[signal: a_634_159# w=1]]', 'g: [connection X14/g =>[signal: a_193_47# w=1]]', 's: [connection X14/s =>[signal: a_891_413# w=1]]', 'b: [connection X14/b =>[signal: VNB w=1]]']]
X_X_61__14 X_61__a_634_159# X_61__a_193_47# X_61__a_891_413# VGND sky130_fd_pr__nfet_01v8 w=360000u l=150000u
** [instance X15 of sky130_fd_pr__nfet_01v8, params={'w': '420000u', 'l': '150000u'} connections=['d: [connection X15/d =>[signal: a_592_47# w=1]]', 'g: [connection X15/g =>[signal: a_634_159# w=1]]', 's: [connection X15/s =>[signal: VGND w=1]]', 'b: [connection X15/b =>[signal: VNB w=1]]']]
X_X_61__15 X_61__a_592_47# X_61__a_634_159# VGND VGND sky130_fd_pr__nfet_01v8 w=420000u l=150000u
** [instance X16 of sky130_fd_pr__nfet_01v8, params={'w': '360000u', 'l': '150000u'} connections=['d: [connection X16/d =>[signal: a_466_413# w=1]]', 'g: [connection X16/g =>[signal: a_193_47# w=1]]', 's: [connection X16/s =>[signal: a_592_47# w=1]]', 'b: [connection X16/b =>[signal: VNB w=1]]']]
X_X_61__16 X_61__a_466_413# X_61__a_193_47# X_61__a_592_47# VGND sky130_fd_pr__nfet_01v8 w=360000u l=150000u
** [instance X17 of sky130_fd_pr__nfet_01v8, params={'w': '420000u', 'l': '150000u'} connections=['d: [connection X17/d =>[signal: VGND w=1]]', 'g: [connection X17/g =>[signal: a_27_47# w=1]]', 's: [connection X17/s =>[signal: a_193_47# w=1]]', 'b: [connection X17/b =>[signal: VNB w=1]]']]
X_X_61__17 VGND X_61__a_27_47# X_61__a_193_47# VGND sky130_fd_pr__nfet_01v8 w=420000u l=150000u
** [instance X18 of sky130_fd_pr__nfet_01v8, params={'w': '360000u', 'l': '150000u'} connections=['d: [connection X18/d =>[signal: a_381_47# w=1]]', 'g: [connection X18/g =>[signal: a_27_47# w=1]]', 's: [connection X18/s =>[signal: a_466_413# w=1]]', 'b: [connection X18/b =>[signal: VNB w=1]]']]
X_X_61__18 X_61__a_381_47# X_61__a_27_47# X_61__a_466_413# VGND sky130_fd_pr__nfet_01v8 w=360000u l=150000u
** [instance X19 of sky130_fd_pr__nfet_01v8, params={'w': '420000u', 'l': '150000u'} connections=['d: [connection X19/d =>[signal: a_27_47# w=1]]', 'g: [connection X19/g =>[signal: CLK w=1]]', 's: [connection X19/s =>[signal: VGND w=1]]', 'b: [connection X19/b =>[signal: VNB w=1]]']]
X_X_61__19 X_61__a_27_47# _76_/CLK VGND VGND sky130_fd_pr__nfet_01v8 w=420000u l=150000u
** [instance X20 of sky130_fd_pr__pfet_01v8_hvt, params={'w': '640000u', 'l': '150000u'} connections=['d: [connection X20/d =>[signal: a_27_47# w=1]]', 'g: [connection X20/g =>[signal: CLK w=1]]', 's: [connection X20/s =>[signal: VPWR w=1]]', 'b: [connection X20/b =>[signal: VPB w=1]]']]
X_X_61__20 X_61__a_27_47# _76_/CLK VPWR VPWR sky130_fd_pr__pfet_01v8_hvt w=640000u l=150000u
** [instance X21 of sky130_fd_pr__nfet_01v8, params={'w': '650000u', 'l': '150000u'} connections=['d: [connection X21/d =>[signal: Q w=1]]', 'g: [connection X21/g =>[signal: a_1059_315# w=1]]', 's: [connection X21/s =>[signal: VGND w=1]]', 'b: [connection X21/b =>[signal: VNB w=1]]']]
X_X_61__21 _61_/Q X_61__a_1059_315# VGND VGND sky130_fd_pr__nfet_01v8 w=650000u l=150000u
** [instance X22 of sky130_fd_pr__pfet_01v8_hvt, params={'w': '640000u', 'l': '150000u'} connections=['d: [connection X22/d =>[signal: VPWR w=1]]', 'g: [connection X22/g =>[signal: a_27_47# w=1]]', 's: [connection X22/s =>[signal: a_193_47# w=1]]', 'b: [connection X22/b =>[signal: VPB w=1]]']]
X_X_61__22 VPWR X_61__a_27_47# X_61__a_193_47# VPWR sky130_fd_pr__pfet_01v8_hvt w=640000u l=150000u
** [instance X23 of sky130_fd_pr__nfet_01v8, params={'w': '420000u', 'l': '150000u'} connections=['d: [connection X23/d =>[signal: VGND w=1]]', 'g: [connection X23/g =>[signal: D w=1]]', 's: [connection X23/s =>[signal: a_381_47# w=1]]', 'b: [connection X23/b =>[signal: VNB w=1]]']]
X_X_61__23 VGND _61_/D X_61__a_381_47# VGND sky130_fd_pr__nfet_01v8 w=420000u l=150000u
** [instance X24 of sky130_fd_pr__pfet_01v8_hvt, params={'w': '420000u', 'l': '150000u'} connections=['d: [connection X24/d =>[signal: a_975_413# w=1]]', 'g: [connection X24/g =>[signal: a_1059_315# w=1]]', 's: [connection X24/s =>[signal: VPWR w=1]]', 'b: [connection X24/b =>[signal: VPB w=1]]']]
X_X_61__24 X_61__a_975_413# X_61__a_1059_315# VPWR VPWR sky130_fd_pr__pfet_01v8_hvt w=420000u l=150000u
** [instance X25 of sky130_fd_pr__nfet_01v8, params={'w': '650000u', 'l': '150000u'} connections=['d: [connection X25/d =>[signal: VGND w=1]]', 'g: [connection X25/g =>[signal: a_1059_315# w=1]]', 's: [connection X25/s =>[signal: Q w=1]]', 'b: [connection X25/b =>[signal: VNB w=1]]']]
X_X_61__25 VGND X_61__a_1059_315# _61_/Q VGND sky130_fd_pr__nfet_01v8 w=650000u l=150000u

** replacing XFILLER_3_6 with the contents of sky130_fd_sc_hd__fill_2

** replacing XPHY_EDGE_ROW_4_Left_18 with the contents of sky130_fd_sc_hd__decap_3
** [instance X0 of sky130_fd_pr__pfet_01v8_hvt, params={'w': '870000u', 'l': '590000u'} connections=['d: [connection X0/d =>[signal: VPWR w=1]]', 'g: [connection X0/g =>[signal: VGND w=1]]', 's: [connection X0/s =>[signal: VPWR w=1]]', 'b: [connection X0/b =>[signal: VPB w=1]]']]
X_XPHY_EDGE_ROW_4_Left_18_0 VPWR VGND VPWR VPWR sky130_fd_pr__pfet_01v8_hvt w=870000u l=590000u
** [instance X1 of sky130_fd_pr__nfet_01v8, params={'w': '550000u', 'l': '590000u'} connections=['d: [connection X1/d =>[signal: VGND w=1]]', 'g: [connection X1/g =>[signal: VPWR w=1]]', 's: [connection X1/s =>[signal: VGND w=1]]', 'b: [connection X1/b =>[signal: VNB w=1]]']]
X_XPHY_EDGE_ROW_4_Left_18_1 VGND VPWR VGND VGND sky130_fd_pr__nfet_01v8 w=550000u l=590000u

** replacing X_44_ with the contents of sky130_fd_sc_hd__mux2_1
** [instance X0 of sky130_fd_pr__pfet_01v8_hvt, params={'w': '420000u', 'l': '150000u'} connections=['d: [connection X0/d =>[signal: VPWR w=1]]', 'g: [connection X0/g =>[signal: S w=1]]', 's: [connection X0/s =>[signal: a_218_374# w=1]]', 'b: [connection X0/b =>[signal: VPB w=1]]']]
X_X_44__0 VPWR _53_/S X_44__a_218_374# VPWR sky130_fd_pr__pfet_01v8_hvt w=420000u l=150000u
** [instance X1 of sky130_fd_pr__nfet_01v8, params={'w': '420000u', 'l': '150000u'} connections=['d: [connection X1/d =>[signal: a_76_199# w=1]]', 'g: [connection X1/g =>[signal: A0 w=1]]', 's: [connection X1/s =>[signal: a_439_47# w=1]]', 'b: [connection X1/b =>[signal: VNB w=1]]']]
X_X_44__1 X_44__a_76_199# _44_/A0 X_44__a_439_47# VGND sky130_fd_pr__nfet_01v8 w=420000u l=150000u
** [instance X2 of sky130_fd_pr__pfet_01v8_hvt, params={'w': '420000u', 'l': '150000u'} connections=['d: [connection X2/d =>[signal: a_535_374# w=1]]', 'g: [connection X2/g =>[signal: a_505_21# w=1]]', 's: [connection X2/s =>[signal: VPWR w=1]]', 'b: [connection X2/b =>[signal: VPB w=1]]']]
X_X_44__2 X_44__a_535_374# X_44__a_505_21# VPWR VPWR sky130_fd_pr__pfet_01v8_hvt w=420000u l=150000u
** [instance X3 of sky130_fd_pr__pfet_01v8_hvt, params={'w': '420000u', 'l': '150000u'} connections=['d: [connection X3/d =>[signal: VPWR w=1]]', 'g: [connection X3/g =>[signal: S w=1]]', 's: [connection X3/s =>[signal: a_505_21# w=1]]', 'b: [connection X3/b =>[signal: VPB w=1]]']]
X_X_44__3 VPWR _53_/S X_44__a_505_21# VPWR sky130_fd_pr__pfet_01v8_hvt w=420000u l=150000u
** [instance X4 of sky130_fd_pr__pfet_01v8_hvt, params={'w': '420000u', 'l': '150000u'} connections=['d: [connection X4/d =>[signal: a_76_199# w=1]]', 'g: [connection X4/g =>[signal: A1 w=1]]', 's: [connection X4/s =>[signal: a_535_374# w=1]]', 'b: [connection X4/b =>[signal: VPB w=1]]']]
X_X_44__4 X_44__a_76_199# _45_/A0 X_44__a_535_374# VPWR sky130_fd_pr__pfet_01v8_hvt w=420000u l=150000u
** [instance X5 of sky130_fd_pr__nfet_01v8, params={'w': '420000u', 'l': '150000u'} connections=['d: [connection X5/d =>[signal: a_218_47# w=1]]', 'g: [connection X5/g =>[signal: A1 w=1]]', 's: [connection X5/s =>[signal: a_76_199# w=1]]', 'b: [connection X5/b =>[signal: VNB w=1]]']]
X_X_44__5 X_44__a_218_47# _45_/A0 X_44__a_76_199# VGND sky130_fd_pr__nfet_01v8 w=420000u l=150000u
** [instance X6 of sky130_fd_pr__pfet_01v8_hvt, params={'w': '420000u', 'l': '150000u'} connections=['d: [connection X6/d =>[signal: a_218_374# w=1]]', 'g: [connection X6/g =>[signal: A0 w=1]]', 's: [connection X6/s =>[signal: a_76_199# w=1]]', 'b: [connection X6/b =>[signal: VPB w=1]]']]
X_X_44__6 X_44__a_218_374# _44_/A0 X_44__a_76_199# VPWR sky130_fd_pr__pfet_01v8_hvt w=420000u l=150000u
** [instance X7 of sky130_fd_pr__nfet_01v8, params={'w': '650000u', 'l': '150000u'} connections=['d: [connection X7/d =>[signal: X w=1]]', 'g: [connection X7/g =>[signal: a_76_199# w=1]]', 's: [connection X7/s =>[signal: VGND w=1]]', 'b: [connection X7/b =>[signal: VNB w=1]]']]
X_X_44__7 _62_/D X_44__a_76_199# VGND VGND sky130_fd_pr__nfet_01v8 w=650000u l=150000u
** [instance X8 of sky130_fd_pr__pfet_01v8_hvt, params={'w': '1e+06u', 'l': '150000u'} connections=['d: [connection X8/d =>[signal: X w=1]]', 'g: [connection X8/g =>[signal: a_76_199# w=1]]', 's: [connection X8/s =>[signal: VPWR w=1]]', 'b: [connection X8/b =>[signal: VPB w=1]]']]
X_X_44__8 _62_/D X_44__a_76_199# VPWR VPWR sky130_fd_pr__pfet_01v8_hvt w=1e+06u l=150000u
** [instance X9 of sky130_fd_pr__nfet_01v8, params={'w': '420000u', 'l': '150000u'} connections=['d: [connection X9/d =>[signal: VGND w=1]]', 'g: [connection X9/g =>[signal: S w=1]]', 's: [connection X9/s =>[signal: a_218_47# w=1]]', 'b: [connection X9/b =>[signal: VNB w=1]]']]
X_X_44__9 VGND _53_/S X_44__a_218_47# VGND sky130_fd_pr__nfet_01v8 w=420000u l=150000u
** [instance X10 of sky130_fd_pr__nfet_01v8, params={'w': '420000u', 'l': '150000u'} connections=['d: [connection X10/d =>[signal: VGND w=1]]', 'g: [connection X10/g =>[signal: S w=1]]', 's: [connection X10/s =>[signal: a_505_21# w=1]]', 'b: [connection X10/b =>[signal: VNB w=1]]']]
X_X_44__10 VGND _53_/S X_44__a_505_21# VGND sky130_fd_pr__nfet_01v8 w=420000u l=150000u
** [instance X11 of sky130_fd_pr__nfet_01v8, params={'w': '420000u', 'l': '150000u'} connections=['d: [connection X11/d =>[signal: a_439_47# w=1]]', 'g: [connection X11/g =>[signal: a_505_21# w=1]]', 's: [connection X11/s =>[signal: VGND w=1]]', 'b: [connection X11/b =>[signal: VNB w=1]]']]
X_X_44__11 X_44__a_439_47# X_44__a_505_21# VGND VGND sky130_fd_pr__nfet_01v8 w=420000u l=150000u

** replacing Xhold35 with the contents of sky130_fd_sc_hd__dlygate4sd3_1
** [instance X0 of sky130_fd_pr__nfet_01v8, params={'w': '420000u', 'l': '500000u'} connections=['d: [connection X0/d =>[signal: a_391_47# w=1]]', 'g: [connection X0/g =>[signal: a_285_47# w=1]]', 's: [connection X0/s =>[signal: VGND w=1]]', 'b: [connection X0/b =>[signal: VNB w=1]]']]
X_Xhold35_0 Xhold35_a_391_47# Xhold35_a_285_47# VGND VGND sky130_fd_pr__nfet_01v8 w=420000u l=500000u
** [instance X1 of sky130_fd_pr__pfet_01v8_hvt, params={'w': '420000u', 'l': '500000u'} connections=['d: [connection X1/d =>[signal: VPWR w=1]]', 'g: [connection X1/g =>[signal: a_49_47# w=1]]', 's: [connection X1/s =>[signal: a_285_47# w=1]]', 'b: [connection X1/b =>[signal: VPB w=1]]']]
X_Xhold35_1 VPWR Xhold35_a_49_47# Xhold35_a_285_47# VPWR sky130_fd_pr__pfet_01v8_hvt w=420000u l=500000u
** [instance X2 of sky130_fd_pr__nfet_01v8, params={'w': '420000u', 'l': '150000u'} connections=['d: [connection X2/d =>[signal: a_49_47# w=1]]', 'g: [connection X2/g =>[signal: A w=1]]', 's: [connection X2/s =>[signal: VGND w=1]]', 'b: [connection X2/b =>[signal: VNB w=1]]']]
X_Xhold35_2 Xhold35_a_49_47# _69_/Q VGND VGND sky130_fd_pr__nfet_01v8 w=420000u l=150000u
** [instance X3 of sky130_fd_pr__pfet_01v8_hvt, params={'w': '1e+06u', 'l': '150000u'} connections=['d: [connection X3/d =>[signal: VPWR w=1]]', 'g: [connection X3/g =>[signal: a_391_47# w=1]]', 's: [connection X3/s =>[signal: X w=1]]', 'b: [connection X3/b =>[signal: VPB w=1]]']]
X_Xhold35_3 VPWR Xhold35_a_391_47# _51_/A0 VPWR sky130_fd_pr__pfet_01v8_hvt w=1e+06u l=150000u
** [instance X4 of sky130_fd_pr__nfet_01v8, params={'w': '650000u', 'l': '150000u'} connections=['d: [connection X4/d =>[signal: VGND w=1]]', 'g: [connection X4/g =>[signal: a_391_47# w=1]]', 's: [connection X4/s =>[signal: X w=1]]', 'b: [connection X4/b =>[signal: VNB w=1]]']]
X_Xhold35_4 VGND Xhold35_a_391_47# _51_/A0 VGND sky130_fd_pr__nfet_01v8 w=650000u l=150000u
** [instance X5 of sky130_fd_pr__nfet_01v8, params={'w': '420000u', 'l': '500000u'} connections=['d: [connection X5/d =>[signal: VGND w=1]]', 'g: [connection X5/g =>[signal: a_49_47# w=1]]', 's: [connection X5/s =>[signal: a_285_47# w=1]]', 'b: [connection X5/b =>[signal: VNB w=1]]']]
X_Xhold35_5 VGND Xhold35_a_49_47# Xhold35_a_285_47# VGND sky130_fd_pr__nfet_01v8 w=420000u l=500000u
** [instance X6 of sky130_fd_pr__pfet_01v8_hvt, params={'w': '420000u', 'l': '500000u'} connections=['d: [connection X6/d =>[signal: a_391_47# w=1]]', 'g: [connection X6/g =>[signal: a_285_47# w=1]]', 's: [connection X6/s =>[signal: VPWR w=1]]', 'b: [connection X6/b =>[signal: VPB w=1]]']]
X_Xhold35_6 Xhold35_a_391_47# Xhold35_a_285_47# VPWR VPWR sky130_fd_pr__pfet_01v8_hvt w=420000u l=500000u
** [instance X7 of sky130_fd_pr__pfet_01v8_hvt, params={'w': '420000u', 'l': '150000u'} connections=['d: [connection X7/d =>[signal: a_49_47# w=1]]', 'g: [connection X7/g =>[signal: A w=1]]', 's: [connection X7/s =>[signal: VPWR w=1]]', 'b: [connection X7/b =>[signal: VPB w=1]]']]
X_Xhold35_7 Xhold35_a_49_47# _69_/Q VPWR VPWR sky130_fd_pr__pfet_01v8_hvt w=420000u l=150000u

** replacing Xhold24 with the contents of sky130_fd_sc_hd__dlygate4sd3_1
** [instance X0 of sky130_fd_pr__nfet_01v8, params={'w': '420000u', 'l': '500000u'} connections=['d: [connection X0/d =>[signal: a_391_47# w=1]]', 'g: [connection X0/g =>[signal: a_285_47# w=1]]', 's: [connection X0/s =>[signal: VGND w=1]]', 'b: [connection X0/b =>[signal: VNB w=1]]']]
X_Xhold24_0 Xhold24_a_391_47# Xhold24_a_285_47# VGND VGND sky130_fd_pr__nfet_01v8 w=420000u l=500000u
** [instance X1 of sky130_fd_pr__pfet_01v8_hvt, params={'w': '420000u', 'l': '500000u'} connections=['d: [connection X1/d =>[signal: VPWR w=1]]', 'g: [connection X1/g =>[signal: a_49_47# w=1]]', 's: [connection X1/s =>[signal: a_285_47# w=1]]', 'b: [connection X1/b =>[signal: VPB w=1]]']]
X_Xhold24_1 VPWR Xhold24_a_49_47# Xhold24_a_285_47# VPWR sky130_fd_pr__pfet_01v8_hvt w=420000u l=500000u
** [instance X2 of sky130_fd_pr__nfet_01v8, params={'w': '420000u', 'l': '150000u'} connections=['d: [connection X2/d =>[signal: a_49_47# w=1]]', 'g: [connection X2/g =>[signal: A w=1]]', 's: [connection X2/s =>[signal: VGND w=1]]', 'b: [connection X2/b =>[signal: VNB w=1]]']]
X_Xhold24_2 Xhold24_a_49_47# _75_/Q VGND VGND sky130_fd_pr__nfet_01v8 w=420000u l=150000u
** [instance X3 of sky130_fd_pr__pfet_01v8_hvt, params={'w': '1e+06u', 'l': '150000u'} connections=['d: [connection X3/d =>[signal: VPWR w=1]]', 'g: [connection X3/g =>[signal: a_391_47# w=1]]', 's: [connection X3/s =>[signal: X w=1]]', 'b: [connection X3/b =>[signal: VPB w=1]]']]
X_Xhold24_3 VPWR Xhold24_a_391_47# _57_/A0 VPWR sky130_fd_pr__pfet_01v8_hvt w=1e+06u l=150000u
** [instance X4 of sky130_fd_pr__nfet_01v8, params={'w': '650000u', 'l': '150000u'} connections=['d: [connection X4/d =>[signal: VGND w=1]]', 'g: [connection X4/g =>[signal: a_391_47# w=1]]', 's: [connection X4/s =>[signal: X w=1]]', 'b: [connection X4/b =>[signal: VNB w=1]]']]
X_Xhold24_4 VGND Xhold24_a_391_47# _57_/A0 VGND sky130_fd_pr__nfet_01v8 w=650000u l=150000u
** [instance X5 of sky130_fd_pr__nfet_01v8, params={'w': '420000u', 'l': '500000u'} connections=['d: [connection X5/d =>[signal: VGND w=1]]', 'g: [connection X5/g =>[signal: a_49_47# w=1]]', 's: [connection X5/s =>[signal: a_285_47# w=1]]', 'b: [connection X5/b =>[signal: VNB w=1]]']]
X_Xhold24_5 VGND Xhold24_a_49_47# Xhold24_a_285_47# VGND sky130_fd_pr__nfet_01v8 w=420000u l=500000u
** [instance X6 of sky130_fd_pr__pfet_01v8_hvt, params={'w': '420000u', 'l': '500000u'} connections=['d: [connection X6/d =>[signal: a_391_47# w=1]]', 'g: [connection X6/g =>[signal: a_285_47# w=1]]', 's: [connection X6/s =>[signal: VPWR w=1]]', 'b: [connection X6/b =>[signal: VPB w=1]]']]
X_Xhold24_6 Xhold24_a_391_47# Xhold24_a_285_47# VPWR VPWR sky130_fd_pr__pfet_01v8_hvt w=420000u l=500000u
** [instance X7 of sky130_fd_pr__pfet_01v8_hvt, params={'w': '420000u', 'l': '150000u'} connections=['d: [connection X7/d =>[signal: a_49_47# w=1]]', 'g: [connection X7/g =>[signal: A w=1]]', 's: [connection X7/s =>[signal: VPWR w=1]]', 'b: [connection X7/b =>[signal: VPB w=1]]']]
X_Xhold24_7 Xhold24_a_49_47# _75_/Q VPWR VPWR sky130_fd_pr__pfet_01v8_hvt w=420000u l=150000u

** replacing XPHY_EDGE_ROW_7_Left_21 with the contents of sky130_fd_sc_hd__decap_3
** [instance X0 of sky130_fd_pr__pfet_01v8_hvt, params={'w': '870000u', 'l': '590000u'} connections=['d: [connection X0/d =>[signal: VPWR w=1]]', 'g: [connection X0/g =>[signal: VGND w=1]]', 's: [connection X0/s =>[signal: VPWR w=1]]', 'b: [connection X0/b =>[signal: VPB w=1]]']]
X_XPHY_EDGE_ROW_7_Left_21_0 VPWR VGND VPWR VPWR sky130_fd_pr__pfet_01v8_hvt w=870000u l=590000u
** [instance X1 of sky130_fd_pr__nfet_01v8, params={'w': '550000u', 'l': '590000u'} connections=['d: [connection X1/d =>[signal: VGND w=1]]', 'g: [connection X1/g =>[signal: VPWR w=1]]', 's: [connection X1/s =>[signal: VGND w=1]]', 'b: [connection X1/b =>[signal: VNB w=1]]']]
X_XPHY_EDGE_ROW_7_Left_21_1 VGND VPWR VGND VGND sky130_fd_pr__nfet_01v8 w=550000u l=590000u

** replacing XFILLER_7_60 with the contents of sky130_fd_sc_hd__decap_3
** [instance X0 of sky130_fd_pr__pfet_01v8_hvt, params={'w': '870000u', 'l': '590000u'} connections=['d: [connection X0/d =>[signal: VPWR w=1]]', 'g: [connection X0/g =>[signal: VGND w=1]]', 's: [connection X0/s =>[signal: VPWR w=1]]', 'b: [connection X0/b =>[signal: VPB w=1]]']]
X_XFILLER_7_60_0 VPWR VGND VPWR VPWR sky130_fd_pr__pfet_01v8_hvt w=870000u l=590000u
** [instance X1 of sky130_fd_pr__nfet_01v8, params={'w': '550000u', 'l': '590000u'} connections=['d: [connection X1/d =>[signal: VGND w=1]]', 'g: [connection X1/g =>[signal: VPWR w=1]]', 's: [connection X1/s =>[signal: VGND w=1]]', 'b: [connection X1/b =>[signal: VNB w=1]]']]
X_XFILLER_7_60_1 VGND VPWR VGND VGND sky130_fd_pr__nfet_01v8 w=550000u l=590000u

** replacing X_60_ with the contents of sky130_fd_sc_hd__dfxtp_2
** [instance X0 of sky130_fd_pr__pfet_01v8_hvt, params={'w': '420000u', 'l': '150000u'} connections=['d: [connection X0/d =>[signal: a_891_413# w=1]]', 'g: [connection X0/g =>[signal: a_193_47# w=1]]', 's: [connection X0/s =>[signal: a_975_413# w=1]]', 'b: [connection X0/b =>[signal: VPB w=1]]']]
X_X_60__0 X_60__a_891_413# X_60__a_193_47# X_60__a_975_413# VPWR sky130_fd_pr__pfet_01v8_hvt w=420000u l=150000u
** [instance X1 of sky130_fd_pr__nfet_01v8, params={'w': '650000u', 'l': '150000u'} connections=['d: [connection X1/d =>[signal: a_1059_315# w=1]]', 'g: [connection X1/g =>[signal: a_891_413# w=1]]', 's: [connection X1/s =>[signal: VGND w=1]]', 'b: [connection X1/b =>[signal: VNB w=1]]']]
X_X_60__1 X_60__a_1059_315# X_60__a_891_413# VGND VGND sky130_fd_pr__nfet_01v8 w=650000u l=150000u
** [instance X2 of sky130_fd_pr__pfet_01v8_hvt, params={'w': '420000u', 'l': '150000u'} connections=['d: [connection X2/d =>[signal: a_466_413# w=1]]', 'g: [connection X2/g =>[signal: a_27_47# w=1]]', 's: [connection X2/s =>[signal: a_561_413# w=1]]', 'b: [connection X2/b =>[signal: VPB w=1]]']]
X_X_60__2 X_60__a_466_413# X_60__a_27_47# X_60__a_561_413# VPWR sky130_fd_pr__pfet_01v8_hvt w=420000u l=150000u
** [instance X3 of sky130_fd_pr__pfet_01v8_hvt, params={'w': '420000u', 'l': '150000u'} connections=['d: [connection X3/d =>[signal: a_634_159# w=1]]', 'g: [connection X3/g =>[signal: a_27_47# w=1]]', 's: [connection X3/s =>[signal: a_891_413# w=1]]', 'b: [connection X3/b =>[signal: VPB w=1]]']]
X_X_60__3 X_60__a_634_159# X_60__a_27_47# X_60__a_891_413# VPWR sky130_fd_pr__pfet_01v8_hvt w=420000u l=150000u
** [instance X4 of sky130_fd_pr__pfet_01v8_hvt, params={'w': '420000u', 'l': '150000u'} connections=['d: [connection X4/d =>[signal: a_381_47# w=1]]', 'g: [connection X4/g =>[signal: a_193_47# w=1]]', 's: [connection X4/s =>[signal: a_466_413# w=1]]', 'b: [connection X4/b =>[signal: VPB w=1]]']]
X_X_60__4 X_60__a_381_47# X_60__a_193_47# X_60__a_466_413# VPWR sky130_fd_pr__pfet_01v8_hvt w=420000u l=150000u
** [instance X5 of sky130_fd_pr__pfet_01v8_hvt, params={'w': '420000u', 'l': '150000u'} connections=['d: [connection X5/d =>[signal: VPWR w=1]]', 'g: [connection X5/g =>[signal: D w=1]]', 's: [connection X5/s =>[signal: a_381_47# w=1]]', 'b: [connection X5/b =>[signal: VPB w=1]]']]
X_X_60__5 VPWR _60_/D X_60__a_381_47# VPWR sky130_fd_pr__pfet_01v8_hvt w=420000u l=150000u
** [instance X6 of sky130_fd_pr__pfet_01v8_hvt, params={'w': '750000u', 'l': '150000u'} connections=['d: [connection X6/d =>[signal: VPWR w=1]]', 'g: [connection X6/g =>[signal: a_466_413# w=1]]', 's: [connection X6/s =>[signal: a_634_159# w=1]]', 'b: [connection X6/b =>[signal: VPB w=1]]']]
X_X_60__6 VPWR X_60__a_466_413# X_60__a_634_159# VPWR sky130_fd_pr__pfet_01v8_hvt w=750000u l=150000u
** [instance X7 of sky130_fd_pr__nfet_01v8, params={'w': '640000u', 'l': '150000u'} connections=['d: [connection X7/d =>[signal: VGND w=1]]', 'g: [connection X7/g =>[signal: a_466_413# w=1]]', 's: [connection X7/s =>[signal: a_634_159# w=1]]', 'b: [connection X7/b =>[signal: VNB w=1]]']]
X_X_60__7 VGND X_60__a_466_413# X_60__a_634_159# VGND sky130_fd_pr__nfet_01v8 w=640000u l=150000u
** [instance X8 of sky130_fd_pr__nfet_01v8, params={'w': '420000u', 'l': '150000u'} connections=['d: [connection X8/d =>[signal: a_1017_47# w=1]]', 'g: [connection X8/g =>[signal: a_1059_315# w=1]]', 's: [connection X8/s =>[signal: VGND w=1]]', 'b: [connection X8/b =>[signal: VNB w=1]]']]
X_X_60__8 X_60__a_1017_47# X_60__a_1059_315# VGND VGND sky130_fd_pr__nfet_01v8 w=420000u l=150000u
** [instance X9 of sky130_fd_pr__pfet_01v8_hvt, params={'w': '1e+06u', 'l': '150000u'} connections=['d: [connection X9/d =>[signal: a_1059_315# w=1]]', 'g: [connection X9/g =>[signal: a_891_413# w=1]]', 's: [connection X9/s =>[signal: VPWR w=1]]', 'b: [connection X9/b =>[signal: VPB w=1]]']]
X_X_60__9 X_60__a_1059_315# X_60__a_891_413# VPWR VPWR sky130_fd_pr__pfet_01v8_hvt w=1e+06u l=150000u
** [instance X10 of sky130_fd_pr__pfet_01v8_hvt, params={'w': '1e+06u', 'l': '150000u'} connections=['d: [connection X10/d =>[signal: Q w=1]]', 'g: [connection X10/g =>[signal: a_1059_315# w=1]]', 's: [connection X10/s =>[signal: VPWR w=1]]', 'b: [connection X10/b =>[signal: VPB w=1]]']]
X_X_60__10 _60_/Q X_60__a_1059_315# VPWR VPWR sky130_fd_pr__pfet_01v8_hvt w=1e+06u l=150000u
** [instance X11 of sky130_fd_pr__pfet_01v8_hvt, params={'w': '420000u', 'l': '150000u'} connections=['d: [connection X11/d =>[signal: a_561_413# w=1]]', 'g: [connection X11/g =>[signal: a_634_159# w=1]]', 's: [connection X11/s =>[signal: VPWR w=1]]', 'b: [connection X11/b =>[signal: VPB w=1]]']]
X_X_60__11 X_60__a_561_413# X_60__a_634_159# VPWR VPWR sky130_fd_pr__pfet_01v8_hvt w=420000u l=150000u
** [instance X12 of sky130_fd_pr__pfet_01v8_hvt, params={'w': '1e+06u', 'l': '150000u'} connections=['d: [connection X12/d =>[signal: VPWR w=1]]', 'g: [connection X12/g =>[signal: a_1059_315# w=1]]', 's: [connection X12/s =>[signal: Q w=1]]', 'b: [connection X12/b =>[signal: VPB w=1]]']]
X_X_60__12 VPWR X_60__a_1059_315# _60_/Q VPWR sky130_fd_pr__pfet_01v8_hvt w=1e+06u l=150000u
** [instance X13 of sky130_fd_pr__nfet_01v8, params={'w': '360000u', 'l': '150000u'} connections=['d: [connection X13/d =>[signal: a_891_413# w=1]]', 'g: [connection X13/g =>[signal: a_27_47# w=1]]', 's: [connection X13/s =>[signal: a_1017_47# w=1]]', 'b: [connection X13/b =>[signal: VNB w=1]]']]
X_X_60__13 X_60__a_891_413# X_60__a_27_47# X_60__a_1017_47# VGND sky130_fd_pr__nfet_01v8 w=360000u l=150000u
** [instance X14 of sky130_fd_pr__nfet_01v8, params={'w': '360000u', 'l': '150000u'} connections=['d: [connection X14/d =>[signal: a_634_159# w=1]]', 'g: [connection X14/g =>[signal: a_193_47# w=1]]', 's: [connection X14/s =>[signal: a_891_413# w=1]]', 'b: [connection X14/b =>[signal: VNB w=1]]']]
X_X_60__14 X_60__a_634_159# X_60__a_193_47# X_60__a_891_413# VGND sky130_fd_pr__nfet_01v8 w=360000u l=150000u
** [instance X15 of sky130_fd_pr__nfet_01v8, params={'w': '420000u', 'l': '150000u'} connections=['d: [connection X15/d =>[signal: a_592_47# w=1]]', 'g: [connection X15/g =>[signal: a_634_159# w=1]]', 's: [connection X15/s =>[signal: VGND w=1]]', 'b: [connection X15/b =>[signal: VNB w=1]]']]
X_X_60__15 X_60__a_592_47# X_60__a_634_159# VGND VGND sky130_fd_pr__nfet_01v8 w=420000u l=150000u
** [instance X16 of sky130_fd_pr__nfet_01v8, params={'w': '360000u', 'l': '150000u'} connections=['d: [connection X16/d =>[signal: a_466_413# w=1]]', 'g: [connection X16/g =>[signal: a_193_47# w=1]]', 's: [connection X16/s =>[signal: a_592_47# w=1]]', 'b: [connection X16/b =>[signal: VNB w=1]]']]
X_X_60__16 X_60__a_466_413# X_60__a_193_47# X_60__a_592_47# VGND sky130_fd_pr__nfet_01v8 w=360000u l=150000u
** [instance X17 of sky130_fd_pr__nfet_01v8, params={'w': '420000u', 'l': '150000u'} connections=['d: [connection X17/d =>[signal: VGND w=1]]', 'g: [connection X17/g =>[signal: a_27_47# w=1]]', 's: [connection X17/s =>[signal: a_193_47# w=1]]', 'b: [connection X17/b =>[signal: VNB w=1]]']]
X_X_60__17 VGND X_60__a_27_47# X_60__a_193_47# VGND sky130_fd_pr__nfet_01v8 w=420000u l=150000u
** [instance X18 of sky130_fd_pr__nfet_01v8, params={'w': '360000u', 'l': '150000u'} connections=['d: [connection X18/d =>[signal: a_381_47# w=1]]', 'g: [connection X18/g =>[signal: a_27_47# w=1]]', 's: [connection X18/s =>[signal: a_466_413# w=1]]', 'b: [connection X18/b =>[signal: VNB w=1]]']]
X_X_60__18 X_60__a_381_47# X_60__a_27_47# X_60__a_466_413# VGND sky130_fd_pr__nfet_01v8 w=360000u l=150000u
** [instance X19 of sky130_fd_pr__nfet_01v8, params={'w': '420000u', 'l': '150000u'} connections=['d: [connection X19/d =>[signal: a_27_47# w=1]]', 'g: [connection X19/g =>[signal: CLK w=1]]', 's: [connection X19/s =>[signal: VGND w=1]]', 'b: [connection X19/b =>[signal: VNB w=1]]']]
X_X_60__19 X_60__a_27_47# _76_/CLK VGND VGND sky130_fd_pr__nfet_01v8 w=420000u l=150000u
** [instance X20 of sky130_fd_pr__pfet_01v8_hvt, params={'w': '640000u', 'l': '150000u'} connections=['d: [connection X20/d =>[signal: a_27_47# w=1]]', 'g: [connection X20/g =>[signal: CLK w=1]]', 's: [connection X20/s =>[signal: VPWR w=1]]', 'b: [connection X20/b =>[signal: VPB w=1]]']]
X_X_60__20 X_60__a_27_47# _76_/CLK VPWR VPWR sky130_fd_pr__pfet_01v8_hvt w=640000u l=150000u
** [instance X21 of sky130_fd_pr__nfet_01v8, params={'w': '650000u', 'l': '150000u'} connections=['d: [connection X21/d =>[signal: Q w=1]]', 'g: [connection X21/g =>[signal: a_1059_315# w=1]]', 's: [connection X21/s =>[signal: VGND w=1]]', 'b: [connection X21/b =>[signal: VNB w=1]]']]
X_X_60__21 _60_/Q X_60__a_1059_315# VGND VGND sky130_fd_pr__nfet_01v8 w=650000u l=150000u
** [instance X22 of sky130_fd_pr__pfet_01v8_hvt, params={'w': '640000u', 'l': '150000u'} connections=['d: [connection X22/d =>[signal: VPWR w=1]]', 'g: [connection X22/g =>[signal: a_27_47# w=1]]', 's: [connection X22/s =>[signal: a_193_47# w=1]]', 'b: [connection X22/b =>[signal: VPB w=1]]']]
X_X_60__22 VPWR X_60__a_27_47# X_60__a_193_47# VPWR sky130_fd_pr__pfet_01v8_hvt w=640000u l=150000u
** [instance X23 of sky130_fd_pr__nfet_01v8, params={'w': '420000u', 'l': '150000u'} connections=['d: [connection X23/d =>[signal: VGND w=1]]', 'g: [connection X23/g =>[signal: D w=1]]', 's: [connection X23/s =>[signal: a_381_47# w=1]]', 'b: [connection X23/b =>[signal: VNB w=1]]']]
X_X_60__23 VGND _60_/D X_60__a_381_47# VGND sky130_fd_pr__nfet_01v8 w=420000u l=150000u
** [instance X24 of sky130_fd_pr__pfet_01v8_hvt, params={'w': '420000u', 'l': '150000u'} connections=['d: [connection X24/d =>[signal: a_975_413# w=1]]', 'g: [connection X24/g =>[signal: a_1059_315# w=1]]', 's: [connection X24/s =>[signal: VPWR w=1]]', 'b: [connection X24/b =>[signal: VPB w=1]]']]
X_X_60__24 X_60__a_975_413# X_60__a_1059_315# VPWR VPWR sky130_fd_pr__pfet_01v8_hvt w=420000u l=150000u
** [instance X25 of sky130_fd_pr__nfet_01v8, params={'w': '650000u', 'l': '150000u'} connections=['d: [connection X25/d =>[signal: VGND w=1]]', 'g: [connection X25/g =>[signal: a_1059_315# w=1]]', 's: [connection X25/s =>[signal: Q w=1]]', 'b: [connection X25/b =>[signal: VNB w=1]]']]
X_X_60__25 VGND X_60__a_1059_315# _60_/Q VGND sky130_fd_pr__nfet_01v8 w=650000u l=150000u

** replacing Xhold36 with the contents of sky130_fd_sc_hd__dlygate4sd3_1
** [instance X0 of sky130_fd_pr__nfet_01v8, params={'w': '420000u', 'l': '500000u'} connections=['d: [connection X0/d =>[signal: a_391_47# w=1]]', 'g: [connection X0/g =>[signal: a_285_47# w=1]]', 's: [connection X0/s =>[signal: VGND w=1]]', 'b: [connection X0/b =>[signal: VNB w=1]]']]
X_Xhold36_0 Xhold36_a_391_47# Xhold36_a_285_47# VGND VGND sky130_fd_pr__nfet_01v8 w=420000u l=500000u
** [instance X1 of sky130_fd_pr__pfet_01v8_hvt, params={'w': '420000u', 'l': '500000u'} connections=['d: [connection X1/d =>[signal: VPWR w=1]]', 'g: [connection X1/g =>[signal: a_49_47# w=1]]', 's: [connection X1/s =>[signal: a_285_47# w=1]]', 'b: [connection X1/b =>[signal: VPB w=1]]']]
X_Xhold36_1 VPWR Xhold36_a_49_47# Xhold36_a_285_47# VPWR sky130_fd_pr__pfet_01v8_hvt w=420000u l=500000u
** [instance X2 of sky130_fd_pr__nfet_01v8, params={'w': '420000u', 'l': '150000u'} connections=['d: [connection X2/d =>[signal: a_49_47# w=1]]', 'g: [connection X2/g =>[signal: A w=1]]', 's: [connection X2/s =>[signal: VGND w=1]]', 'b: [connection X2/b =>[signal: VNB w=1]]']]
X_Xhold36_2 Xhold36_a_49_47# _71_/Q VGND VGND sky130_fd_pr__nfet_01v8 w=420000u l=150000u
** [instance X3 of sky130_fd_pr__pfet_01v8_hvt, params={'w': '1e+06u', 'l': '150000u'} connections=['d: [connection X3/d =>[signal: VPWR w=1]]', 'g: [connection X3/g =>[signal: a_391_47# w=1]]', 's: [connection X3/s =>[signal: X w=1]]', 'b: [connection X3/b =>[signal: VPB w=1]]']]
X_Xhold36_3 VPWR Xhold36_a_391_47# _53_/A0 VPWR sky130_fd_pr__pfet_01v8_hvt w=1e+06u l=150000u
** [instance X4 of sky130_fd_pr__nfet_01v8, params={'w': '650000u', 'l': '150000u'} connections=['d: [connection X4/d =>[signal: VGND w=1]]', 'g: [connection X4/g =>[signal: a_391_47# w=1]]', 's: [connection X4/s =>[signal: X w=1]]', 'b: [connection X4/b =>[signal: VNB w=1]]']]
X_Xhold36_4 VGND Xhold36_a_391_47# _53_/A0 VGND sky130_fd_pr__nfet_01v8 w=650000u l=150000u
** [instance X5 of sky130_fd_pr__nfet_01v8, params={'w': '420000u', 'l': '500000u'} connections=['d: [connection X5/d =>[signal: VGND w=1]]', 'g: [connection X5/g =>[signal: a_49_47# w=1]]', 's: [connection X5/s =>[signal: a_285_47# w=1]]', 'b: [connection X5/b =>[signal: VNB w=1]]']]
X_Xhold36_5 VGND Xhold36_a_49_47# Xhold36_a_285_47# VGND sky130_fd_pr__nfet_01v8 w=420000u l=500000u
** [instance X6 of sky130_fd_pr__pfet_01v8_hvt, params={'w': '420000u', 'l': '500000u'} connections=['d: [connection X6/d =>[signal: a_391_47# w=1]]', 'g: [connection X6/g =>[signal: a_285_47# w=1]]', 's: [connection X6/s =>[signal: VPWR w=1]]', 'b: [connection X6/b =>[signal: VPB w=1]]']]
X_Xhold36_6 Xhold36_a_391_47# Xhold36_a_285_47# VPWR VPWR sky130_fd_pr__pfet_01v8_hvt w=420000u l=500000u
** [instance X7 of sky130_fd_pr__pfet_01v8_hvt, params={'w': '420000u', 'l': '150000u'} connections=['d: [connection X7/d =>[signal: a_49_47# w=1]]', 'g: [connection X7/g =>[signal: A w=1]]', 's: [connection X7/s =>[signal: VPWR w=1]]', 'b: [connection X7/b =>[signal: VPB w=1]]']]
X_Xhold36_7 Xhold36_a_49_47# _71_/Q VPWR VPWR sky130_fd_pr__pfet_01v8_hvt w=420000u l=150000u

** replacing Xhold14 with the contents of sky130_fd_sc_hd__dlygate4sd3_1
** [instance X0 of sky130_fd_pr__nfet_01v8, params={'w': '420000u', 'l': '500000u'} connections=['d: [connection X0/d =>[signal: a_391_47# w=1]]', 'g: [connection X0/g =>[signal: a_285_47# w=1]]', 's: [connection X0/s =>[signal: VGND w=1]]', 'b: [connection X0/b =>[signal: VNB w=1]]']]
X_Xhold14_0 Xhold14_a_391_47# Xhold14_a_285_47# VGND VGND sky130_fd_pr__nfet_01v8 w=420000u l=500000u
** [instance X1 of sky130_fd_pr__pfet_01v8_hvt, params={'w': '420000u', 'l': '500000u'} connections=['d: [connection X1/d =>[signal: VPWR w=1]]', 'g: [connection X1/g =>[signal: a_49_47# w=1]]', 's: [connection X1/s =>[signal: a_285_47# w=1]]', 'b: [connection X1/b =>[signal: VPB w=1]]']]
X_Xhold14_1 VPWR Xhold14_a_49_47# Xhold14_a_285_47# VPWR sky130_fd_pr__pfet_01v8_hvt w=420000u l=500000u
** [instance X2 of sky130_fd_pr__nfet_01v8, params={'w': '420000u', 'l': '150000u'} connections=['d: [connection X2/d =>[signal: a_49_47# w=1]]', 'g: [connection X2/g =>[signal: A w=1]]', 's: [connection X2/s =>[signal: VGND w=1]]', 'b: [connection X2/b =>[signal: VNB w=1]]']]
X_Xhold14_2 Xhold14_a_49_47# _64_/Q VGND VGND sky130_fd_pr__nfet_01v8 w=420000u l=150000u
** [instance X3 of sky130_fd_pr__pfet_01v8_hvt, params={'w': '1e+06u', 'l': '150000u'} connections=['d: [connection X3/d =>[signal: VPWR w=1]]', 'g: [connection X3/g =>[signal: a_391_47# w=1]]', 's: [connection X3/s =>[signal: X w=1]]', 'b: [connection X3/b =>[signal: VPB w=1]]']]
X_Xhold14_3 VPWR Xhold14_a_391_47# _46_/A0 VPWR sky130_fd_pr__pfet_01v8_hvt w=1e+06u l=150000u
** [instance X4 of sky130_fd_pr__nfet_01v8, params={'w': '650000u', 'l': '150000u'} connections=['d: [connection X4/d =>[signal: VGND w=1]]', 'g: [connection X4/g =>[signal: a_391_47# w=1]]', 's: [connection X4/s =>[signal: X w=1]]', 'b: [connection X4/b =>[signal: VNB w=1]]']]
X_Xhold14_4 VGND Xhold14_a_391_47# _46_/A0 VGND sky130_fd_pr__nfet_01v8 w=650000u l=150000u
** [instance X5 of sky130_fd_pr__nfet_01v8, params={'w': '420000u', 'l': '500000u'} connections=['d: [connection X5/d =>[signal: VGND w=1]]', 'g: [connection X5/g =>[signal: a_49_47# w=1]]', 's: [connection X5/s =>[signal: a_285_47# w=1]]', 'b: [connection X5/b =>[signal: VNB w=1]]']]
X_Xhold14_5 VGND Xhold14_a_49_47# Xhold14_a_285_47# VGND sky130_fd_pr__nfet_01v8 w=420000u l=500000u
** [instance X6 of sky130_fd_pr__pfet_01v8_hvt, params={'w': '420000u', 'l': '500000u'} connections=['d: [connection X6/d =>[signal: a_391_47# w=1]]', 'g: [connection X6/g =>[signal: a_285_47# w=1]]', 's: [connection X6/s =>[signal: VPWR w=1]]', 'b: [connection X6/b =>[signal: VPB w=1]]']]
X_Xhold14_6 Xhold14_a_391_47# Xhold14_a_285_47# VPWR VPWR sky130_fd_pr__pfet_01v8_hvt w=420000u l=500000u
** [instance X7 of sky130_fd_pr__pfet_01v8_hvt, params={'w': '420000u', 'l': '150000u'} connections=['d: [connection X7/d =>[signal: a_49_47# w=1]]', 'g: [connection X7/g =>[signal: A w=1]]', 's: [connection X7/s =>[signal: VPWR w=1]]', 'b: [connection X7/b =>[signal: VPB w=1]]']]
X_Xhold14_7 Xhold14_a_49_47# _64_/Q VPWR VPWR sky130_fd_pr__pfet_01v8_hvt w=420000u l=150000u

** replacing Xhold25 with the contents of sky130_fd_sc_hd__dlygate4sd3_1
** [instance X0 of sky130_fd_pr__nfet_01v8, params={'w': '420000u', 'l': '500000u'} connections=['d: [connection X0/d =>[signal: a_391_47# w=1]]', 'g: [connection X0/g =>[signal: a_285_47# w=1]]', 's: [connection X0/s =>[signal: VGND w=1]]', 'b: [connection X0/b =>[signal: VNB w=1]]']]
X_Xhold25_0 Xhold25_a_391_47# Xhold25_a_285_47# VGND VGND sky130_fd_pr__nfet_01v8 w=420000u l=500000u
** [instance X1 of sky130_fd_pr__pfet_01v8_hvt, params={'w': '420000u', 'l': '500000u'} connections=['d: [connection X1/d =>[signal: VPWR w=1]]', 'g: [connection X1/g =>[signal: a_49_47# w=1]]', 's: [connection X1/s =>[signal: a_285_47# w=1]]', 'b: [connection X1/b =>[signal: VPB w=1]]']]
X_Xhold25_1 VPWR Xhold25_a_49_47# Xhold25_a_285_47# VPWR sky130_fd_pr__pfet_01v8_hvt w=420000u l=500000u
** [instance X2 of sky130_fd_pr__nfet_01v8, params={'w': '420000u', 'l': '150000u'} connections=['d: [connection X2/d =>[signal: a_49_47# w=1]]', 'g: [connection X2/g =>[signal: A w=1]]', 's: [connection X2/s =>[signal: VGND w=1]]', 'b: [connection X2/b =>[signal: VNB w=1]]']]
X_Xhold25_2 Xhold25_a_49_47# _57_/X VGND VGND sky130_fd_pr__nfet_01v8 w=420000u l=150000u
** [instance X3 of sky130_fd_pr__pfet_01v8_hvt, params={'w': '1e+06u', 'l': '150000u'} connections=['d: [connection X3/d =>[signal: VPWR w=1]]', 'g: [connection X3/g =>[signal: a_391_47# w=1]]', 's: [connection X3/s =>[signal: X w=1]]', 'b: [connection X3/b =>[signal: VPB w=1]]']]
X_Xhold25_3 VPWR Xhold25_a_391_47# _75_/D VPWR sky130_fd_pr__pfet_01v8_hvt w=1e+06u l=150000u
** [instance X4 of sky130_fd_pr__nfet_01v8, params={'w': '650000u', 'l': '150000u'} connections=['d: [connection X4/d =>[signal: VGND w=1]]', 'g: [connection X4/g =>[signal: a_391_47# w=1]]', 's: [connection X4/s =>[signal: X w=1]]', 'b: [connection X4/b =>[signal: VNB w=1]]']]
X_Xhold25_4 VGND Xhold25_a_391_47# _75_/D VGND sky130_fd_pr__nfet_01v8 w=650000u l=150000u
** [instance X5 of sky130_fd_pr__nfet_01v8, params={'w': '420000u', 'l': '500000u'} connections=['d: [connection X5/d =>[signal: VGND w=1]]', 'g: [connection X5/g =>[signal: a_49_47# w=1]]', 's: [connection X5/s =>[signal: a_285_47# w=1]]', 'b: [connection X5/b =>[signal: VNB w=1]]']]
X_Xhold25_5 VGND Xhold25_a_49_47# Xhold25_a_285_47# VGND sky130_fd_pr__nfet_01v8 w=420000u l=500000u
** [instance X6 of sky130_fd_pr__pfet_01v8_hvt, params={'w': '420000u', 'l': '500000u'} connections=['d: [connection X6/d =>[signal: a_391_47# w=1]]', 'g: [connection X6/g =>[signal: a_285_47# w=1]]', 's: [connection X6/s =>[signal: VPWR w=1]]', 'b: [connection X6/b =>[signal: VPB w=1]]']]
X_Xhold25_6 Xhold25_a_391_47# Xhold25_a_285_47# VPWR VPWR sky130_fd_pr__pfet_01v8_hvt w=420000u l=500000u
** [instance X7 of sky130_fd_pr__pfet_01v8_hvt, params={'w': '420000u', 'l': '150000u'} connections=['d: [connection X7/d =>[signal: a_49_47# w=1]]', 'g: [connection X7/g =>[signal: A w=1]]', 's: [connection X7/s =>[signal: VPWR w=1]]', 'b: [connection X7/b =>[signal: VPB w=1]]']]
X_Xhold25_7 Xhold25_a_49_47# _57_/X VPWR VPWR sky130_fd_pr__pfet_01v8_hvt w=420000u l=150000u

** replacing X_43_ with the contents of sky130_fd_sc_hd__mux2_1
** [instance X0 of sky130_fd_pr__pfet_01v8_hvt, params={'w': '420000u', 'l': '150000u'} connections=['d: [connection X0/d =>[signal: VPWR w=1]]', 'g: [connection X0/g =>[signal: S w=1]]', 's: [connection X0/s =>[signal: a_218_374# w=1]]', 'b: [connection X0/b =>[signal: VPB w=1]]']]
X_X_43__0 VPWR _58_/S X_43__a_218_374# VPWR sky130_fd_pr__pfet_01v8_hvt w=420000u l=150000u
** [instance X1 of sky130_fd_pr__nfet_01v8, params={'w': '420000u', 'l': '150000u'} connections=['d: [connection X1/d =>[signal: a_76_199# w=1]]', 'g: [connection X1/g =>[signal: A0 w=1]]', 's: [connection X1/s =>[signal: a_439_47# w=1]]', 'b: [connection X1/b =>[signal: VNB w=1]]']]
X_X_43__1 X_43__a_76_199# _43_/A0 X_43__a_439_47# VGND sky130_fd_pr__nfet_01v8 w=420000u l=150000u
** [instance X2 of sky130_fd_pr__pfet_01v8_hvt, params={'w': '420000u', 'l': '150000u'} connections=['d: [connection X2/d =>[signal: a_535_374# w=1]]', 'g: [connection X2/g =>[signal: a_505_21# w=1]]', 's: [connection X2/s =>[signal: VPWR w=1]]', 'b: [connection X2/b =>[signal: VPB w=1]]']]
X_X_43__2 X_43__a_535_374# X_43__a_505_21# VPWR VPWR sky130_fd_pr__pfet_01v8_hvt w=420000u l=150000u
** [instance X3 of sky130_fd_pr__pfet_01v8_hvt, params={'w': '420000u', 'l': '150000u'} connections=['d: [connection X3/d =>[signal: VPWR w=1]]', 'g: [connection X3/g =>[signal: S w=1]]', 's: [connection X3/s =>[signal: a_505_21# w=1]]', 'b: [connection X3/b =>[signal: VPB w=1]]']]
X_X_43__3 VPWR _58_/S X_43__a_505_21# VPWR sky130_fd_pr__pfet_01v8_hvt w=420000u l=150000u
** [instance X4 of sky130_fd_pr__pfet_01v8_hvt, params={'w': '420000u', 'l': '150000u'} connections=['d: [connection X4/d =>[signal: a_76_199# w=1]]', 'g: [connection X4/g =>[signal: A1 w=1]]', 's: [connection X4/s =>[signal: a_535_374# w=1]]', 'b: [connection X4/b =>[signal: VPB w=1]]']]
X_X_43__4 X_43__a_76_199# _62_/Q X_43__a_535_374# VPWR sky130_fd_pr__pfet_01v8_hvt w=420000u l=150000u
** [instance X5 of sky130_fd_pr__nfet_01v8, params={'w': '420000u', 'l': '150000u'} connections=['d: [connection X5/d =>[signal: a_218_47# w=1]]', 'g: [connection X5/g =>[signal: A1 w=1]]', 's: [connection X5/s =>[signal: a_76_199# w=1]]', 'b: [connection X5/b =>[signal: VNB w=1]]']]
X_X_43__5 X_43__a_218_47# _62_/Q X_43__a_76_199# VGND sky130_fd_pr__nfet_01v8 w=420000u l=150000u
** [instance X6 of sky130_fd_pr__pfet_01v8_hvt, params={'w': '420000u', 'l': '150000u'} connections=['d: [connection X6/d =>[signal: a_218_374# w=1]]', 'g: [connection X6/g =>[signal: A0 w=1]]', 's: [connection X6/s =>[signal: a_76_199# w=1]]', 'b: [connection X6/b =>[signal: VPB w=1]]']]
X_X_43__6 X_43__a_218_374# _43_/A0 X_43__a_76_199# VPWR sky130_fd_pr__pfet_01v8_hvt w=420000u l=150000u
** [instance X7 of sky130_fd_pr__nfet_01v8, params={'w': '650000u', 'l': '150000u'} connections=['d: [connection X7/d =>[signal: X w=1]]', 'g: [connection X7/g =>[signal: a_76_199# w=1]]', 's: [connection X7/s =>[signal: VGND w=1]]', 'b: [connection X7/b =>[signal: VNB w=1]]']]
X_X_43__7 _43_/X X_43__a_76_199# VGND VGND sky130_fd_pr__nfet_01v8 w=650000u l=150000u
** [instance X8 of sky130_fd_pr__pfet_01v8_hvt, params={'w': '1e+06u', 'l': '150000u'} connections=['d: [connection X8/d =>[signal: X w=1]]', 'g: [connection X8/g =>[signal: a_76_199# w=1]]', 's: [connection X8/s =>[signal: VPWR w=1]]', 'b: [connection X8/b =>[signal: VPB w=1]]']]
X_X_43__8 _43_/X X_43__a_76_199# VPWR VPWR sky130_fd_pr__pfet_01v8_hvt w=1e+06u l=150000u
** [instance X9 of sky130_fd_pr__nfet_01v8, params={'w': '420000u', 'l': '150000u'} connections=['d: [connection X9/d =>[signal: VGND w=1]]', 'g: [connection X9/g =>[signal: S w=1]]', 's: [connection X9/s =>[signal: a_218_47# w=1]]', 'b: [connection X9/b =>[signal: VNB w=1]]']]
X_X_43__9 VGND _58_/S X_43__a_218_47# VGND sky130_fd_pr__nfet_01v8 w=420000u l=150000u
** [instance X10 of sky130_fd_pr__nfet_01v8, params={'w': '420000u', 'l': '150000u'} connections=['d: [connection X10/d =>[signal: VGND w=1]]', 'g: [connection X10/g =>[signal: S w=1]]', 's: [connection X10/s =>[signal: a_505_21# w=1]]', 'b: [connection X10/b =>[signal: VNB w=1]]']]
X_X_43__10 VGND _58_/S X_43__a_505_21# VGND sky130_fd_pr__nfet_01v8 w=420000u l=150000u
** [instance X11 of sky130_fd_pr__nfet_01v8, params={'w': '420000u', 'l': '150000u'} connections=['d: [connection X11/d =>[signal: a_439_47# w=1]]', 'g: [connection X11/g =>[signal: a_505_21# w=1]]', 's: [connection X11/s =>[signal: VGND w=1]]', 'b: [connection X11/b =>[signal: VNB w=1]]']]
X_X_43__11 X_43__a_439_47# X_43__a_505_21# VGND VGND sky130_fd_pr__nfet_01v8 w=420000u l=150000u

** replacing XPHY_EDGE_ROW_1_Right_1 with the contents of sky130_fd_sc_hd__decap_3
** [instance X0 of sky130_fd_pr__pfet_01v8_hvt, params={'w': '870000u', 'l': '590000u'} connections=['d: [connection X0/d =>[signal: VPWR w=1]]', 'g: [connection X0/g =>[signal: VGND w=1]]', 's: [connection X0/s =>[signal: VPWR w=1]]', 'b: [connection X0/b =>[signal: VPB w=1]]']]
X_XPHY_EDGE_ROW_1_Right_1_0 VPWR VGND VPWR VPWR sky130_fd_pr__pfet_01v8_hvt w=870000u l=590000u
** [instance X1 of sky130_fd_pr__nfet_01v8, params={'w': '550000u', 'l': '590000u'} connections=['d: [connection X1/d =>[signal: VGND w=1]]', 'g: [connection X1/g =>[signal: VPWR w=1]]', 's: [connection X1/s =>[signal: VGND w=1]]', 'b: [connection X1/b =>[signal: VNB w=1]]']]
X_XPHY_EDGE_ROW_1_Right_1_1 VGND VPWR VGND VGND sky130_fd_pr__nfet_01v8 w=550000u l=590000u

** replacing XFILLER_13_60 with the contents of sky130_fd_sc_hd__decap_3
** [instance X0 of sky130_fd_pr__pfet_01v8_hvt, params={'w': '870000u', 'l': '590000u'} connections=['d: [connection X0/d =>[signal: VPWR w=1]]', 'g: [connection X0/g =>[signal: VGND w=1]]', 's: [connection X0/s =>[signal: VPWR w=1]]', 'b: [connection X0/b =>[signal: VPB w=1]]']]
X_XFILLER_13_60_0 VPWR VGND VPWR VPWR sky130_fd_pr__pfet_01v8_hvt w=870000u l=590000u
** [instance X1 of sky130_fd_pr__nfet_01v8, params={'w': '550000u', 'l': '590000u'} connections=['d: [connection X1/d =>[signal: VGND w=1]]', 'g: [connection X1/g =>[signal: VPWR w=1]]', 's: [connection X1/s =>[signal: VGND w=1]]', 'b: [connection X1/b =>[signal: VNB w=1]]']]
X_XFILLER_13_60_1 VGND VPWR VGND VGND sky130_fd_pr__nfet_01v8 w=550000u l=590000u

** replacing X_42_ with the contents of sky130_fd_sc_hd__mux2_1
** [instance X0 of sky130_fd_pr__pfet_01v8_hvt, params={'w': '420000u', 'l': '150000u'} connections=['d: [connection X0/d =>[signal: VPWR w=1]]', 'g: [connection X0/g =>[signal: S w=1]]', 's: [connection X0/s =>[signal: a_218_374# w=1]]', 'b: [connection X0/b =>[signal: VPB w=1]]']]
X_X_42__0 VPWR _58_/S X_42__a_218_374# VPWR sky130_fd_pr__pfet_01v8_hvt w=420000u l=150000u
** [instance X1 of sky130_fd_pr__nfet_01v8, params={'w': '420000u', 'l': '150000u'} connections=['d: [connection X1/d =>[signal: a_76_199# w=1]]', 'g: [connection X1/g =>[signal: A0 w=1]]', 's: [connection X1/s =>[signal: a_439_47# w=1]]', 'b: [connection X1/b =>[signal: VNB w=1]]']]
X_X_42__1 X_42__a_76_199# _42_/A0 X_42__a_439_47# VGND sky130_fd_pr__nfet_01v8 w=420000u l=150000u
** [instance X2 of sky130_fd_pr__pfet_01v8_hvt, params={'w': '420000u', 'l': '150000u'} connections=['d: [connection X2/d =>[signal: a_535_374# w=1]]', 'g: [connection X2/g =>[signal: a_505_21# w=1]]', 's: [connection X2/s =>[signal: VPWR w=1]]', 'b: [connection X2/b =>[signal: VPB w=1]]']]
X_X_42__2 X_42__a_535_374# X_42__a_505_21# VPWR VPWR sky130_fd_pr__pfet_01v8_hvt w=420000u l=150000u
** [instance X3 of sky130_fd_pr__pfet_01v8_hvt, params={'w': '420000u', 'l': '150000u'} connections=['d: [connection X3/d =>[signal: VPWR w=1]]', 'g: [connection X3/g =>[signal: S w=1]]', 's: [connection X3/s =>[signal: a_505_21# w=1]]', 'b: [connection X3/b =>[signal: VPB w=1]]']]
X_X_42__3 VPWR _58_/S X_42__a_505_21# VPWR sky130_fd_pr__pfet_01v8_hvt w=420000u l=150000u
** [instance X4 of sky130_fd_pr__pfet_01v8_hvt, params={'w': '420000u', 'l': '150000u'} connections=['d: [connection X4/d =>[signal: a_76_199# w=1]]', 'g: [connection X4/g =>[signal: A1 w=1]]', 's: [connection X4/s =>[signal: a_535_374# w=1]]', 'b: [connection X4/b =>[signal: VPB w=1]]']]
X_X_42__4 X_42__a_76_199# _61_/Q X_42__a_535_374# VPWR sky130_fd_pr__pfet_01v8_hvt w=420000u l=150000u
** [instance X5 of sky130_fd_pr__nfet_01v8, params={'w': '420000u', 'l': '150000u'} connections=['d: [connection X5/d =>[signal: a_218_47# w=1]]', 'g: [connection X5/g =>[signal: A1 w=1]]', 's: [connection X5/s =>[signal: a_76_199# w=1]]', 'b: [connection X5/b =>[signal: VNB w=1]]']]
X_X_42__5 X_42__a_218_47# _61_/Q X_42__a_76_199# VGND sky130_fd_pr__nfet_01v8 w=420000u l=150000u
** [instance X6 of sky130_fd_pr__pfet_01v8_hvt, params={'w': '420000u', 'l': '150000u'} connections=['d: [connection X6/d =>[signal: a_218_374# w=1]]', 'g: [connection X6/g =>[signal: A0 w=1]]', 's: [connection X6/s =>[signal: a_76_199# w=1]]', 'b: [connection X6/b =>[signal: VPB w=1]]']]
X_X_42__6 X_42__a_218_374# _42_/A0 X_42__a_76_199# VPWR sky130_fd_pr__pfet_01v8_hvt w=420000u l=150000u
** [instance X7 of sky130_fd_pr__nfet_01v8, params={'w': '650000u', 'l': '150000u'} connections=['d: [connection X7/d =>[signal: X w=1]]', 'g: [connection X7/g =>[signal: a_76_199# w=1]]', 's: [connection X7/s =>[signal: VGND w=1]]', 'b: [connection X7/b =>[signal: VNB w=1]]']]
X_X_42__7 _42_/X X_42__a_76_199# VGND VGND sky130_fd_pr__nfet_01v8 w=650000u l=150000u
** [instance X8 of sky130_fd_pr__pfet_01v8_hvt, params={'w': '1e+06u', 'l': '150000u'} connections=['d: [connection X8/d =>[signal: X w=1]]', 'g: [connection X8/g =>[signal: a_76_199# w=1]]', 's: [connection X8/s =>[signal: VPWR w=1]]', 'b: [connection X8/b =>[signal: VPB w=1]]']]
X_X_42__8 _42_/X X_42__a_76_199# VPWR VPWR sky130_fd_pr__pfet_01v8_hvt w=1e+06u l=150000u
** [instance X9 of sky130_fd_pr__nfet_01v8, params={'w': '420000u', 'l': '150000u'} connections=['d: [connection X9/d =>[signal: VGND w=1]]', 'g: [connection X9/g =>[signal: S w=1]]', 's: [connection X9/s =>[signal: a_218_47# w=1]]', 'b: [connection X9/b =>[signal: VNB w=1]]']]
X_X_42__9 VGND _58_/S X_42__a_218_47# VGND sky130_fd_pr__nfet_01v8 w=420000u l=150000u
** [instance X10 of sky130_fd_pr__nfet_01v8, params={'w': '420000u', 'l': '150000u'} connections=['d: [connection X10/d =>[signal: VGND w=1]]', 'g: [connection X10/g =>[signal: S w=1]]', 's: [connection X10/s =>[signal: a_505_21# w=1]]', 'b: [connection X10/b =>[signal: VNB w=1]]']]
X_X_42__10 VGND _58_/S X_42__a_505_21# VGND sky130_fd_pr__nfet_01v8 w=420000u l=150000u
** [instance X11 of sky130_fd_pr__nfet_01v8, params={'w': '420000u', 'l': '150000u'} connections=['d: [connection X11/d =>[signal: a_439_47# w=1]]', 'g: [connection X11/g =>[signal: a_505_21# w=1]]', 's: [connection X11/s =>[signal: VGND w=1]]', 'b: [connection X11/b =>[signal: VNB w=1]]']]
X_X_42__11 X_42__a_439_47# X_42__a_505_21# VGND VGND sky130_fd_pr__nfet_01v8 w=420000u l=150000u

** replacing Xhold37 with the contents of sky130_fd_sc_hd__dlygate4sd3_1
** [instance X0 of sky130_fd_pr__nfet_01v8, params={'w': '420000u', 'l': '500000u'} connections=['d: [connection X0/d =>[signal: a_391_47# w=1]]', 'g: [connection X0/g =>[signal: a_285_47# w=1]]', 's: [connection X0/s =>[signal: VGND w=1]]', 'b: [connection X0/b =>[signal: VNB w=1]]']]
X_Xhold37_0 Xhold37_a_391_47# Xhold37_a_285_47# VGND VGND sky130_fd_pr__nfet_01v8 w=420000u l=500000u
** [instance X1 of sky130_fd_pr__pfet_01v8_hvt, params={'w': '420000u', 'l': '500000u'} connections=['d: [connection X1/d =>[signal: VPWR w=1]]', 'g: [connection X1/g =>[signal: a_49_47# w=1]]', 's: [connection X1/s =>[signal: a_285_47# w=1]]', 'b: [connection X1/b =>[signal: VPB w=1]]']]
X_Xhold37_1 VPWR Xhold37_a_49_47# Xhold37_a_285_47# VPWR sky130_fd_pr__pfet_01v8_hvt w=420000u l=500000u
** [instance X2 of sky130_fd_pr__nfet_01v8, params={'w': '420000u', 'l': '150000u'} connections=['d: [connection X2/d =>[signal: a_49_47# w=1]]', 'g: [connection X2/g =>[signal: A w=1]]', 's: [connection X2/s =>[signal: VGND w=1]]', 'b: [connection X2/b =>[signal: VNB w=1]]']]
X_Xhold37_2 Xhold37_a_49_47# _68_/Q VGND VGND sky130_fd_pr__nfet_01v8 w=420000u l=150000u
** [instance X3 of sky130_fd_pr__pfet_01v8_hvt, params={'w': '1e+06u', 'l': '150000u'} connections=['d: [connection X3/d =>[signal: VPWR w=1]]', 'g: [connection X3/g =>[signal: a_391_47# w=1]]', 's: [connection X3/s =>[signal: X w=1]]', 'b: [connection X3/b =>[signal: VPB w=1]]']]
X_Xhold37_3 VPWR Xhold37_a_391_47# _50_/A0 VPWR sky130_fd_pr__pfet_01v8_hvt w=1e+06u l=150000u
** [instance X4 of sky130_fd_pr__nfet_01v8, params={'w': '650000u', 'l': '150000u'} connections=['d: [connection X4/d =>[signal: VGND w=1]]', 'g: [connection X4/g =>[signal: a_391_47# w=1]]', 's: [connection X4/s =>[signal: X w=1]]', 'b: [connection X4/b =>[signal: VNB w=1]]']]
X_Xhold37_4 VGND Xhold37_a_391_47# _50_/A0 VGND sky130_fd_pr__nfet_01v8 w=650000u l=150000u
** [instance X5 of sky130_fd_pr__nfet_01v8, params={'w': '420000u', 'l': '500000u'} connections=['d: [connection X5/d =>[signal: VGND w=1]]', 'g: [connection X5/g =>[signal: a_49_47# w=1]]', 's: [connection X5/s =>[signal: a_285_47# w=1]]', 'b: [connection X5/b =>[signal: VNB w=1]]']]
X_Xhold37_5 VGND Xhold37_a_49_47# Xhold37_a_285_47# VGND sky130_fd_pr__nfet_01v8 w=420000u l=500000u
** [instance X6 of sky130_fd_pr__pfet_01v8_hvt, params={'w': '420000u', 'l': '500000u'} connections=['d: [connection X6/d =>[signal: a_391_47# w=1]]', 'g: [connection X6/g =>[signal: a_285_47# w=1]]', 's: [connection X6/s =>[signal: VPWR w=1]]', 'b: [connection X6/b =>[signal: VPB w=1]]']]
X_Xhold37_6 Xhold37_a_391_47# Xhold37_a_285_47# VPWR VPWR sky130_fd_pr__pfet_01v8_hvt w=420000u l=500000u
** [instance X7 of sky130_fd_pr__pfet_01v8_hvt, params={'w': '420000u', 'l': '150000u'} connections=['d: [connection X7/d =>[signal: a_49_47# w=1]]', 'g: [connection X7/g =>[signal: A w=1]]', 's: [connection X7/s =>[signal: VPWR w=1]]', 'b: [connection X7/b =>[signal: VPB w=1]]']]
X_Xhold37_7 Xhold37_a_49_47# _68_/Q VPWR VPWR sky130_fd_pr__pfet_01v8_hvt w=420000u l=150000u

** replacing Xhold15 with the contents of sky130_fd_sc_hd__dlygate4sd3_1
** [instance X0 of sky130_fd_pr__nfet_01v8, params={'w': '420000u', 'l': '500000u'} connections=['d: [connection X0/d =>[signal: a_391_47# w=1]]', 'g: [connection X0/g =>[signal: a_285_47# w=1]]', 's: [connection X0/s =>[signal: VGND w=1]]', 'b: [connection X0/b =>[signal: VNB w=1]]']]
X_Xhold15_0 Xhold15_a_391_47# Xhold15_a_285_47# VGND VGND sky130_fd_pr__nfet_01v8 w=420000u l=500000u
** [instance X1 of sky130_fd_pr__pfet_01v8_hvt, params={'w': '420000u', 'l': '500000u'} connections=['d: [connection X1/d =>[signal: VPWR w=1]]', 'g: [connection X1/g =>[signal: a_49_47# w=1]]', 's: [connection X1/s =>[signal: a_285_47# w=1]]', 'b: [connection X1/b =>[signal: VPB w=1]]']]
X_Xhold15_1 VPWR Xhold15_a_49_47# Xhold15_a_285_47# VPWR sky130_fd_pr__pfet_01v8_hvt w=420000u l=500000u
** [instance X2 of sky130_fd_pr__nfet_01v8, params={'w': '420000u', 'l': '150000u'} connections=['d: [connection X2/d =>[signal: a_49_47# w=1]]', 'g: [connection X2/g =>[signal: A w=1]]', 's: [connection X2/s =>[signal: VGND w=1]]', 'b: [connection X2/b =>[signal: VNB w=1]]']]
X_Xhold15_2 Xhold15_a_49_47# _46_/X VGND VGND sky130_fd_pr__nfet_01v8 w=420000u l=150000u
** [instance X3 of sky130_fd_pr__pfet_01v8_hvt, params={'w': '1e+06u', 'l': '150000u'} connections=['d: [connection X3/d =>[signal: VPWR w=1]]', 'g: [connection X3/g =>[signal: a_391_47# w=1]]', 's: [connection X3/s =>[signal: X w=1]]', 'b: [connection X3/b =>[signal: VPB w=1]]']]
X_Xhold15_3 VPWR Xhold15_a_391_47# _64_/D VPWR sky130_fd_pr__pfet_01v8_hvt w=1e+06u l=150000u
** [instance X4 of sky130_fd_pr__nfet_01v8, params={'w': '650000u', 'l': '150000u'} connections=['d: [connection X4/d =>[signal: VGND w=1]]', 'g: [connection X4/g =>[signal: a_391_47# w=1]]', 's: [connection X4/s =>[signal: X w=1]]', 'b: [connection X4/b =>[signal: VNB w=1]]']]
X_Xhold15_4 VGND Xhold15_a_391_47# _64_/D VGND sky130_fd_pr__nfet_01v8 w=650000u l=150000u
** [instance X5 of sky130_fd_pr__nfet_01v8, params={'w': '420000u', 'l': '500000u'} connections=['d: [connection X5/d =>[signal: VGND w=1]]', 'g: [connection X5/g =>[signal: a_49_47# w=1]]', 's: [connection X5/s =>[signal: a_285_47# w=1]]', 'b: [connection X5/b =>[signal: VNB w=1]]']]
X_Xhold15_5 VGND Xhold15_a_49_47# Xhold15_a_285_47# VGND sky130_fd_pr__nfet_01v8 w=420000u l=500000u
** [instance X6 of sky130_fd_pr__pfet_01v8_hvt, params={'w': '420000u', 'l': '500000u'} connections=['d: [connection X6/d =>[signal: a_391_47# w=1]]', 'g: [connection X6/g =>[signal: a_285_47# w=1]]', 's: [connection X6/s =>[signal: VPWR w=1]]', 'b: [connection X6/b =>[signal: VPB w=1]]']]
X_Xhold15_6 Xhold15_a_391_47# Xhold15_a_285_47# VPWR VPWR sky130_fd_pr__pfet_01v8_hvt w=420000u l=500000u
** [instance X7 of sky130_fd_pr__pfet_01v8_hvt, params={'w': '420000u', 'l': '150000u'} connections=['d: [connection X7/d =>[signal: a_49_47# w=1]]', 'g: [connection X7/g =>[signal: A w=1]]', 's: [connection X7/s =>[signal: VPWR w=1]]', 'b: [connection X7/b =>[signal: VPB w=1]]']]
X_Xhold15_7 Xhold15_a_49_47# _46_/X VPWR VPWR sky130_fd_pr__pfet_01v8_hvt w=420000u l=150000u

** replacing XFILLER_10_61 with the contents of sky130_fd_sc_hd__decap_3
** [instance X0 of sky130_fd_pr__pfet_01v8_hvt, params={'w': '870000u', 'l': '590000u'} connections=['d: [connection X0/d =>[signal: VPWR w=1]]', 'g: [connection X0/g =>[signal: VGND w=1]]', 's: [connection X0/s =>[signal: VPWR w=1]]', 'b: [connection X0/b =>[signal: VPB w=1]]']]
X_XFILLER_10_61_0 VPWR VGND VPWR VPWR sky130_fd_pr__pfet_01v8_hvt w=870000u l=590000u
** [instance X1 of sky130_fd_pr__nfet_01v8, params={'w': '550000u', 'l': '590000u'} connections=['d: [connection X1/d =>[signal: VGND w=1]]', 'g: [connection X1/g =>[signal: VPWR w=1]]', 's: [connection X1/s =>[signal: VGND w=1]]', 'b: [connection X1/b =>[signal: VNB w=1]]']]
X_XFILLER_10_61_1 VGND VPWR VGND VGND sky130_fd_pr__nfet_01v8 w=550000u l=590000u

** replacing Xhold26 with the contents of sky130_fd_sc_hd__dlygate4sd3_1
** [instance X0 of sky130_fd_pr__nfet_01v8, params={'w': '420000u', 'l': '500000u'} connections=['d: [connection X0/d =>[signal: a_391_47# w=1]]', 'g: [connection X0/g =>[signal: a_285_47# w=1]]', 's: [connection X0/s =>[signal: VGND w=1]]', 'b: [connection X0/b =>[signal: VNB w=1]]']]
X_Xhold26_0 Xhold26_a_391_47# Xhold26_a_285_47# VGND VGND sky130_fd_pr__nfet_01v8 w=420000u l=500000u
** [instance X1 of sky130_fd_pr__pfet_01v8_hvt, params={'w': '420000u', 'l': '500000u'} connections=['d: [connection X1/d =>[signal: VPWR w=1]]', 'g: [connection X1/g =>[signal: a_49_47# w=1]]', 's: [connection X1/s =>[signal: a_285_47# w=1]]', 'b: [connection X1/b =>[signal: VPB w=1]]']]
X_Xhold26_1 VPWR Xhold26_a_49_47# Xhold26_a_285_47# VPWR sky130_fd_pr__pfet_01v8_hvt w=420000u l=500000u
** [instance X2 of sky130_fd_pr__nfet_01v8, params={'w': '420000u', 'l': '150000u'} connections=['d: [connection X2/d =>[signal: a_49_47# w=1]]', 'g: [connection X2/g =>[signal: A w=1]]', 's: [connection X2/s =>[signal: VGND w=1]]', 'b: [connection X2/b =>[signal: VNB w=1]]']]
X_Xhold26_2 Xhold26_a_49_47# _73_/Q VGND VGND sky130_fd_pr__nfet_01v8 w=420000u l=150000u
** [instance X3 of sky130_fd_pr__pfet_01v8_hvt, params={'w': '1e+06u', 'l': '150000u'} connections=['d: [connection X3/d =>[signal: VPWR w=1]]', 'g: [connection X3/g =>[signal: a_391_47# w=1]]', 's: [connection X3/s =>[signal: X w=1]]', 'b: [connection X3/b =>[signal: VPB w=1]]']]
X_Xhold26_3 VPWR Xhold26_a_391_47# _55_/A0 VPWR sky130_fd_pr__pfet_01v8_hvt w=1e+06u l=150000u
** [instance X4 of sky130_fd_pr__nfet_01v8, params={'w': '650000u', 'l': '150000u'} connections=['d: [connection X4/d =>[signal: VGND w=1]]', 'g: [connection X4/g =>[signal: a_391_47# w=1]]', 's: [connection X4/s =>[signal: X w=1]]', 'b: [connection X4/b =>[signal: VNB w=1]]']]
X_Xhold26_4 VGND Xhold26_a_391_47# _55_/A0 VGND sky130_fd_pr__nfet_01v8 w=650000u l=150000u
** [instance X5 of sky130_fd_pr__nfet_01v8, params={'w': '420000u', 'l': '500000u'} connections=['d: [connection X5/d =>[signal: VGND w=1]]', 'g: [connection X5/g =>[signal: a_49_47# w=1]]', 's: [connection X5/s =>[signal: a_285_47# w=1]]', 'b: [connection X5/b =>[signal: VNB w=1]]']]
X_Xhold26_5 VGND Xhold26_a_49_47# Xhold26_a_285_47# VGND sky130_fd_pr__nfet_01v8 w=420000u l=500000u
** [instance X6 of sky130_fd_pr__pfet_01v8_hvt, params={'w': '420000u', 'l': '500000u'} connections=['d: [connection X6/d =>[signal: a_391_47# w=1]]', 'g: [connection X6/g =>[signal: a_285_47# w=1]]', 's: [connection X6/s =>[signal: VPWR w=1]]', 'b: [connection X6/b =>[signal: VPB w=1]]']]
X_Xhold26_6 Xhold26_a_391_47# Xhold26_a_285_47# VPWR VPWR sky130_fd_pr__pfet_01v8_hvt w=420000u l=500000u
** [instance X7 of sky130_fd_pr__pfet_01v8_hvt, params={'w': '420000u', 'l': '150000u'} connections=['d: [connection X7/d =>[signal: a_49_47# w=1]]', 'g: [connection X7/g =>[signal: A w=1]]', 's: [connection X7/s =>[signal: VPWR w=1]]', 'b: [connection X7/b =>[signal: VPB w=1]]']]
X_Xhold26_7 Xhold26_a_49_47# _73_/Q VPWR VPWR sky130_fd_pr__pfet_01v8_hvt w=420000u l=150000u

** replacing XFILLER_12_29 with the contents of sky130_fd_sc_hd__decap_3
** [instance X0 of sky130_fd_pr__pfet_01v8_hvt, params={'w': '870000u', 'l': '590000u'} connections=['d: [connection X0/d =>[signal: VPWR w=1]]', 'g: [connection X0/g =>[signal: VGND w=1]]', 's: [connection X0/s =>[signal: VPWR w=1]]', 'b: [connection X0/b =>[signal: VPB w=1]]']]
X_XFILLER_12_29_0 VPWR VGND VPWR VPWR sky130_fd_pr__pfet_01v8_hvt w=870000u l=590000u
** [instance X1 of sky130_fd_pr__nfet_01v8, params={'w': '550000u', 'l': '590000u'} connections=['d: [connection X1/d =>[signal: VGND w=1]]', 'g: [connection X1/g =>[signal: VPWR w=1]]', 's: [connection X1/s =>[signal: VGND w=1]]', 'b: [connection X1/b =>[signal: VNB w=1]]']]
X_XFILLER_12_29_1 VGND VPWR VGND VGND sky130_fd_pr__nfet_01v8 w=550000u l=590000u

** replacing X_41_ with the contents of sky130_fd_sc_hd__mux2_1
** [instance X0 of sky130_fd_pr__pfet_01v8_hvt, params={'w': '420000u', 'l': '150000u'} connections=['d: [connection X0/d =>[signal: VPWR w=1]]', 'g: [connection X0/g =>[signal: S w=1]]', 's: [connection X0/s =>[signal: a_218_374# w=1]]', 'b: [connection X0/b =>[signal: VPB w=1]]']]
X_X_41__0 VPWR _58_/S X_41__a_218_374# VPWR sky130_fd_pr__pfet_01v8_hvt w=420000u l=150000u
** [instance X1 of sky130_fd_pr__nfet_01v8, params={'w': '420000u', 'l': '150000u'} connections=['d: [connection X1/d =>[signal: a_76_199# w=1]]', 'g: [connection X1/g =>[signal: A0 w=1]]', 's: [connection X1/s =>[signal: a_439_47# w=1]]', 'b: [connection X1/b =>[signal: VNB w=1]]']]
X_X_41__1 X_41__a_76_199# _58_/A1 X_41__a_439_47# VGND sky130_fd_pr__nfet_01v8 w=420000u l=150000u
** [instance X2 of sky130_fd_pr__pfet_01v8_hvt, params={'w': '420000u', 'l': '150000u'} connections=['d: [connection X2/d =>[signal: a_535_374# w=1]]', 'g: [connection X2/g =>[signal: a_505_21# w=1]]', 's: [connection X2/s =>[signal: VPWR w=1]]', 'b: [connection X2/b =>[signal: VPB w=1]]']]
X_X_41__2 X_41__a_535_374# X_41__a_505_21# VPWR VPWR sky130_fd_pr__pfet_01v8_hvt w=420000u l=150000u
** [instance X3 of sky130_fd_pr__pfet_01v8_hvt, params={'w': '420000u', 'l': '150000u'} connections=['d: [connection X3/d =>[signal: VPWR w=1]]', 'g: [connection X3/g =>[signal: S w=1]]', 's: [connection X3/s =>[signal: a_505_21# w=1]]', 'b: [connection X3/b =>[signal: VPB w=1]]']]
X_X_41__3 VPWR _58_/S X_41__a_505_21# VPWR sky130_fd_pr__pfet_01v8_hvt w=420000u l=150000u
** [instance X4 of sky130_fd_pr__pfet_01v8_hvt, params={'w': '420000u', 'l': '150000u'} connections=['d: [connection X4/d =>[signal: a_76_199# w=1]]', 'g: [connection X4/g =>[signal: A1 w=1]]', 's: [connection X4/s =>[signal: a_535_374# w=1]]', 'b: [connection X4/b =>[signal: VPB w=1]]']]
X_X_41__4 X_41__a_76_199# _42_/A0 X_41__a_535_374# VPWR sky130_fd_pr__pfet_01v8_hvt w=420000u l=150000u
** [instance X5 of sky130_fd_pr__nfet_01v8, params={'w': '420000u', 'l': '150000u'} connections=['d: [connection X5/d =>[signal: a_218_47# w=1]]', 'g: [connection X5/g =>[signal: A1 w=1]]', 's: [connection X5/s =>[signal: a_76_199# w=1]]', 'b: [connection X5/b =>[signal: VNB w=1]]']]
X_X_41__5 X_41__a_218_47# _42_/A0 X_41__a_76_199# VGND sky130_fd_pr__nfet_01v8 w=420000u l=150000u
** [instance X6 of sky130_fd_pr__pfet_01v8_hvt, params={'w': '420000u', 'l': '150000u'} connections=['d: [connection X6/d =>[signal: a_218_374# w=1]]', 'g: [connection X6/g =>[signal: A0 w=1]]', 's: [connection X6/s =>[signal: a_76_199# w=1]]', 'b: [connection X6/b =>[signal: VPB w=1]]']]
X_X_41__6 X_41__a_218_374# _58_/A1 X_41__a_76_199# VPWR sky130_fd_pr__pfet_01v8_hvt w=420000u l=150000u
** [instance X7 of sky130_fd_pr__nfet_01v8, params={'w': '650000u', 'l': '150000u'} connections=['d: [connection X7/d =>[signal: X w=1]]', 'g: [connection X7/g =>[signal: a_76_199# w=1]]', 's: [connection X7/s =>[signal: VGND w=1]]', 'b: [connection X7/b =>[signal: VNB w=1]]']]
X_X_41__7 _59_/D X_41__a_76_199# VGND VGND sky130_fd_pr__nfet_01v8 w=650000u l=150000u
** [instance X8 of sky130_fd_pr__pfet_01v8_hvt, params={'w': '1e+06u', 'l': '150000u'} connections=['d: [connection X8/d =>[signal: X w=1]]', 'g: [connection X8/g =>[signal: a_76_199# w=1]]', 's: [connection X8/s =>[signal: VPWR w=1]]', 'b: [connection X8/b =>[signal: VPB w=1]]']]
X_X_41__8 _59_/D X_41__a_76_199# VPWR VPWR sky130_fd_pr__pfet_01v8_hvt w=1e+06u l=150000u
** [instance X9 of sky130_fd_pr__nfet_01v8, params={'w': '420000u', 'l': '150000u'} connections=['d: [connection X9/d =>[signal: VGND w=1]]', 'g: [connection X9/g =>[signal: S w=1]]', 's: [connection X9/s =>[signal: a_218_47# w=1]]', 'b: [connection X9/b =>[signal: VNB w=1]]']]
X_X_41__9 VGND _58_/S X_41__a_218_47# VGND sky130_fd_pr__nfet_01v8 w=420000u l=150000u
** [instance X10 of sky130_fd_pr__nfet_01v8, params={'w': '420000u', 'l': '150000u'} connections=['d: [connection X10/d =>[signal: VGND w=1]]', 'g: [connection X10/g =>[signal: S w=1]]', 's: [connection X10/s =>[signal: a_505_21# w=1]]', 'b: [connection X10/b =>[signal: VNB w=1]]']]
X_X_41__10 VGND _58_/S X_41__a_505_21# VGND sky130_fd_pr__nfet_01v8 w=420000u l=150000u
** [instance X11 of sky130_fd_pr__nfet_01v8, params={'w': '420000u', 'l': '150000u'} connections=['d: [connection X11/d =>[signal: a_439_47# w=1]]', 'g: [connection X11/g =>[signal: a_505_21# w=1]]', 's: [connection X11/s =>[signal: VGND w=1]]', 'b: [connection X11/b =>[signal: VNB w=1]]']]
X_X_41__11 X_41__a_439_47# X_41__a_505_21# VGND VGND sky130_fd_pr__nfet_01v8 w=420000u l=150000u

** replacing Xhold16 with the contents of sky130_fd_sc_hd__dlygate4sd3_1
** [instance X0 of sky130_fd_pr__nfet_01v8, params={'w': '420000u', 'l': '500000u'} connections=['d: [connection X0/d =>[signal: a_391_47# w=1]]', 'g: [connection X0/g =>[signal: a_285_47# w=1]]', 's: [connection X0/s =>[signal: VGND w=1]]', 'b: [connection X0/b =>[signal: VNB w=1]]']]
X_Xhold16_0 Xhold16_a_391_47# Xhold16_a_285_47# VGND VGND sky130_fd_pr__nfet_01v8 w=420000u l=500000u
** [instance X1 of sky130_fd_pr__pfet_01v8_hvt, params={'w': '420000u', 'l': '500000u'} connections=['d: [connection X1/d =>[signal: VPWR w=1]]', 'g: [connection X1/g =>[signal: a_49_47# w=1]]', 's: [connection X1/s =>[signal: a_285_47# w=1]]', 'b: [connection X1/b =>[signal: VPB w=1]]']]
X_Xhold16_1 VPWR Xhold16_a_49_47# Xhold16_a_285_47# VPWR sky130_fd_pr__pfet_01v8_hvt w=420000u l=500000u
** [instance X2 of sky130_fd_pr__nfet_01v8, params={'w': '420000u', 'l': '150000u'} connections=['d: [connection X2/d =>[signal: a_49_47# w=1]]', 'g: [connection X2/g =>[signal: A w=1]]', 's: [connection X2/s =>[signal: VGND w=1]]', 'b: [connection X2/b =>[signal: VNB w=1]]']]
X_Xhold16_2 Xhold16_a_49_47# _60_/Q VGND VGND sky130_fd_pr__nfet_01v8 w=420000u l=150000u
** [instance X3 of sky130_fd_pr__pfet_01v8_hvt, params={'w': '1e+06u', 'l': '150000u'} connections=['d: [connection X3/d =>[signal: VPWR w=1]]', 'g: [connection X3/g =>[signal: a_391_47# w=1]]', 's: [connection X3/s =>[signal: X w=1]]', 'b: [connection X3/b =>[signal: VPB w=1]]']]
X_Xhold16_3 VPWR Xhold16_a_391_47# _42_/A0 VPWR sky130_fd_pr__pfet_01v8_hvt w=1e+06u l=150000u
** [instance X4 of sky130_fd_pr__nfet_01v8, params={'w': '650000u', 'l': '150000u'} connections=['d: [connection X4/d =>[signal: VGND w=1]]', 'g: [connection X4/g =>[signal: a_391_47# w=1]]', 's: [connection X4/s =>[signal: X w=1]]', 'b: [connection X4/b =>[signal: VNB w=1]]']]
X_Xhold16_4 VGND Xhold16_a_391_47# _42_/A0 VGND sky130_fd_pr__nfet_01v8 w=650000u l=150000u
** [instance X5 of sky130_fd_pr__nfet_01v8, params={'w': '420000u', 'l': '500000u'} connections=['d: [connection X5/d =>[signal: VGND w=1]]', 'g: [connection X5/g =>[signal: a_49_47# w=1]]', 's: [connection X5/s =>[signal: a_285_47# w=1]]', 'b: [connection X5/b =>[signal: VNB w=1]]']]
X_Xhold16_5 VGND Xhold16_a_49_47# Xhold16_a_285_47# VGND sky130_fd_pr__nfet_01v8 w=420000u l=500000u
** [instance X6 of sky130_fd_pr__pfet_01v8_hvt, params={'w': '420000u', 'l': '500000u'} connections=['d: [connection X6/d =>[signal: a_391_47# w=1]]', 'g: [connection X6/g =>[signal: a_285_47# w=1]]', 's: [connection X6/s =>[signal: VPWR w=1]]', 'b: [connection X6/b =>[signal: VPB w=1]]']]
X_Xhold16_6 Xhold16_a_391_47# Xhold16_a_285_47# VPWR VPWR sky130_fd_pr__pfet_01v8_hvt w=420000u l=500000u
** [instance X7 of sky130_fd_pr__pfet_01v8_hvt, params={'w': '420000u', 'l': '150000u'} connections=['d: [connection X7/d =>[signal: a_49_47# w=1]]', 'g: [connection X7/g =>[signal: A w=1]]', 's: [connection X7/s =>[signal: VPWR w=1]]', 'b: [connection X7/b =>[signal: VPB w=1]]']]
X_Xhold16_7 Xhold16_a_49_47# _60_/Q VPWR VPWR sky130_fd_pr__pfet_01v8_hvt w=420000u l=150000u

** replacing Xhold27 with the contents of sky130_fd_sc_hd__dlygate4sd3_1
** [instance X0 of sky130_fd_pr__nfet_01v8, params={'w': '420000u', 'l': '500000u'} connections=['d: [connection X0/d =>[signal: a_391_47# w=1]]', 'g: [connection X0/g =>[signal: a_285_47# w=1]]', 's: [connection X0/s =>[signal: VGND w=1]]', 'b: [connection X0/b =>[signal: VNB w=1]]']]
X_Xhold27_0 Xhold27_a_391_47# Xhold27_a_285_47# VGND VGND sky130_fd_pr__nfet_01v8 w=420000u l=500000u
** [instance X1 of sky130_fd_pr__pfet_01v8_hvt, params={'w': '420000u', 'l': '500000u'} connections=['d: [connection X1/d =>[signal: VPWR w=1]]', 'g: [connection X1/g =>[signal: a_49_47# w=1]]', 's: [connection X1/s =>[signal: a_285_47# w=1]]', 'b: [connection X1/b =>[signal: VPB w=1]]']]
X_Xhold27_1 VPWR Xhold27_a_49_47# Xhold27_a_285_47# VPWR sky130_fd_pr__pfet_01v8_hvt w=420000u l=500000u
** [instance X2 of sky130_fd_pr__nfet_01v8, params={'w': '420000u', 'l': '150000u'} connections=['d: [connection X2/d =>[signal: a_49_47# w=1]]', 'g: [connection X2/g =>[signal: A w=1]]', 's: [connection X2/s =>[signal: VGND w=1]]', 'b: [connection X2/b =>[signal: VNB w=1]]']]
X_Xhold27_2 Xhold27_a_49_47# _62_/Q VGND VGND sky130_fd_pr__nfet_01v8 w=420000u l=150000u
** [instance X3 of sky130_fd_pr__pfet_01v8_hvt, params={'w': '1e+06u', 'l': '150000u'} connections=['d: [connection X3/d =>[signal: VPWR w=1]]', 'g: [connection X3/g =>[signal: a_391_47# w=1]]', 's: [connection X3/s =>[signal: X w=1]]', 'b: [connection X3/b =>[signal: VPB w=1]]']]
X_Xhold27_3 VPWR Xhold27_a_391_47# _44_/A0 VPWR sky130_fd_pr__pfet_01v8_hvt w=1e+06u l=150000u
** [instance X4 of sky130_fd_pr__nfet_01v8, params={'w': '650000u', 'l': '150000u'} connections=['d: [connection X4/d =>[signal: VGND w=1]]', 'g: [connection X4/g =>[signal: a_391_47# w=1]]', 's: [connection X4/s =>[signal: X w=1]]', 'b: [connection X4/b =>[signal: VNB w=1]]']]
X_Xhold27_4 VGND Xhold27_a_391_47# _44_/A0 VGND sky130_fd_pr__nfet_01v8 w=650000u l=150000u
** [instance X5 of sky130_fd_pr__nfet_01v8, params={'w': '420000u', 'l': '500000u'} connections=['d: [connection X5/d =>[signal: VGND w=1]]', 'g: [connection X5/g =>[signal: a_49_47# w=1]]', 's: [connection X5/s =>[signal: a_285_47# w=1]]', 'b: [connection X5/b =>[signal: VNB w=1]]']]
X_Xhold27_5 VGND Xhold27_a_49_47# Xhold27_a_285_47# VGND sky130_fd_pr__nfet_01v8 w=420000u l=500000u
** [instance X6 of sky130_fd_pr__pfet_01v8_hvt, params={'w': '420000u', 'l': '500000u'} connections=['d: [connection X6/d =>[signal: a_391_47# w=1]]', 'g: [connection X6/g =>[signal: a_285_47# w=1]]', 's: [connection X6/s =>[signal: VPWR w=1]]', 'b: [connection X6/b =>[signal: VPB w=1]]']]
X_Xhold27_6 Xhold27_a_391_47# Xhold27_a_285_47# VPWR VPWR sky130_fd_pr__pfet_01v8_hvt w=420000u l=500000u
** [instance X7 of sky130_fd_pr__pfet_01v8_hvt, params={'w': '420000u', 'l': '150000u'} connections=['d: [connection X7/d =>[signal: a_49_47# w=1]]', 'g: [connection X7/g =>[signal: A w=1]]', 's: [connection X7/s =>[signal: VPWR w=1]]', 'b: [connection X7/b =>[signal: VPB w=1]]']]
X_Xhold27_7 Xhold27_a_49_47# _62_/Q VPWR VPWR sky130_fd_pr__pfet_01v8_hvt w=420000u l=150000u

** replacing XFILLER_13_51 with the contents of sky130_fd_sc_hd__decap_3
** [instance X0 of sky130_fd_pr__pfet_01v8_hvt, params={'w': '870000u', 'l': '590000u'} connections=['d: [connection X0/d =>[signal: VPWR w=1]]', 'g: [connection X0/g =>[signal: VGND w=1]]', 's: [connection X0/s =>[signal: VPWR w=1]]', 'b: [connection X0/b =>[signal: VPB w=1]]']]
X_XFILLER_13_51_0 VPWR VGND VPWR VPWR sky130_fd_pr__pfet_01v8_hvt w=870000u l=590000u
** [instance X1 of sky130_fd_pr__nfet_01v8, params={'w': '550000u', 'l': '590000u'} connections=['d: [connection X1/d =>[signal: VGND w=1]]', 'g: [connection X1/g =>[signal: VPWR w=1]]', 's: [connection X1/s =>[signal: VGND w=1]]', 'b: [connection X1/b =>[signal: VNB w=1]]']]
X_XFILLER_13_51_1 VGND VPWR VGND VGND sky130_fd_pr__nfet_01v8 w=550000u l=590000u

** replacing X_40_ with the contents of sky130_fd_sc_hd__mux2_1
** [instance X0 of sky130_fd_pr__pfet_01v8_hvt, params={'w': '420000u', 'l': '150000u'} connections=['d: [connection X0/d =>[signal: VPWR w=1]]', 'g: [connection X0/g =>[signal: S w=1]]', 's: [connection X0/s =>[signal: a_218_374# w=1]]', 'b: [connection X0/b =>[signal: VPB w=1]]']]
X_X_40__0 VPWR _76_/Q X_40__a_218_374# VPWR sky130_fd_pr__pfet_01v8_hvt w=420000u l=150000u
** [instance X1 of sky130_fd_pr__nfet_01v8, params={'w': '420000u', 'l': '150000u'} connections=['d: [connection X1/d =>[signal: a_76_199# w=1]]', 'g: [connection X1/g =>[signal: A0 w=1]]', 's: [connection X1/s =>[signal: a_439_47# w=1]]', 'b: [connection X1/b =>[signal: VNB w=1]]']]
X_X_40__1 X_40__a_76_199# _38_/X X_40__a_439_47# VGND sky130_fd_pr__nfet_01v8 w=420000u l=150000u
** [instance X2 of sky130_fd_pr__pfet_01v8_hvt, params={'w': '420000u', 'l': '150000u'} connections=['d: [connection X2/d =>[signal: a_535_374# w=1]]', 'g: [connection X2/g =>[signal: a_505_21# w=1]]', 's: [connection X2/s =>[signal: VPWR w=1]]', 'b: [connection X2/b =>[signal: VPB w=1]]']]
X_X_40__2 X_40__a_535_374# X_40__a_505_21# VPWR VPWR sky130_fd_pr__pfet_01v8_hvt w=420000u l=150000u
** [instance X3 of sky130_fd_pr__pfet_01v8_hvt, params={'w': '420000u', 'l': '150000u'} connections=['d: [connection X3/d =>[signal: VPWR w=1]]', 'g: [connection X3/g =>[signal: S w=1]]', 's: [connection X3/s =>[signal: a_505_21# w=1]]', 'b: [connection X3/b =>[signal: VPB w=1]]']]
X_X_40__3 VPWR _76_/Q X_40__a_505_21# VPWR sky130_fd_pr__pfet_01v8_hvt w=420000u l=150000u
** [instance X4 of sky130_fd_pr__pfet_01v8_hvt, params={'w': '420000u', 'l': '150000u'} connections=['d: [connection X4/d =>[signal: a_76_199# w=1]]', 'g: [connection X4/g =>[signal: A1 w=1]]', 's: [connection X4/s =>[signal: a_535_374# w=1]]', 'b: [connection X4/b =>[signal: VPB w=1]]']]
X_X_40__4 X_40__a_76_199# _40_/A1 X_40__a_535_374# VPWR sky130_fd_pr__pfet_01v8_hvt w=420000u l=150000u
** [instance X5 of sky130_fd_pr__nfet_01v8, params={'w': '420000u', 'l': '150000u'} connections=['d: [connection X5/d =>[signal: a_218_47# w=1]]', 'g: [connection X5/g =>[signal: A1 w=1]]', 's: [connection X5/s =>[signal: a_76_199# w=1]]', 'b: [connection X5/b =>[signal: VNB w=1]]']]
X_X_40__5 X_40__a_218_47# _40_/A1 X_40__a_76_199# VGND sky130_fd_pr__nfet_01v8 w=420000u l=150000u
** [instance X6 of sky130_fd_pr__pfet_01v8_hvt, params={'w': '420000u', 'l': '150000u'} connections=['d: [connection X6/d =>[signal: a_218_374# w=1]]', 'g: [connection X6/g =>[signal: A0 w=1]]', 's: [connection X6/s =>[signal: a_76_199# w=1]]', 'b: [connection X6/b =>[signal: VPB w=1]]']]
X_X_40__6 X_40__a_218_374# _38_/X X_40__a_76_199# VPWR sky130_fd_pr__pfet_01v8_hvt w=420000u l=150000u
** [instance X7 of sky130_fd_pr__nfet_01v8, params={'w': '650000u', 'l': '150000u'} connections=['d: [connection X7/d =>[signal: X w=1]]', 'g: [connection X7/g =>[signal: a_76_199# w=1]]', 's: [connection X7/s =>[signal: VGND w=1]]', 'b: [connection X7/b =>[signal: VNB w=1]]']]
X_X_40__7 _40_/X X_40__a_76_199# VGND VGND sky130_fd_pr__nfet_01v8 w=650000u l=150000u
** [instance X8 of sky130_fd_pr__pfet_01v8_hvt, params={'w': '1e+06u', 'l': '150000u'} connections=['d: [connection X8/d =>[signal: X w=1]]', 'g: [connection X8/g =>[signal: a_76_199# w=1]]', 's: [connection X8/s =>[signal: VPWR w=1]]', 'b: [connection X8/b =>[signal: VPB w=1]]']]
X_X_40__8 _40_/X X_40__a_76_199# VPWR VPWR sky130_fd_pr__pfet_01v8_hvt w=1e+06u l=150000u
** [instance X9 of sky130_fd_pr__nfet_01v8, params={'w': '420000u', 'l': '150000u'} connections=['d: [connection X9/d =>[signal: VGND w=1]]', 'g: [connection X9/g =>[signal: S w=1]]', 's: [connection X9/s =>[signal: a_218_47# w=1]]', 'b: [connection X9/b =>[signal: VNB w=1]]']]
X_X_40__9 VGND _76_/Q X_40__a_218_47# VGND sky130_fd_pr__nfet_01v8 w=420000u l=150000u
** [instance X10 of sky130_fd_pr__nfet_01v8, params={'w': '420000u', 'l': '150000u'} connections=['d: [connection X10/d =>[signal: VGND w=1]]', 'g: [connection X10/g =>[signal: S w=1]]', 's: [connection X10/s =>[signal: a_505_21# w=1]]', 'b: [connection X10/b =>[signal: VNB w=1]]']]
X_X_40__10 VGND _76_/Q X_40__a_505_21# VGND sky130_fd_pr__nfet_01v8 w=420000u l=150000u
** [instance X11 of sky130_fd_pr__nfet_01v8, params={'w': '420000u', 'l': '150000u'} connections=['d: [connection X11/d =>[signal: a_439_47# w=1]]', 'g: [connection X11/g =>[signal: a_505_21# w=1]]', 's: [connection X11/s =>[signal: VGND w=1]]', 'b: [connection X11/b =>[signal: VNB w=1]]']]
X_X_40__11 X_40__a_439_47# X_40__a_505_21# VGND VGND sky130_fd_pr__nfet_01v8 w=420000u l=150000u

** replacing Xhold28 with the contents of sky130_fd_sc_hd__dlygate4sd3_1
** [instance X0 of sky130_fd_pr__nfet_01v8, params={'w': '420000u', 'l': '500000u'} connections=['d: [connection X0/d =>[signal: a_391_47# w=1]]', 'g: [connection X0/g =>[signal: a_285_47# w=1]]', 's: [connection X0/s =>[signal: VGND w=1]]', 'b: [connection X0/b =>[signal: VNB w=1]]']]
X_Xhold28_0 Xhold28_a_391_47# Xhold28_a_285_47# VGND VGND sky130_fd_pr__nfet_01v8 w=420000u l=500000u
** [instance X1 of sky130_fd_pr__pfet_01v8_hvt, params={'w': '420000u', 'l': '500000u'} connections=['d: [connection X1/d =>[signal: VPWR w=1]]', 'g: [connection X1/g =>[signal: a_49_47# w=1]]', 's: [connection X1/s =>[signal: a_285_47# w=1]]', 'b: [connection X1/b =>[signal: VPB w=1]]']]
X_Xhold28_1 VPWR Xhold28_a_49_47# Xhold28_a_285_47# VPWR sky130_fd_pr__pfet_01v8_hvt w=420000u l=500000u
** [instance X2 of sky130_fd_pr__nfet_01v8, params={'w': '420000u', 'l': '150000u'} connections=['d: [connection X2/d =>[signal: a_49_47# w=1]]', 'g: [connection X2/g =>[signal: A w=1]]', 's: [connection X2/s =>[signal: VGND w=1]]', 'b: [connection X2/b =>[signal: VNB w=1]]']]
X_Xhold28_2 Xhold28_a_49_47# _76_/Q VGND VGND sky130_fd_pr__nfet_01v8 w=420000u l=150000u
** [instance X3 of sky130_fd_pr__pfet_01v8_hvt, params={'w': '1e+06u', 'l': '150000u'} connections=['d: [connection X3/d =>[signal: VPWR w=1]]', 'g: [connection X3/g =>[signal: a_391_47# w=1]]', 's: [connection X3/s =>[signal: X w=1]]', 'b: [connection X3/b =>[signal: VPB w=1]]']]
X_Xhold28_3 VPWR Xhold28_a_391_47# _58_/A0 VPWR sky130_fd_pr__pfet_01v8_hvt w=1e+06u l=150000u
** [instance X4 of sky130_fd_pr__nfet_01v8, params={'w': '650000u', 'l': '150000u'} connections=['d: [connection X4/d =>[signal: VGND w=1]]', 'g: [connection X4/g =>[signal: a_391_47# w=1]]', 's: [connection X4/s =>[signal: X w=1]]', 'b: [connection X4/b =>[signal: VNB w=1]]']]
X_Xhold28_4 VGND Xhold28_a_391_47# _58_/A0 VGND sky130_fd_pr__nfet_01v8 w=650000u l=150000u
** [instance X5 of sky130_fd_pr__nfet_01v8, params={'w': '420000u', 'l': '500000u'} connections=['d: [connection X5/d =>[signal: VGND w=1]]', 'g: [connection X5/g =>[signal: a_49_47# w=1]]', 's: [connection X5/s =>[signal: a_285_47# w=1]]', 'b: [connection X5/b =>[signal: VNB w=1]]']]
X_Xhold28_5 VGND Xhold28_a_49_47# Xhold28_a_285_47# VGND sky130_fd_pr__nfet_01v8 w=420000u l=500000u
** [instance X6 of sky130_fd_pr__pfet_01v8_hvt, params={'w': '420000u', 'l': '500000u'} connections=['d: [connection X6/d =>[signal: a_391_47# w=1]]', 'g: [connection X6/g =>[signal: a_285_47# w=1]]', 's: [connection X6/s =>[signal: VPWR w=1]]', 'b: [connection X6/b =>[signal: VPB w=1]]']]
X_Xhold28_6 Xhold28_a_391_47# Xhold28_a_285_47# VPWR VPWR sky130_fd_pr__pfet_01v8_hvt w=420000u l=500000u
** [instance X7 of sky130_fd_pr__pfet_01v8_hvt, params={'w': '420000u', 'l': '150000u'} connections=['d: [connection X7/d =>[signal: a_49_47# w=1]]', 'g: [connection X7/g =>[signal: A w=1]]', 's: [connection X7/s =>[signal: VPWR w=1]]', 'b: [connection X7/b =>[signal: VPB w=1]]']]
X_Xhold28_7 Xhold28_a_49_47# _76_/Q VPWR VPWR sky130_fd_pr__pfet_01v8_hvt w=420000u l=150000u

** replacing Xhold17 with the contents of sky130_fd_sc_hd__dlygate4sd3_1
** [instance X0 of sky130_fd_pr__nfet_01v8, params={'w': '420000u', 'l': '500000u'} connections=['d: [connection X0/d =>[signal: a_391_47# w=1]]', 'g: [connection X0/g =>[signal: a_285_47# w=1]]', 's: [connection X0/s =>[signal: VGND w=1]]', 'b: [connection X0/b =>[signal: VNB w=1]]']]
X_Xhold17_0 Xhold17_a_391_47# Xhold17_a_285_47# VGND VGND sky130_fd_pr__nfet_01v8 w=420000u l=500000u
** [instance X1 of sky130_fd_pr__pfet_01v8_hvt, params={'w': '420000u', 'l': '500000u'} connections=['d: [connection X1/d =>[signal: VPWR w=1]]', 'g: [connection X1/g =>[signal: a_49_47# w=1]]', 's: [connection X1/s =>[signal: a_285_47# w=1]]', 'b: [connection X1/b =>[signal: VPB w=1]]']]
X_Xhold17_1 VPWR Xhold17_a_49_47# Xhold17_a_285_47# VPWR sky130_fd_pr__pfet_01v8_hvt w=420000u l=500000u
** [instance X2 of sky130_fd_pr__nfet_01v8, params={'w': '420000u', 'l': '150000u'} connections=['d: [connection X2/d =>[signal: a_49_47# w=1]]', 'g: [connection X2/g =>[signal: A w=1]]', 's: [connection X2/s =>[signal: VGND w=1]]', 'b: [connection X2/b =>[signal: VNB w=1]]']]
X_Xhold17_2 Xhold17_a_49_47# _42_/X VGND VGND sky130_fd_pr__nfet_01v8 w=420000u l=150000u
** [instance X3 of sky130_fd_pr__pfet_01v8_hvt, params={'w': '1e+06u', 'l': '150000u'} connections=['d: [connection X3/d =>[signal: VPWR w=1]]', 'g: [connection X3/g =>[signal: a_391_47# w=1]]', 's: [connection X3/s =>[signal: X w=1]]', 'b: [connection X3/b =>[signal: VPB w=1]]']]
X_Xhold17_3 VPWR Xhold17_a_391_47# _60_/D VPWR sky130_fd_pr__pfet_01v8_hvt w=1e+06u l=150000u
** [instance X4 of sky130_fd_pr__nfet_01v8, params={'w': '650000u', 'l': '150000u'} connections=['d: [connection X4/d =>[signal: VGND w=1]]', 'g: [connection X4/g =>[signal: a_391_47# w=1]]', 's: [connection X4/s =>[signal: X w=1]]', 'b: [connection X4/b =>[signal: VNB w=1]]']]
X_Xhold17_4 VGND Xhold17_a_391_47# _60_/D VGND sky130_fd_pr__nfet_01v8 w=650000u l=150000u
** [instance X5 of sky130_fd_pr__nfet_01v8, params={'w': '420000u', 'l': '500000u'} connections=['d: [connection X5/d =>[signal: VGND w=1]]', 'g: [connection X5/g =>[signal: a_49_47# w=1]]', 's: [connection X5/s =>[signal: a_285_47# w=1]]', 'b: [connection X5/b =>[signal: VNB w=1]]']]
X_Xhold17_5 VGND Xhold17_a_49_47# Xhold17_a_285_47# VGND sky130_fd_pr__nfet_01v8 w=420000u l=500000u
** [instance X6 of sky130_fd_pr__pfet_01v8_hvt, params={'w': '420000u', 'l': '500000u'} connections=['d: [connection X6/d =>[signal: a_391_47# w=1]]', 'g: [connection X6/g =>[signal: a_285_47# w=1]]', 's: [connection X6/s =>[signal: VPWR w=1]]', 'b: [connection X6/b =>[signal: VPB w=1]]']]
X_Xhold17_6 Xhold17_a_391_47# Xhold17_a_285_47# VPWR VPWR sky130_fd_pr__pfet_01v8_hvt w=420000u l=500000u
** [instance X7 of sky130_fd_pr__pfet_01v8_hvt, params={'w': '420000u', 'l': '150000u'} connections=['d: [connection X7/d =>[signal: a_49_47# w=1]]', 'g: [connection X7/g =>[signal: A w=1]]', 's: [connection X7/s =>[signal: VPWR w=1]]', 'b: [connection X7/b =>[signal: VPB w=1]]']]
X_Xhold17_7 Xhold17_a_49_47# _42_/X VPWR VPWR sky130_fd_pr__pfet_01v8_hvt w=420000u l=150000u

** replacing XFILLER_1_54 with the contents of sky130_fd_sc_hd__fill_2

** replacing XPHY_EDGE_ROW_11_Left_25 with the contents of sky130_fd_sc_hd__decap_3
** [instance X0 of sky130_fd_pr__pfet_01v8_hvt, params={'w': '870000u', 'l': '590000u'} connections=['d: [connection X0/d =>[signal: VPWR w=1]]', 'g: [connection X0/g =>[signal: VGND w=1]]', 's: [connection X0/s =>[signal: VPWR w=1]]', 'b: [connection X0/b =>[signal: VPB w=1]]']]
X_XPHY_EDGE_ROW_11_Left_25_0 VPWR VGND VPWR VPWR sky130_fd_pr__pfet_01v8_hvt w=870000u l=590000u
** [instance X1 of sky130_fd_pr__nfet_01v8, params={'w': '550000u', 'l': '590000u'} connections=['d: [connection X1/d =>[signal: VGND w=1]]', 'g: [connection X1/g =>[signal: VPWR w=1]]', 's: [connection X1/s =>[signal: VGND w=1]]', 'b: [connection X1/b =>[signal: VNB w=1]]']]
X_XPHY_EDGE_ROW_11_Left_25_1 VGND VPWR VGND VGND sky130_fd_pr__nfet_01v8 w=550000u l=590000u

** replacing XPHY_EDGE_ROW_5_Right_5 with the contents of sky130_fd_sc_hd__decap_3
** [instance X0 of sky130_fd_pr__pfet_01v8_hvt, params={'w': '870000u', 'l': '590000u'} connections=['d: [connection X0/d =>[signal: VPWR w=1]]', 'g: [connection X0/g =>[signal: VGND w=1]]', 's: [connection X0/s =>[signal: VPWR w=1]]', 'b: [connection X0/b =>[signal: VPB w=1]]']]
X_XPHY_EDGE_ROW_5_Right_5_0 VPWR VGND VPWR VPWR sky130_fd_pr__pfet_01v8_hvt w=870000u l=590000u
** [instance X1 of sky130_fd_pr__nfet_01v8, params={'w': '550000u', 'l': '590000u'} connections=['d: [connection X1/d =>[signal: VGND w=1]]', 'g: [connection X1/g =>[signal: VPWR w=1]]', 's: [connection X1/s =>[signal: VGND w=1]]', 'b: [connection X1/b =>[signal: VNB w=1]]']]
X_XPHY_EDGE_ROW_5_Right_5_1 VGND VPWR VGND VGND sky130_fd_pr__nfet_01v8 w=550000u l=590000u

** replacing XTAP_TAPCELL_ROW_3_32 with the contents of sky130_fd_sc_hd__tapvpwrvgnd_1

** replacing XFILLER_13_63 with the contents of sky130_fd_sc_hd__decap_3
** [instance X0 of sky130_fd_pr__pfet_01v8_hvt, params={'w': '870000u', 'l': '590000u'} connections=['d: [connection X0/d =>[signal: VPWR w=1]]', 'g: [connection X0/g =>[signal: VGND w=1]]', 's: [connection X0/s =>[signal: VPWR w=1]]', 'b: [connection X0/b =>[signal: VPB w=1]]']]
X_XFILLER_13_63_0 VPWR VGND VPWR VPWR sky130_fd_pr__pfet_01v8_hvt w=870000u l=590000u
** [instance X1 of sky130_fd_pr__nfet_01v8, params={'w': '550000u', 'l': '590000u'} connections=['d: [connection X1/d =>[signal: VGND w=1]]', 'g: [connection X1/g =>[signal: VPWR w=1]]', 's: [connection X1/s =>[signal: VGND w=1]]', 'b: [connection X1/b =>[signal: VNB w=1]]']]
X_XFILLER_13_63_1 VGND VPWR VGND VGND sky130_fd_pr__nfet_01v8 w=550000u l=590000u

** replacing Xhold18 with the contents of sky130_fd_sc_hd__dlygate4sd3_1
** [instance X0 of sky130_fd_pr__nfet_01v8, params={'w': '420000u', 'l': '500000u'} connections=['d: [connection X0/d =>[signal: a_391_47# w=1]]', 'g: [connection X0/g =>[signal: a_285_47# w=1]]', 's: [connection X0/s =>[signal: VGND w=1]]', 'b: [connection X0/b =>[signal: VNB w=1]]']]
X_Xhold18_0 Xhold18_a_391_47# Xhold18_a_285_47# VGND VGND sky130_fd_pr__nfet_01v8 w=420000u l=500000u
** [instance X1 of sky130_fd_pr__pfet_01v8_hvt, params={'w': '420000u', 'l': '500000u'} connections=['d: [connection X1/d =>[signal: VPWR w=1]]', 'g: [connection X1/g =>[signal: a_49_47# w=1]]', 's: [connection X1/s =>[signal: a_285_47# w=1]]', 'b: [connection X1/b =>[signal: VPB w=1]]']]
X_Xhold18_1 VPWR Xhold18_a_49_47# Xhold18_a_285_47# VPWR sky130_fd_pr__pfet_01v8_hvt w=420000u l=500000u
** [instance X2 of sky130_fd_pr__nfet_01v8, params={'w': '420000u', 'l': '150000u'} connections=['d: [connection X2/d =>[signal: a_49_47# w=1]]', 'g: [connection X2/g =>[signal: A w=1]]', 's: [connection X2/s =>[signal: VGND w=1]]', 'b: [connection X2/b =>[signal: VNB w=1]]']]
X_Xhold18_2 Xhold18_a_49_47# _67_/Q VGND VGND sky130_fd_pr__nfet_01v8 w=420000u l=150000u
** [instance X3 of sky130_fd_pr__pfet_01v8_hvt, params={'w': '1e+06u', 'l': '150000u'} connections=['d: [connection X3/d =>[signal: VPWR w=1]]', 'g: [connection X3/g =>[signal: a_391_47# w=1]]', 's: [connection X3/s =>[signal: X w=1]]', 'b: [connection X3/b =>[signal: VPB w=1]]']]
X_Xhold18_3 VPWR Xhold18_a_391_47# _49_/A0 VPWR sky130_fd_pr__pfet_01v8_hvt w=1e+06u l=150000u
** [instance X4 of sky130_fd_pr__nfet_01v8, params={'w': '650000u', 'l': '150000u'} connections=['d: [connection X4/d =>[signal: VGND w=1]]', 'g: [connection X4/g =>[signal: a_391_47# w=1]]', 's: [connection X4/s =>[signal: X w=1]]', 'b: [connection X4/b =>[signal: VNB w=1]]']]
X_Xhold18_4 VGND Xhold18_a_391_47# _49_/A0 VGND sky130_fd_pr__nfet_01v8 w=650000u l=150000u
** [instance X5 of sky130_fd_pr__nfet_01v8, params={'w': '420000u', 'l': '500000u'} connections=['d: [connection X5/d =>[signal: VGND w=1]]', 'g: [connection X5/g =>[signal: a_49_47# w=1]]', 's: [connection X5/s =>[signal: a_285_47# w=1]]', 'b: [connection X5/b =>[signal: VNB w=1]]']]
X_Xhold18_5 VGND Xhold18_a_49_47# Xhold18_a_285_47# VGND sky130_fd_pr__nfet_01v8 w=420000u l=500000u
** [instance X6 of sky130_fd_pr__pfet_01v8_hvt, params={'w': '420000u', 'l': '500000u'} connections=['d: [connection X6/d =>[signal: a_391_47# w=1]]', 'g: [connection X6/g =>[signal: a_285_47# w=1]]', 's: [connection X6/s =>[signal: VPWR w=1]]', 'b: [connection X6/b =>[signal: VPB w=1]]']]
X_Xhold18_6 Xhold18_a_391_47# Xhold18_a_285_47# VPWR VPWR sky130_fd_pr__pfet_01v8_hvt w=420000u l=500000u
** [instance X7 of sky130_fd_pr__pfet_01v8_hvt, params={'w': '420000u', 'l': '150000u'} connections=['d: [connection X7/d =>[signal: a_49_47# w=1]]', 'g: [connection X7/g =>[signal: A w=1]]', 's: [connection X7/s =>[signal: VPWR w=1]]', 'b: [connection X7/b =>[signal: VPB w=1]]']]
X_Xhold18_7 Xhold18_a_49_47# _67_/Q VPWR VPWR sky130_fd_pr__pfet_01v8_hvt w=420000u l=150000u

** replacing XFILLER_10_64 with the contents of sky130_fd_sc_hd__decap_3
** [instance X0 of sky130_fd_pr__pfet_01v8_hvt, params={'w': '870000u', 'l': '590000u'} connections=['d: [connection X0/d =>[signal: VPWR w=1]]', 'g: [connection X0/g =>[signal: VGND w=1]]', 's: [connection X0/s =>[signal: VPWR w=1]]', 'b: [connection X0/b =>[signal: VPB w=1]]']]
X_XFILLER_10_64_0 VPWR VGND VPWR VPWR sky130_fd_pr__pfet_01v8_hvt w=870000u l=590000u
** [instance X1 of sky130_fd_pr__nfet_01v8, params={'w': '550000u', 'l': '590000u'} connections=['d: [connection X1/d =>[signal: VGND w=1]]', 'g: [connection X1/g =>[signal: VPWR w=1]]', 's: [connection X1/s =>[signal: VGND w=1]]', 'b: [connection X1/b =>[signal: VNB w=1]]']]
X_XFILLER_10_64_1 VGND VPWR VGND VGND sky130_fd_pr__nfet_01v8 w=550000u l=590000u

** replacing Xhold29 with the contents of sky130_fd_sc_hd__dlygate4sd3_1
** [instance X0 of sky130_fd_pr__nfet_01v8, params={'w': '420000u', 'l': '500000u'} connections=['d: [connection X0/d =>[signal: a_391_47# w=1]]', 'g: [connection X0/g =>[signal: a_285_47# w=1]]', 's: [connection X0/s =>[signal: VGND w=1]]', 'b: [connection X0/b =>[signal: VNB w=1]]']]
X_Xhold29_0 Xhold29_a_391_47# Xhold29_a_285_47# VGND VGND sky130_fd_pr__nfet_01v8 w=420000u l=500000u
** [instance X1 of sky130_fd_pr__pfet_01v8_hvt, params={'w': '420000u', 'l': '500000u'} connections=['d: [connection X1/d =>[signal: VPWR w=1]]', 'g: [connection X1/g =>[signal: a_49_47# w=1]]', 's: [connection X1/s =>[signal: a_285_47# w=1]]', 'b: [connection X1/b =>[signal: VPB w=1]]']]
X_Xhold29_1 VPWR Xhold29_a_49_47# Xhold29_a_285_47# VPWR sky130_fd_pr__pfet_01v8_hvt w=420000u l=500000u
** [instance X2 of sky130_fd_pr__nfet_01v8, params={'w': '420000u', 'l': '150000u'} connections=['d: [connection X2/d =>[signal: a_49_47# w=1]]', 'g: [connection X2/g =>[signal: A w=1]]', 's: [connection X2/s =>[signal: VGND w=1]]', 'b: [connection X2/b =>[signal: VNB w=1]]']]
X_Xhold29_2 Xhold29_a_49_47# _66_/Q VGND VGND sky130_fd_pr__nfet_01v8 w=420000u l=150000u
** [instance X3 of sky130_fd_pr__pfet_01v8_hvt, params={'w': '1e+06u', 'l': '150000u'} connections=['d: [connection X3/d =>[signal: VPWR w=1]]', 'g: [connection X3/g =>[signal: a_391_47# w=1]]', 's: [connection X3/s =>[signal: X w=1]]', 'b: [connection X3/b =>[signal: VPB w=1]]']]
X_Xhold29_3 VPWR Xhold29_a_391_47# _48_/A0 VPWR sky130_fd_pr__pfet_01v8_hvt w=1e+06u l=150000u
** [instance X4 of sky130_fd_pr__nfet_01v8, params={'w': '650000u', 'l': '150000u'} connections=['d: [connection X4/d =>[signal: VGND w=1]]', 'g: [connection X4/g =>[signal: a_391_47# w=1]]', 's: [connection X4/s =>[signal: X w=1]]', 'b: [connection X4/b =>[signal: VNB w=1]]']]
X_Xhold29_4 VGND Xhold29_a_391_47# _48_/A0 VGND sky130_fd_pr__nfet_01v8 w=650000u l=150000u
** [instance X5 of sky130_fd_pr__nfet_01v8, params={'w': '420000u', 'l': '500000u'} connections=['d: [connection X5/d =>[signal: VGND w=1]]', 'g: [connection X5/g =>[signal: a_49_47# w=1]]', 's: [connection X5/s =>[signal: a_285_47# w=1]]', 'b: [connection X5/b =>[signal: VNB w=1]]']]
X_Xhold29_5 VGND Xhold29_a_49_47# Xhold29_a_285_47# VGND sky130_fd_pr__nfet_01v8 w=420000u l=500000u
** [instance X6 of sky130_fd_pr__pfet_01v8_hvt, params={'w': '420000u', 'l': '500000u'} connections=['d: [connection X6/d =>[signal: a_391_47# w=1]]', 'g: [connection X6/g =>[signal: a_285_47# w=1]]', 's: [connection X6/s =>[signal: VPWR w=1]]', 'b: [connection X6/b =>[signal: VPB w=1]]']]
X_Xhold29_6 Xhold29_a_391_47# Xhold29_a_285_47# VPWR VPWR sky130_fd_pr__pfet_01v8_hvt w=420000u l=500000u
** [instance X7 of sky130_fd_pr__pfet_01v8_hvt, params={'w': '420000u', 'l': '150000u'} connections=['d: [connection X7/d =>[signal: a_49_47# w=1]]', 'g: [connection X7/g =>[signal: A w=1]]', 's: [connection X7/s =>[signal: VPWR w=1]]', 'b: [connection X7/b =>[signal: VPB w=1]]']]
X_Xhold29_7 Xhold29_a_49_47# _66_/Q VPWR VPWR sky130_fd_pr__pfet_01v8_hvt w=420000u l=150000u

** replacing XPHY_EDGE_ROW_11_Right_11 with the contents of sky130_fd_sc_hd__decap_3
** [instance X0 of sky130_fd_pr__pfet_01v8_hvt, params={'w': '870000u', 'l': '590000u'} connections=['d: [connection X0/d =>[signal: VPWR w=1]]', 'g: [connection X0/g =>[signal: VGND w=1]]', 's: [connection X0/s =>[signal: VPWR w=1]]', 'b: [connection X0/b =>[signal: VPB w=1]]']]
X_XPHY_EDGE_ROW_11_Right_11_0 VPWR VGND VPWR VPWR sky130_fd_pr__pfet_01v8_hvt w=870000u l=590000u
** [instance X1 of sky130_fd_pr__nfet_01v8, params={'w': '550000u', 'l': '590000u'} connections=['d: [connection X1/d =>[signal: VGND w=1]]', 'g: [connection X1/g =>[signal: VPWR w=1]]', 's: [connection X1/s =>[signal: VGND w=1]]', 'b: [connection X1/b =>[signal: VNB w=1]]']]
X_XPHY_EDGE_ROW_11_Right_11_1 VGND VPWR VGND VGND sky130_fd_pr__nfet_01v8 w=550000u l=590000u

** replacing XTAP_TAPCELL_ROW_13_42 with the contents of sky130_fd_sc_hd__tapvpwrvgnd_1

** replacing XFILLER_4_22 with the contents of sky130_fd_sc_hd__fill_1

** replacing Xhold19 with the contents of sky130_fd_sc_hd__dlygate4sd3_1
** [instance X0 of sky130_fd_pr__nfet_01v8, params={'w': '420000u', 'l': '500000u'} connections=['d: [connection X0/d =>[signal: a_391_47# w=1]]', 'g: [connection X0/g =>[signal: a_285_47# w=1]]', 's: [connection X0/s =>[signal: VGND w=1]]', 'b: [connection X0/b =>[signal: VNB w=1]]']]
X_Xhold19_0 Xhold19_a_391_47# Xhold19_a_285_47# VGND VGND sky130_fd_pr__nfet_01v8 w=420000u l=500000u
** [instance X1 of sky130_fd_pr__pfet_01v8_hvt, params={'w': '420000u', 'l': '500000u'} connections=['d: [connection X1/d =>[signal: VPWR w=1]]', 'g: [connection X1/g =>[signal: a_49_47# w=1]]', 's: [connection X1/s =>[signal: a_285_47# w=1]]', 'b: [connection X1/b =>[signal: VPB w=1]]']]
X_Xhold19_1 VPWR Xhold19_a_49_47# Xhold19_a_285_47# VPWR sky130_fd_pr__pfet_01v8_hvt w=420000u l=500000u
** [instance X2 of sky130_fd_pr__nfet_01v8, params={'w': '420000u', 'l': '150000u'} connections=['d: [connection X2/d =>[signal: a_49_47# w=1]]', 'g: [connection X2/g =>[signal: A w=1]]', 's: [connection X2/s =>[signal: VGND w=1]]', 'b: [connection X2/b =>[signal: VNB w=1]]']]
X_Xhold19_2 Xhold19_a_49_47# _49_/X VGND VGND sky130_fd_pr__nfet_01v8 w=420000u l=150000u
** [instance X3 of sky130_fd_pr__pfet_01v8_hvt, params={'w': '1e+06u', 'l': '150000u'} connections=['d: [connection X3/d =>[signal: VPWR w=1]]', 'g: [connection X3/g =>[signal: a_391_47# w=1]]', 's: [connection X3/s =>[signal: X w=1]]', 'b: [connection X3/b =>[signal: VPB w=1]]']]
X_Xhold19_3 VPWR Xhold19_a_391_47# _67_/D VPWR sky130_fd_pr__pfet_01v8_hvt w=1e+06u l=150000u
** [instance X4 of sky130_fd_pr__nfet_01v8, params={'w': '650000u', 'l': '150000u'} connections=['d: [connection X4/d =>[signal: VGND w=1]]', 'g: [connection X4/g =>[signal: a_391_47# w=1]]', 's: [connection X4/s =>[signal: X w=1]]', 'b: [connection X4/b =>[signal: VNB w=1]]']]
X_Xhold19_4 VGND Xhold19_a_391_47# _67_/D VGND sky130_fd_pr__nfet_01v8 w=650000u l=150000u
** [instance X5 of sky130_fd_pr__nfet_01v8, params={'w': '420000u', 'l': '500000u'} connections=['d: [connection X5/d =>[signal: VGND w=1]]', 'g: [connection X5/g =>[signal: a_49_47# w=1]]', 's: [connection X5/s =>[signal: a_285_47# w=1]]', 'b: [connection X5/b =>[signal: VNB w=1]]']]
X_Xhold19_5 VGND Xhold19_a_49_47# Xhold19_a_285_47# VGND sky130_fd_pr__nfet_01v8 w=420000u l=500000u
** [instance X6 of sky130_fd_pr__pfet_01v8_hvt, params={'w': '420000u', 'l': '500000u'} connections=['d: [connection X6/d =>[signal: a_391_47# w=1]]', 'g: [connection X6/g =>[signal: a_285_47# w=1]]', 's: [connection X6/s =>[signal: VPWR w=1]]', 'b: [connection X6/b =>[signal: VPB w=1]]']]
X_Xhold19_6 Xhold19_a_391_47# Xhold19_a_285_47# VPWR VPWR sky130_fd_pr__pfet_01v8_hvt w=420000u l=500000u
** [instance X7 of sky130_fd_pr__pfet_01v8_hvt, params={'w': '420000u', 'l': '150000u'} connections=['d: [connection X7/d =>[signal: a_49_47# w=1]]', 'g: [connection X7/g =>[signal: A w=1]]', 's: [connection X7/s =>[signal: VPWR w=1]]', 'b: [connection X7/b =>[signal: VPB w=1]]']]
X_Xhold19_7 Xhold19_a_49_47# _49_/X VPWR VPWR sky130_fd_pr__pfet_01v8_hvt w=420000u l=150000u

** replacing XFILLER_7_55 with the contents of sky130_fd_sc_hd__fill_1

** replacing XTAP_TAPCELL_ROW_13_43 with the contents of sky130_fd_sc_hd__tapvpwrvgnd_1

** replacing XFILLER_13_54 with the contents of sky130_fd_sc_hd__fill_2

** replacing Xinput1 with the contents of sky130_fd_sc_hd__clkdlybuf4s25_1
** [instance X0 of sky130_fd_pr__pfet_01v8_hvt, params={'w': '820000u', 'l': '250000u'} connections=['d: [connection X0/d =>[signal: a_355_47# w=1]]', 'g: [connection X0/g =>[signal: a_244_47# w=1]]', 's: [connection X0/s =>[signal: VPWR w=1]]', 'b: [connection X0/b =>[signal: VPB w=1]]']]
X_Xinput1_0 Xinput1_a_355_47# Xinput1_a_244_47# VPWR VPWR sky130_fd_pr__pfet_01v8_hvt w=820000u l=250000u
** [instance X1 of sky130_fd_pr__pfet_01v8_hvt, params={'w': '820000u', 'l': '250000u'} connections=['d: [connection X1/d =>[signal: VPWR w=1]]', 'g: [connection X1/g =>[signal: a_27_47# w=1]]', 's: [connection X1/s =>[signal: a_244_47# w=1]]', 'b: [connection X1/b =>[signal: VPB w=1]]']]
X_Xinput1_1 VPWR Xinput1_a_27_47# Xinput1_a_244_47# VPWR sky130_fd_pr__pfet_01v8_hvt w=820000u l=250000u
** [instance X2 of sky130_fd_pr__pfet_01v8_hvt, params={'w': '1e+06u', 'l': '150000u'} connections=['d: [connection X2/d =>[signal: VPWR w=1]]', 'g: [connection X2/g =>[signal: a_355_47# w=1]]', 's: [connection X2/s =>[signal: X w=1]]', 'b: [connection X2/b =>[signal: VPB w=1]]']]
X_Xinput1_2 VPWR Xinput1_a_355_47# _36_/S0 VPWR sky130_fd_pr__pfet_01v8_hvt w=1e+06u l=150000u
** [instance X3 of sky130_fd_pr__pfet_01v8_hvt, params={'w': '1e+06u', 'l': '150000u'} connections=['d: [connection X3/d =>[signal: a_27_47# w=1]]', 'g: [connection X3/g =>[signal: A w=1]]', 's: [connection X3/s =>[signal: VPWR w=1]]', 'b: [connection X3/b =>[signal: VPB w=1]]']]
X_Xinput1_3 Xinput1_a_27_47# addr[0] VPWR VPWR sky130_fd_pr__pfet_01v8_hvt w=1e+06u l=150000u
** [instance X4 of sky130_fd_pr__nfet_01v8, params={'w': '650000u', 'l': '250000u'} connections=['d: [connection X4/d =>[signal: a_355_47# w=1]]', 'g: [connection X4/g =>[signal: a_244_47# w=1]]', 's: [connection X4/s =>[signal: VGND w=1]]', 'b: [connection X4/b =>[signal: VNB w=1]]']]
X_Xinput1_4 Xinput1_a_355_47# Xinput1_a_244_47# VGND VGND sky130_fd_pr__nfet_01v8 w=650000u l=250000u
** [instance X5 of sky130_fd_pr__nfet_01v8, params={'w': '650000u', 'l': '250000u'} connections=['d: [connection X5/d =>[signal: VGND w=1]]', 'g: [connection X5/g =>[signal: a_27_47# w=1]]', 's: [connection X5/s =>[signal: a_244_47# w=1]]', 'b: [connection X5/b =>[signal: VNB w=1]]']]
X_Xinput1_5 VGND Xinput1_a_27_47# Xinput1_a_244_47# VGND sky130_fd_pr__nfet_01v8 w=650000u l=250000u
** [instance X6 of sky130_fd_pr__nfet_01v8, params={'w': '420000u', 'l': '150000u'} connections=['d: [connection X6/d =>[signal: VGND w=1]]', 'g: [connection X6/g =>[signal: a_355_47# w=1]]', 's: [connection X6/s =>[signal: X w=1]]', 'b: [connection X6/b =>[signal: VNB w=1]]']]
X_Xinput1_6 VGND Xinput1_a_355_47# _36_/S0 VGND sky130_fd_pr__nfet_01v8 w=420000u l=150000u
** [instance X7 of sky130_fd_pr__nfet_01v8, params={'w': '420000u', 'l': '150000u'} connections=['d: [connection X7/d =>[signal: a_27_47# w=1]]', 'g: [connection X7/g =>[signal: A w=1]]', 's: [connection X7/s =>[signal: VGND w=1]]', 'b: [connection X7/b =>[signal: VNB w=1]]']]
X_Xinput1_7 Xinput1_a_27_47# addr[0] VGND VGND sky130_fd_pr__nfet_01v8 w=420000u l=150000u

** replacing XPHY_EDGE_ROW_9_Right_9 with the contents of sky130_fd_sc_hd__decap_3
** [instance X0 of sky130_fd_pr__pfet_01v8_hvt, params={'w': '870000u', 'l': '590000u'} connections=['d: [connection X0/d =>[signal: VPWR w=1]]', 'g: [connection X0/g =>[signal: VGND w=1]]', 's: [connection X0/s =>[signal: VPWR w=1]]', 'b: [connection X0/b =>[signal: VPB w=1]]']]
X_XPHY_EDGE_ROW_9_Right_9_0 VPWR VGND VPWR VPWR sky130_fd_pr__pfet_01v8_hvt w=870000u l=590000u
** [instance X1 of sky130_fd_pr__nfet_01v8, params={'w': '550000u', 'l': '590000u'} connections=['d: [connection X1/d =>[signal: VGND w=1]]', 'g: [connection X1/g =>[signal: VPWR w=1]]', 's: [connection X1/s =>[signal: VGND w=1]]', 'b: [connection X1/b =>[signal: VNB w=1]]']]
X_XPHY_EDGE_ROW_9_Right_9_1 VGND VPWR VGND VGND sky130_fd_pr__nfet_01v8 w=550000u l=590000u

** replacing XFILLER_13_66 with the contents of sky130_fd_sc_hd__fill_1

** replacing Xfanout12 with the contents of sky130_fd_sc_hd__clkdlybuf4s25_1
** [instance X0 of sky130_fd_pr__pfet_01v8_hvt, params={'w': '820000u', 'l': '250000u'} connections=['d: [connection X0/d =>[signal: a_355_47# w=1]]', 'g: [connection X0/g =>[signal: a_244_47# w=1]]', 's: [connection X0/s =>[signal: VPWR w=1]]', 'b: [connection X0/b =>[signal: VPB w=1]]']]
X_Xfanout12_0 Xfanout12_a_355_47# Xfanout12_a_244_47# VPWR VPWR sky130_fd_pr__pfet_01v8_hvt w=820000u l=250000u
** [instance X1 of sky130_fd_pr__pfet_01v8_hvt, params={'w': '820000u', 'l': '250000u'} connections=['d: [connection X1/d =>[signal: VPWR w=1]]', 'g: [connection X1/g =>[signal: a_27_47# w=1]]', 's: [connection X1/s =>[signal: a_244_47# w=1]]', 'b: [connection X1/b =>[signal: VPB w=1]]']]
X_Xfanout12_1 VPWR Xfanout12_a_27_47# Xfanout12_a_244_47# VPWR sky130_fd_pr__pfet_01v8_hvt w=820000u l=250000u
** [instance X2 of sky130_fd_pr__pfet_01v8_hvt, params={'w': '1e+06u', 'l': '150000u'} connections=['d: [connection X2/d =>[signal: VPWR w=1]]', 'g: [connection X2/g =>[signal: a_355_47# w=1]]', 's: [connection X2/s =>[signal: X w=1]]', 'b: [connection X2/b =>[signal: VPB w=1]]']]
X_Xfanout12_2 VPWR Xfanout12_a_355_47# _53_/S VPWR sky130_fd_pr__pfet_01v8_hvt w=1e+06u l=150000u
** [instance X3 of sky130_fd_pr__pfet_01v8_hvt, params={'w': '1e+06u', 'l': '150000u'} connections=['d: [connection X3/d =>[signal: a_27_47# w=1]]', 'g: [connection X3/g =>[signal: A w=1]]', 's: [connection X3/s =>[signal: VPWR w=1]]', 'b: [connection X3/b =>[signal: VPB w=1]]']]
X_Xfanout12_3 Xfanout12_a_27_47# input6/X VPWR VPWR sky130_fd_pr__pfet_01v8_hvt w=1e+06u l=150000u
** [instance X4 of sky130_fd_pr__nfet_01v8, params={'w': '650000u', 'l': '250000u'} connections=['d: [connection X4/d =>[signal: a_355_47# w=1]]', 'g: [connection X4/g =>[signal: a_244_47# w=1]]', 's: [connection X4/s =>[signal: VGND w=1]]', 'b: [connection X4/b =>[signal: VNB w=1]]']]
X_Xfanout12_4 Xfanout12_a_355_47# Xfanout12_a_244_47# VGND VGND sky130_fd_pr__nfet_01v8 w=650000u l=250000u
** [instance X5 of sky130_fd_pr__nfet_01v8, params={'w': '650000u', 'l': '250000u'} connections=['d: [connection X5/d =>[signal: VGND w=1]]', 'g: [connection X5/g =>[signal: a_27_47# w=1]]', 's: [connection X5/s =>[signal: a_244_47# w=1]]', 'b: [connection X5/b =>[signal: VNB w=1]]']]
X_Xfanout12_5 VGND Xfanout12_a_27_47# Xfanout12_a_244_47# VGND sky130_fd_pr__nfet_01v8 w=650000u l=250000u
** [instance X6 of sky130_fd_pr__nfet_01v8, params={'w': '420000u', 'l': '150000u'} connections=['d: [connection X6/d =>[signal: VGND w=1]]', 'g: [connection X6/g =>[signal: a_355_47# w=1]]', 's: [connection X6/s =>[signal: X w=1]]', 'b: [connection X6/b =>[signal: VNB w=1]]']]
X_Xfanout12_6 VGND Xfanout12_a_355_47# _53_/S VGND sky130_fd_pr__nfet_01v8 w=420000u l=150000u
** [instance X7 of sky130_fd_pr__nfet_01v8, params={'w': '420000u', 'l': '150000u'} connections=['d: [connection X7/d =>[signal: a_27_47# w=1]]', 'g: [connection X7/g =>[signal: A w=1]]', 's: [connection X7/s =>[signal: VGND w=1]]', 'b: [connection X7/b =>[signal: VNB w=1]]']]
X_Xfanout12_7 Xfanout12_a_27_47# input6/X VGND VGND sky130_fd_pr__nfet_01v8 w=420000u l=150000u

** replacing Xinput2 with the contents of sky130_fd_sc_hd__clkdlybuf4s25_1
** [instance X0 of sky130_fd_pr__pfet_01v8_hvt, params={'w': '820000u', 'l': '250000u'} connections=['d: [connection X0/d =>[signal: a_355_47# w=1]]', 'g: [connection X0/g =>[signal: a_244_47# w=1]]', 's: [connection X0/s =>[signal: VPWR w=1]]', 'b: [connection X0/b =>[signal: VPB w=1]]']]
X_Xinput2_0 Xinput2_a_355_47# Xinput2_a_244_47# VPWR VPWR sky130_fd_pr__pfet_01v8_hvt w=820000u l=250000u
** [instance X1 of sky130_fd_pr__pfet_01v8_hvt, params={'w': '820000u', 'l': '250000u'} connections=['d: [connection X1/d =>[signal: VPWR w=1]]', 'g: [connection X1/g =>[signal: a_27_47# w=1]]', 's: [connection X1/s =>[signal: a_244_47# w=1]]', 'b: [connection X1/b =>[signal: VPB w=1]]']]
X_Xinput2_1 VPWR Xinput2_a_27_47# Xinput2_a_244_47# VPWR sky130_fd_pr__pfet_01v8_hvt w=820000u l=250000u
** [instance X2 of sky130_fd_pr__pfet_01v8_hvt, params={'w': '1e+06u', 'l': '150000u'} connections=['d: [connection X2/d =>[signal: VPWR w=1]]', 'g: [connection X2/g =>[signal: a_355_47# w=1]]', 's: [connection X2/s =>[signal: X w=1]]', 'b: [connection X2/b =>[signal: VPB w=1]]']]
X_Xinput2_2 VPWR Xinput2_a_355_47# _36_/S1 VPWR sky130_fd_pr__pfet_01v8_hvt w=1e+06u l=150000u
** [instance X3 of sky130_fd_pr__pfet_01v8_hvt, params={'w': '1e+06u', 'l': '150000u'} connections=['d: [connection X3/d =>[signal: a_27_47# w=1]]', 'g: [connection X3/g =>[signal: A w=1]]', 's: [connection X3/s =>[signal: VPWR w=1]]', 'b: [connection X3/b =>[signal: VPB w=1]]']]
X_Xinput2_3 Xinput2_a_27_47# addr[1] VPWR VPWR sky130_fd_pr__pfet_01v8_hvt w=1e+06u l=150000u
** [instance X4 of sky130_fd_pr__nfet_01v8, params={'w': '650000u', 'l': '250000u'} connections=['d: [connection X4/d =>[signal: a_355_47# w=1]]', 'g: [connection X4/g =>[signal: a_244_47# w=1]]', 's: [connection X4/s =>[signal: VGND w=1]]', 'b: [connection X4/b =>[signal: VNB w=1]]']]
X_Xinput2_4 Xinput2_a_355_47# Xinput2_a_244_47# VGND VGND sky130_fd_pr__nfet_01v8 w=650000u l=250000u
** [instance X5 of sky130_fd_pr__nfet_01v8, params={'w': '650000u', 'l': '250000u'} connections=['d: [connection X5/d =>[signal: VGND w=1]]', 'g: [connection X5/g =>[signal: a_27_47# w=1]]', 's: [connection X5/s =>[signal: a_244_47# w=1]]', 'b: [connection X5/b =>[signal: VNB w=1]]']]
X_Xinput2_5 VGND Xinput2_a_27_47# Xinput2_a_244_47# VGND sky130_fd_pr__nfet_01v8 w=650000u l=250000u
** [instance X6 of sky130_fd_pr__nfet_01v8, params={'w': '420000u', 'l': '150000u'} connections=['d: [connection X6/d =>[signal: VGND w=1]]', 'g: [connection X6/g =>[signal: a_355_47# w=1]]', 's: [connection X6/s =>[signal: X w=1]]', 'b: [connection X6/b =>[signal: VNB w=1]]']]
X_Xinput2_6 VGND Xinput2_a_355_47# _36_/S1 VGND sky130_fd_pr__nfet_01v8 w=420000u l=150000u
** [instance X7 of sky130_fd_pr__nfet_01v8, params={'w': '420000u', 'l': '150000u'} connections=['d: [connection X7/d =>[signal: a_27_47# w=1]]', 'g: [connection X7/g =>[signal: A w=1]]', 's: [connection X7/s =>[signal: VGND w=1]]', 'b: [connection X7/b =>[signal: VNB w=1]]']]
X_Xinput2_7 Xinput2_a_27_47# addr[1] VGND VGND sky130_fd_pr__nfet_01v8 w=420000u l=150000u

** replacing XPHY_EDGE_ROW_3_Left_17 with the contents of sky130_fd_sc_hd__decap_3
** [instance X0 of sky130_fd_pr__pfet_01v8_hvt, params={'w': '870000u', 'l': '590000u'} connections=['d: [connection X0/d =>[signal: VPWR w=1]]', 'g: [connection X0/g =>[signal: VGND w=1]]', 's: [connection X0/s =>[signal: VPWR w=1]]', 'b: [connection X0/b =>[signal: VPB w=1]]']]
X_XPHY_EDGE_ROW_3_Left_17_0 VPWR VGND VPWR VPWR sky130_fd_pr__pfet_01v8_hvt w=870000u l=590000u
** [instance X1 of sky130_fd_pr__nfet_01v8, params={'w': '550000u', 'l': '590000u'} connections=['d: [connection X1/d =>[signal: VGND w=1]]', 'g: [connection X1/g =>[signal: VPWR w=1]]', 's: [connection X1/s =>[signal: VGND w=1]]', 'b: [connection X1/b =>[signal: VNB w=1]]']]
X_XPHY_EDGE_ROW_3_Left_17_1 VGND VPWR VGND VGND sky130_fd_pr__nfet_01v8 w=550000u l=590000u

** replacing XPHY_EDGE_ROW_6_Left_20 with the contents of sky130_fd_sc_hd__decap_3
** [instance X0 of sky130_fd_pr__pfet_01v8_hvt, params={'w': '870000u', 'l': '590000u'} connections=['d: [connection X0/d =>[signal: VPWR w=1]]', 'g: [connection X0/g =>[signal: VGND w=1]]', 's: [connection X0/s =>[signal: VPWR w=1]]', 'b: [connection X0/b =>[signal: VPB w=1]]']]
X_XPHY_EDGE_ROW_6_Left_20_0 VPWR VGND VPWR VPWR sky130_fd_pr__pfet_01v8_hvt w=870000u l=590000u
** [instance X1 of sky130_fd_pr__nfet_01v8, params={'w': '550000u', 'l': '590000u'} connections=['d: [connection X1/d =>[signal: VGND w=1]]', 'g: [connection X1/g =>[signal: VPWR w=1]]', 's: [connection X1/s =>[signal: VGND w=1]]', 'b: [connection X1/b =>[signal: VNB w=1]]']]
X_XPHY_EDGE_ROW_6_Left_20_1 VGND VPWR VGND VGND sky130_fd_pr__nfet_01v8 w=550000u l=590000u

** replacing XFILLER_7_35 with the contents of sky130_fd_sc_hd__fill_2

** replacing XTAP_TAPCELL_ROW_6_35 with the contents of sky130_fd_sc_hd__tapvpwrvgnd_1

** replacing XFILLER_13_45 with the contents of sky130_fd_sc_hd__decap_3
** [instance X0 of sky130_fd_pr__pfet_01v8_hvt, params={'w': '870000u', 'l': '590000u'} connections=['d: [connection X0/d =>[signal: VPWR w=1]]', 'g: [connection X0/g =>[signal: VGND w=1]]', 's: [connection X0/s =>[signal: VPWR w=1]]', 'b: [connection X0/b =>[signal: VPB w=1]]']]
X_XFILLER_13_45_0 VPWR VGND VPWR VPWR sky130_fd_pr__pfet_01v8_hvt w=870000u l=590000u
** [instance X1 of sky130_fd_pr__nfet_01v8, params={'w': '550000u', 'l': '590000u'} connections=['d: [connection X1/d =>[signal: VGND w=1]]', 'g: [connection X1/g =>[signal: VPWR w=1]]', 's: [connection X1/s =>[signal: VGND w=1]]', 'b: [connection X1/b =>[signal: VNB w=1]]']]
X_XFILLER_13_45_1 VGND VPWR VGND VGND sky130_fd_pr__nfet_01v8 w=550000u l=590000u

** replacing Xfanout13 with the contents of sky130_fd_sc_hd__clkdlybuf4s25_1
** [instance X0 of sky130_fd_pr__pfet_01v8_hvt, params={'w': '820000u', 'l': '250000u'} connections=['d: [connection X0/d =>[signal: a_355_47# w=1]]', 'g: [connection X0/g =>[signal: a_244_47# w=1]]', 's: [connection X0/s =>[signal: VPWR w=1]]', 'b: [connection X0/b =>[signal: VPB w=1]]']]
X_Xfanout13_0 Xfanout13_a_355_47# Xfanout13_a_244_47# VPWR VPWR sky130_fd_pr__pfet_01v8_hvt w=820000u l=250000u
** [instance X1 of sky130_fd_pr__pfet_01v8_hvt, params={'w': '820000u', 'l': '250000u'} connections=['d: [connection X1/d =>[signal: VPWR w=1]]', 'g: [connection X1/g =>[signal: a_27_47# w=1]]', 's: [connection X1/s =>[signal: a_244_47# w=1]]', 'b: [connection X1/b =>[signal: VPB w=1]]']]
X_Xfanout13_1 VPWR Xfanout13_a_27_47# Xfanout13_a_244_47# VPWR sky130_fd_pr__pfet_01v8_hvt w=820000u l=250000u
** [instance X2 of sky130_fd_pr__pfet_01v8_hvt, params={'w': '1e+06u', 'l': '150000u'} connections=['d: [connection X2/d =>[signal: VPWR w=1]]', 'g: [connection X2/g =>[signal: a_355_47# w=1]]', 's: [connection X2/s =>[signal: X w=1]]', 'b: [connection X2/b =>[signal: VPB w=1]]']]
X_Xfanout13_2 VPWR Xfanout13_a_355_47# _58_/S VPWR sky130_fd_pr__pfet_01v8_hvt w=1e+06u l=150000u
** [instance X3 of sky130_fd_pr__pfet_01v8_hvt, params={'w': '1e+06u', 'l': '150000u'} connections=['d: [connection X3/d =>[signal: a_27_47# w=1]]', 'g: [connection X3/g =>[signal: A w=1]]', 's: [connection X3/s =>[signal: VPWR w=1]]', 'b: [connection X3/b =>[signal: VPB w=1]]']]
X_Xfanout13_3 Xfanout13_a_27_47# input6/X VPWR VPWR sky130_fd_pr__pfet_01v8_hvt w=1e+06u l=150000u
** [instance X4 of sky130_fd_pr__nfet_01v8, params={'w': '650000u', 'l': '250000u'} connections=['d: [connection X4/d =>[signal: a_355_47# w=1]]', 'g: [connection X4/g =>[signal: a_244_47# w=1]]', 's: [connection X4/s =>[signal: VGND w=1]]', 'b: [connection X4/b =>[signal: VNB w=1]]']]
X_Xfanout13_4 Xfanout13_a_355_47# Xfanout13_a_244_47# VGND VGND sky130_fd_pr__nfet_01v8 w=650000u l=250000u
** [instance X5 of sky130_fd_pr__nfet_01v8, params={'w': '650000u', 'l': '250000u'} connections=['d: [connection X5/d =>[signal: VGND w=1]]', 'g: [connection X5/g =>[signal: a_27_47# w=1]]', 's: [connection X5/s =>[signal: a_244_47# w=1]]', 'b: [connection X5/b =>[signal: VNB w=1]]']]
X_Xfanout13_5 VGND Xfanout13_a_27_47# Xfanout13_a_244_47# VGND sky130_fd_pr__nfet_01v8 w=650000u l=250000u
** [instance X6 of sky130_fd_pr__nfet_01v8, params={'w': '420000u', 'l': '150000u'} connections=['d: [connection X6/d =>[signal: VGND w=1]]', 'g: [connection X6/g =>[signal: a_355_47# w=1]]', 's: [connection X6/s =>[signal: X w=1]]', 'b: [connection X6/b =>[signal: VNB w=1]]']]
X_Xfanout13_6 VGND Xfanout13_a_355_47# _58_/S VGND sky130_fd_pr__nfet_01v8 w=420000u l=150000u
** [instance X7 of sky130_fd_pr__nfet_01v8, params={'w': '420000u', 'l': '150000u'} connections=['d: [connection X7/d =>[signal: a_27_47# w=1]]', 'g: [connection X7/g =>[signal: A w=1]]', 's: [connection X7/s =>[signal: VGND w=1]]', 'b: [connection X7/b =>[signal: VNB w=1]]']]
X_Xfanout13_7 Xfanout13_a_27_47# input6/X VGND VGND sky130_fd_pr__nfet_01v8 w=420000u l=150000u

** replacing Xinput3 with the contents of sky130_fd_sc_hd__clkdlybuf4s25_1
** [instance X0 of sky130_fd_pr__pfet_01v8_hvt, params={'w': '820000u', 'l': '250000u'} connections=['d: [connection X0/d =>[signal: a_355_47# w=1]]', 'g: [connection X0/g =>[signal: a_244_47# w=1]]', 's: [connection X0/s =>[signal: VPWR w=1]]', 'b: [connection X0/b =>[signal: VPB w=1]]']]
X_Xinput3_0 Xinput3_a_355_47# Xinput3_a_244_47# VPWR VPWR sky130_fd_pr__pfet_01v8_hvt w=820000u l=250000u
** [instance X1 of sky130_fd_pr__pfet_01v8_hvt, params={'w': '820000u', 'l': '250000u'} connections=['d: [connection X1/d =>[signal: VPWR w=1]]', 'g: [connection X1/g =>[signal: a_27_47# w=1]]', 's: [connection X1/s =>[signal: a_244_47# w=1]]', 'b: [connection X1/b =>[signal: VPB w=1]]']]
X_Xinput3_1 VPWR Xinput3_a_27_47# Xinput3_a_244_47# VPWR sky130_fd_pr__pfet_01v8_hvt w=820000u l=250000u
** [instance X2 of sky130_fd_pr__pfet_01v8_hvt, params={'w': '1e+06u', 'l': '150000u'} connections=['d: [connection X2/d =>[signal: VPWR w=1]]', 'g: [connection X2/g =>[signal: a_355_47# w=1]]', 's: [connection X2/s =>[signal: X w=1]]', 'b: [connection X2/b =>[signal: VPB w=1]]']]
X_Xinput3_2 VPWR Xinput3_a_355_47# _37_/S VPWR sky130_fd_pr__pfet_01v8_hvt w=1e+06u l=150000u
** [instance X3 of sky130_fd_pr__pfet_01v8_hvt, params={'w': '1e+06u', 'l': '150000u'} connections=['d: [connection X3/d =>[signal: a_27_47# w=1]]', 'g: [connection X3/g =>[signal: A w=1]]', 's: [connection X3/s =>[signal: VPWR w=1]]', 'b: [connection X3/b =>[signal: VPB w=1]]']]
X_Xinput3_3 Xinput3_a_27_47# addr[2] VPWR VPWR sky130_fd_pr__pfet_01v8_hvt w=1e+06u l=150000u
** [instance X4 of sky130_fd_pr__nfet_01v8, params={'w': '650000u', 'l': '250000u'} connections=['d: [connection X4/d =>[signal: a_355_47# w=1]]', 'g: [connection X4/g =>[signal: a_244_47# w=1]]', 's: [connection X4/s =>[signal: VGND w=1]]', 'b: [connection X4/b =>[signal: VNB w=1]]']]
X_Xinput3_4 Xinput3_a_355_47# Xinput3_a_244_47# VGND VGND sky130_fd_pr__nfet_01v8 w=650000u l=250000u
** [instance X5 of sky130_fd_pr__nfet_01v8, params={'w': '650000u', 'l': '250000u'} connections=['d: [connection X5/d =>[signal: VGND w=1]]', 'g: [connection X5/g =>[signal: a_27_47# w=1]]', 's: [connection X5/s =>[signal: a_244_47# w=1]]', 'b: [connection X5/b =>[signal: VNB w=1]]']]
X_Xinput3_5 VGND Xinput3_a_27_47# Xinput3_a_244_47# VGND sky130_fd_pr__nfet_01v8 w=650000u l=250000u
** [instance X6 of sky130_fd_pr__nfet_01v8, params={'w': '420000u', 'l': '150000u'} connections=['d: [connection X6/d =>[signal: VGND w=1]]', 'g: [connection X6/g =>[signal: a_355_47# w=1]]', 's: [connection X6/s =>[signal: X w=1]]', 'b: [connection X6/b =>[signal: VNB w=1]]']]
X_Xinput3_6 VGND Xinput3_a_355_47# _37_/S VGND sky130_fd_pr__nfet_01v8 w=420000u l=150000u
** [instance X7 of sky130_fd_pr__nfet_01v8, params={'w': '420000u', 'l': '150000u'} connections=['d: [connection X7/d =>[signal: a_27_47# w=1]]', 'g: [connection X7/g =>[signal: A w=1]]', 's: [connection X7/s =>[signal: VGND w=1]]', 'b: [connection X7/b =>[signal: VNB w=1]]']]
X_Xinput3_7 Xinput3_a_27_47# addr[2] VGND VGND sky130_fd_pr__nfet_01v8 w=420000u l=150000u

** replacing XFILLER_10_24 with the contents of sky130_fd_sc_hd__decap_3
** [instance X0 of sky130_fd_pr__pfet_01v8_hvt, params={'w': '870000u', 'l': '590000u'} connections=['d: [connection X0/d =>[signal: VPWR w=1]]', 'g: [connection X0/g =>[signal: VGND w=1]]', 's: [connection X0/s =>[signal: VPWR w=1]]', 'b: [connection X0/b =>[signal: VPB w=1]]']]
X_XFILLER_10_24_0 VPWR VGND VPWR VPWR sky130_fd_pr__pfet_01v8_hvt w=870000u l=590000u
** [instance X1 of sky130_fd_pr__nfet_01v8, params={'w': '550000u', 'l': '590000u'} connections=['d: [connection X1/d =>[signal: VGND w=1]]', 'g: [connection X1/g =>[signal: VPWR w=1]]', 's: [connection X1/s =>[signal: VGND w=1]]', 'b: [connection X1/b =>[signal: VNB w=1]]']]
X_XFILLER_10_24_1 VGND VPWR VGND VGND sky130_fd_pr__nfet_01v8 w=550000u l=590000u

** replacing XPHY_EDGE_ROW_0_Right_0 with the contents of sky130_fd_sc_hd__decap_3
** [instance X0 of sky130_fd_pr__pfet_01v8_hvt, params={'w': '870000u', 'l': '590000u'} connections=['d: [connection X0/d =>[signal: VPWR w=1]]', 'g: [connection X0/g =>[signal: VGND w=1]]', 's: [connection X0/s =>[signal: VPWR w=1]]', 'b: [connection X0/b =>[signal: VPB w=1]]']]
X_XPHY_EDGE_ROW_0_Right_0_0 VPWR VGND VPWR VPWR sky130_fd_pr__pfet_01v8_hvt w=870000u l=590000u
** [instance X1 of sky130_fd_pr__nfet_01v8, params={'w': '550000u', 'l': '590000u'} connections=['d: [connection X1/d =>[signal: VGND w=1]]', 'g: [connection X1/g =>[signal: VPWR w=1]]', 's: [connection X1/s =>[signal: VGND w=1]]', 'b: [connection X1/b =>[signal: VNB w=1]]']]
X_XPHY_EDGE_ROW_0_Right_0_1 VGND VPWR VGND VGND sky130_fd_pr__nfet_01v8 w=550000u l=590000u

** replacing XFILLER_2_80 with the contents of sky130_fd_sc_hd__decap_3
** [instance X0 of sky130_fd_pr__pfet_01v8_hvt, params={'w': '870000u', 'l': '590000u'} connections=['d: [connection X0/d =>[signal: VPWR w=1]]', 'g: [connection X0/g =>[signal: VGND w=1]]', 's: [connection X0/s =>[signal: VPWR w=1]]', 'b: [connection X0/b =>[signal: VPB w=1]]']]
X_XFILLER_2_80_0 VPWR VGND VPWR VPWR sky130_fd_pr__pfet_01v8_hvt w=870000u l=590000u
** [instance X1 of sky130_fd_pr__nfet_01v8, params={'w': '550000u', 'l': '590000u'} connections=['d: [connection X1/d =>[signal: VGND w=1]]', 'g: [connection X1/g =>[signal: VPWR w=1]]', 's: [connection X1/s =>[signal: VGND w=1]]', 'b: [connection X1/b =>[signal: VNB w=1]]']]
X_XFILLER_2_80_1 VGND VPWR VGND VGND sky130_fd_pr__nfet_01v8 w=550000u l=590000u

** replacing XFILLER_13_57 with the contents of sky130_fd_sc_hd__decap_3
** [instance X0 of sky130_fd_pr__pfet_01v8_hvt, params={'w': '870000u', 'l': '590000u'} connections=['d: [connection X0/d =>[signal: VPWR w=1]]', 'g: [connection X0/g =>[signal: VGND w=1]]', 's: [connection X0/s =>[signal: VPWR w=1]]', 'b: [connection X0/b =>[signal: VPB w=1]]']]
X_XFILLER_13_57_0 VPWR VGND VPWR VPWR sky130_fd_pr__pfet_01v8_hvt w=870000u l=590000u
** [instance X1 of sky130_fd_pr__nfet_01v8, params={'w': '550000u', 'l': '590000u'} connections=['d: [connection X1/d =>[signal: VGND w=1]]', 'g: [connection X1/g =>[signal: VPWR w=1]]', 's: [connection X1/s =>[signal: VGND w=1]]', 'b: [connection X1/b =>[signal: VNB w=1]]']]
X_XFILLER_13_57_1 VGND VPWR VGND VGND sky130_fd_pr__nfet_01v8 w=550000u l=590000u

** replacing Xinput4 with the contents of sky130_fd_sc_hd__clkdlybuf4s25_1
** [instance X0 of sky130_fd_pr__pfet_01v8_hvt, params={'w': '820000u', 'l': '250000u'} connections=['d: [connection X0/d =>[signal: a_355_47# w=1]]', 'g: [connection X0/g =>[signal: a_244_47# w=1]]', 's: [connection X0/s =>[signal: VPWR w=1]]', 'b: [connection X0/b =>[signal: VPB w=1]]']]
X_Xinput4_0 Xinput4_a_355_47# Xinput4_a_244_47# VPWR VPWR sky130_fd_pr__pfet_01v8_hvt w=820000u l=250000u
** [instance X1 of sky130_fd_pr__pfet_01v8_hvt, params={'w': '820000u', 'l': '250000u'} connections=['d: [connection X1/d =>[signal: VPWR w=1]]', 'g: [connection X1/g =>[signal: a_27_47# w=1]]', 's: [connection X1/s =>[signal: a_244_47# w=1]]', 'b: [connection X1/b =>[signal: VPB w=1]]']]
X_Xinput4_1 VPWR Xinput4_a_27_47# Xinput4_a_244_47# VPWR sky130_fd_pr__pfet_01v8_hvt w=820000u l=250000u
** [instance X2 of sky130_fd_pr__pfet_01v8_hvt, params={'w': '1e+06u', 'l': '150000u'} connections=['d: [connection X2/d =>[signal: VPWR w=1]]', 'g: [connection X2/g =>[signal: a_355_47# w=1]]', 's: [connection X2/s =>[signal: X w=1]]', 'b: [connection X2/b =>[signal: VPB w=1]]']]
X_Xinput4_2 VPWR Xinput4_a_355_47# _30_/A VPWR sky130_fd_pr__pfet_01v8_hvt w=1e+06u l=150000u
** [instance X3 of sky130_fd_pr__pfet_01v8_hvt, params={'w': '1e+06u', 'l': '150000u'} connections=['d: [connection X3/d =>[signal: a_27_47# w=1]]', 'g: [connection X3/g =>[signal: A w=1]]', 's: [connection X3/s =>[signal: VPWR w=1]]', 'b: [connection X3/b =>[signal: VPB w=1]]']]
X_Xinput4_3 Xinput4_a_27_47# addr[3] VPWR VPWR sky130_fd_pr__pfet_01v8_hvt w=1e+06u l=150000u
** [instance X4 of sky130_fd_pr__nfet_01v8, params={'w': '650000u', 'l': '250000u'} connections=['d: [connection X4/d =>[signal: a_355_47# w=1]]', 'g: [connection X4/g =>[signal: a_244_47# w=1]]', 's: [connection X4/s =>[signal: VGND w=1]]', 'b: [connection X4/b =>[signal: VNB w=1]]']]
X_Xinput4_4 Xinput4_a_355_47# Xinput4_a_244_47# VGND VGND sky130_fd_pr__nfet_01v8 w=650000u l=250000u
** [instance X5 of sky130_fd_pr__nfet_01v8, params={'w': '650000u', 'l': '250000u'} connections=['d: [connection X5/d =>[signal: VGND w=1]]', 'g: [connection X5/g =>[signal: a_27_47# w=1]]', 's: [connection X5/s =>[signal: a_244_47# w=1]]', 'b: [connection X5/b =>[signal: VNB w=1]]']]
X_Xinput4_5 VGND Xinput4_a_27_47# Xinput4_a_244_47# VGND sky130_fd_pr__nfet_01v8 w=650000u l=250000u
** [instance X6 of sky130_fd_pr__nfet_01v8, params={'w': '420000u', 'l': '150000u'} connections=['d: [connection X6/d =>[signal: VGND w=1]]', 'g: [connection X6/g =>[signal: a_355_47# w=1]]', 's: [connection X6/s =>[signal: X w=1]]', 'b: [connection X6/b =>[signal: VNB w=1]]']]
X_Xinput4_6 VGND Xinput4_a_355_47# _30_/A VGND sky130_fd_pr__nfet_01v8 w=420000u l=150000u
** [instance X7 of sky130_fd_pr__nfet_01v8, params={'w': '420000u', 'l': '150000u'} connections=['d: [connection X7/d =>[signal: a_27_47# w=1]]', 'g: [connection X7/g =>[signal: A w=1]]', 's: [connection X7/s =>[signal: VGND w=1]]', 'b: [connection X7/b =>[signal: VNB w=1]]']]
X_Xinput4_7 Xinput4_a_27_47# addr[3] VGND VGND sky130_fd_pr__nfet_01v8 w=420000u l=150000u

** replacing X_77_ with the contents of sky130_fd_sc_hd__dfxtp_2
** [instance X0 of sky130_fd_pr__pfet_01v8_hvt, params={'w': '420000u', 'l': '150000u'} connections=['d: [connection X0/d =>[signal: a_891_413# w=1]]', 'g: [connection X0/g =>[signal: a_193_47# w=1]]', 's: [connection X0/s =>[signal: a_975_413# w=1]]', 'b: [connection X0/b =>[signal: VPB w=1]]']]
X_X_77__0 X_77__a_891_413# X_77__a_193_47# X_77__a_975_413# VPWR sky130_fd_pr__pfet_01v8_hvt w=420000u l=150000u
** [instance X1 of sky130_fd_pr__nfet_01v8, params={'w': '650000u', 'l': '150000u'} connections=['d: [connection X1/d =>[signal: a_1059_315# w=1]]', 'g: [connection X1/g =>[signal: a_891_413# w=1]]', 's: [connection X1/s =>[signal: VGND w=1]]', 'b: [connection X1/b =>[signal: VNB w=1]]']]
X_X_77__1 X_77__a_1059_315# X_77__a_891_413# VGND VGND sky130_fd_pr__nfet_01v8 w=650000u l=150000u
** [instance X2 of sky130_fd_pr__pfet_01v8_hvt, params={'w': '420000u', 'l': '150000u'} connections=['d: [connection X2/d =>[signal: a_466_413# w=1]]', 'g: [connection X2/g =>[signal: a_27_47# w=1]]', 's: [connection X2/s =>[signal: a_561_413# w=1]]', 'b: [connection X2/b =>[signal: VPB w=1]]']]
X_X_77__2 X_77__a_466_413# X_77__a_27_47# X_77__a_561_413# VPWR sky130_fd_pr__pfet_01v8_hvt w=420000u l=150000u
** [instance X3 of sky130_fd_pr__pfet_01v8_hvt, params={'w': '420000u', 'l': '150000u'} connections=['d: [connection X3/d =>[signal: a_634_159# w=1]]', 'g: [connection X3/g =>[signal: a_27_47# w=1]]', 's: [connection X3/s =>[signal: a_891_413# w=1]]', 'b: [connection X3/b =>[signal: VPB w=1]]']]
X_X_77__3 X_77__a_634_159# X_77__a_27_47# X_77__a_891_413# VPWR sky130_fd_pr__pfet_01v8_hvt w=420000u l=150000u
** [instance X4 of sky130_fd_pr__pfet_01v8_hvt, params={'w': '420000u', 'l': '150000u'} connections=['d: [connection X4/d =>[signal: a_381_47# w=1]]', 'g: [connection X4/g =>[signal: a_193_47# w=1]]', 's: [connection X4/s =>[signal: a_466_413# w=1]]', 'b: [connection X4/b =>[signal: VPB w=1]]']]
X_X_77__4 X_77__a_381_47# X_77__a_193_47# X_77__a_466_413# VPWR sky130_fd_pr__pfet_01v8_hvt w=420000u l=150000u
** [instance X5 of sky130_fd_pr__pfet_01v8_hvt, params={'w': '420000u', 'l': '150000u'} connections=['d: [connection X5/d =>[signal: VPWR w=1]]', 'g: [connection X5/g =>[signal: D w=1]]', 's: [connection X5/s =>[signal: a_381_47# w=1]]', 'b: [connection X5/b =>[signal: VPB w=1]]']]
X_X_77__5 VPWR _77_/D X_77__a_381_47# VPWR sky130_fd_pr__pfet_01v8_hvt w=420000u l=150000u
** [instance X6 of sky130_fd_pr__pfet_01v8_hvt, params={'w': '750000u', 'l': '150000u'} connections=['d: [connection X6/d =>[signal: VPWR w=1]]', 'g: [connection X6/g =>[signal: a_466_413# w=1]]', 's: [connection X6/s =>[signal: a_634_159# w=1]]', 'b: [connection X6/b =>[signal: VPB w=1]]']]
X_X_77__6 VPWR X_77__a_466_413# X_77__a_634_159# VPWR sky130_fd_pr__pfet_01v8_hvt w=750000u l=150000u
** [instance X7 of sky130_fd_pr__nfet_01v8, params={'w': '640000u', 'l': '150000u'} connections=['d: [connection X7/d =>[signal: VGND w=1]]', 'g: [connection X7/g =>[signal: a_466_413# w=1]]', 's: [connection X7/s =>[signal: a_634_159# w=1]]', 'b: [connection X7/b =>[signal: VNB w=1]]']]
X_X_77__7 VGND X_77__a_466_413# X_77__a_634_159# VGND sky130_fd_pr__nfet_01v8 w=640000u l=150000u
** [instance X8 of sky130_fd_pr__nfet_01v8, params={'w': '420000u', 'l': '150000u'} connections=['d: [connection X8/d =>[signal: a_1017_47# w=1]]', 'g: [connection X8/g =>[signal: a_1059_315# w=1]]', 's: [connection X8/s =>[signal: VGND w=1]]', 'b: [connection X8/b =>[signal: VNB w=1]]']]
X_X_77__8 X_77__a_1017_47# X_77__a_1059_315# VGND VGND sky130_fd_pr__nfet_01v8 w=420000u l=150000u
** [instance X9 of sky130_fd_pr__pfet_01v8_hvt, params={'w': '1e+06u', 'l': '150000u'} connections=['d: [connection X9/d =>[signal: a_1059_315# w=1]]', 'g: [connection X9/g =>[signal: a_891_413# w=1]]', 's: [connection X9/s =>[signal: VPWR w=1]]', 'b: [connection X9/b =>[signal: VPB w=1]]']]
X_X_77__9 X_77__a_1059_315# X_77__a_891_413# VPWR VPWR sky130_fd_pr__pfet_01v8_hvt w=1e+06u l=150000u
** [instance X10 of sky130_fd_pr__pfet_01v8_hvt, params={'w': '1e+06u', 'l': '150000u'} connections=['d: [connection X10/d =>[signal: Q w=1]]', 'g: [connection X10/g =>[signal: a_1059_315# w=1]]', 's: [connection X10/s =>[signal: VPWR w=1]]', 'b: [connection X10/b =>[signal: VPB w=1]]']]
X_X_77__10 _77_/Q X_77__a_1059_315# VPWR VPWR sky130_fd_pr__pfet_01v8_hvt w=1e+06u l=150000u
** [instance X11 of sky130_fd_pr__pfet_01v8_hvt, params={'w': '420000u', 'l': '150000u'} connections=['d: [connection X11/d =>[signal: a_561_413# w=1]]', 'g: [connection X11/g =>[signal: a_634_159# w=1]]', 's: [connection X11/s =>[signal: VPWR w=1]]', 'b: [connection X11/b =>[signal: VPB w=1]]']]
X_X_77__11 X_77__a_561_413# X_77__a_634_159# VPWR VPWR sky130_fd_pr__pfet_01v8_hvt w=420000u l=150000u
** [instance X12 of sky130_fd_pr__pfet_01v8_hvt, params={'w': '1e+06u', 'l': '150000u'} connections=['d: [connection X12/d =>[signal: VPWR w=1]]', 'g: [connection X12/g =>[signal: a_1059_315# w=1]]', 's: [connection X12/s =>[signal: Q w=1]]', 'b: [connection X12/b =>[signal: VPB w=1]]']]
X_X_77__12 VPWR X_77__a_1059_315# _77_/Q VPWR sky130_fd_pr__pfet_01v8_hvt w=1e+06u l=150000u
** [instance X13 of sky130_fd_pr__nfet_01v8, params={'w': '360000u', 'l': '150000u'} connections=['d: [connection X13/d =>[signal: a_891_413# w=1]]', 'g: [connection X13/g =>[signal: a_27_47# w=1]]', 's: [connection X13/s =>[signal: a_1017_47# w=1]]', 'b: [connection X13/b =>[signal: VNB w=1]]']]
X_X_77__13 X_77__a_891_413# X_77__a_27_47# X_77__a_1017_47# VGND sky130_fd_pr__nfet_01v8 w=360000u l=150000u
** [instance X14 of sky130_fd_pr__nfet_01v8, params={'w': '360000u', 'l': '150000u'} connections=['d: [connection X14/d =>[signal: a_634_159# w=1]]', 'g: [connection X14/g =>[signal: a_193_47# w=1]]', 's: [connection X14/s =>[signal: a_891_413# w=1]]', 'b: [connection X14/b =>[signal: VNB w=1]]']]
X_X_77__14 X_77__a_634_159# X_77__a_193_47# X_77__a_891_413# VGND sky130_fd_pr__nfet_01v8 w=360000u l=150000u
** [instance X15 of sky130_fd_pr__nfet_01v8, params={'w': '420000u', 'l': '150000u'} connections=['d: [connection X15/d =>[signal: a_592_47# w=1]]', 'g: [connection X15/g =>[signal: a_634_159# w=1]]', 's: [connection X15/s =>[signal: VGND w=1]]', 'b: [connection X15/b =>[signal: VNB w=1]]']]
X_X_77__15 X_77__a_592_47# X_77__a_634_159# VGND VGND sky130_fd_pr__nfet_01v8 w=420000u l=150000u
** [instance X16 of sky130_fd_pr__nfet_01v8, params={'w': '360000u', 'l': '150000u'} connections=['d: [connection X16/d =>[signal: a_466_413# w=1]]', 'g: [connection X16/g =>[signal: a_193_47# w=1]]', 's: [connection X16/s =>[signal: a_592_47# w=1]]', 'b: [connection X16/b =>[signal: VNB w=1]]']]
X_X_77__16 X_77__a_466_413# X_77__a_193_47# X_77__a_592_47# VGND sky130_fd_pr__nfet_01v8 w=360000u l=150000u
** [instance X17 of sky130_fd_pr__nfet_01v8, params={'w': '420000u', 'l': '150000u'} connections=['d: [connection X17/d =>[signal: VGND w=1]]', 'g: [connection X17/g =>[signal: a_27_47# w=1]]', 's: [connection X17/s =>[signal: a_193_47# w=1]]', 'b: [connection X17/b =>[signal: VNB w=1]]']]
X_X_77__17 VGND X_77__a_27_47# X_77__a_193_47# VGND sky130_fd_pr__nfet_01v8 w=420000u l=150000u
** [instance X18 of sky130_fd_pr__nfet_01v8, params={'w': '360000u', 'l': '150000u'} connections=['d: [connection X18/d =>[signal: a_381_47# w=1]]', 'g: [connection X18/g =>[signal: a_27_47# w=1]]', 's: [connection X18/s =>[signal: a_466_413# w=1]]', 'b: [connection X18/b =>[signal: VNB w=1]]']]
X_X_77__18 X_77__a_381_47# X_77__a_27_47# X_77__a_466_413# VGND sky130_fd_pr__nfet_01v8 w=360000u l=150000u
** [instance X19 of sky130_fd_pr__nfet_01v8, params={'w': '420000u', 'l': '150000u'} connections=['d: [connection X19/d =>[signal: a_27_47# w=1]]', 'g: [connection X19/g =>[signal: CLK w=1]]', 's: [connection X19/s =>[signal: VGND w=1]]', 'b: [connection X19/b =>[signal: VNB w=1]]']]
X_X_77__19 X_77__a_27_47# input5/X VGND VGND sky130_fd_pr__nfet_01v8 w=420000u l=150000u
** [instance X20 of sky130_fd_pr__pfet_01v8_hvt, params={'w': '640000u', 'l': '150000u'} connections=['d: [connection X20/d =>[signal: a_27_47# w=1]]', 'g: [connection X20/g =>[signal: CLK w=1]]', 's: [connection X20/s =>[signal: VPWR w=1]]', 'b: [connection X20/b =>[signal: VPB w=1]]']]
X_X_77__20 X_77__a_27_47# input5/X VPWR VPWR sky130_fd_pr__pfet_01v8_hvt w=640000u l=150000u
** [instance X21 of sky130_fd_pr__nfet_01v8, params={'w': '650000u', 'l': '150000u'} connections=['d: [connection X21/d =>[signal: Q w=1]]', 'g: [connection X21/g =>[signal: a_1059_315# w=1]]', 's: [connection X21/s =>[signal: VGND w=1]]', 'b: [connection X21/b =>[signal: VNB w=1]]']]
X_X_77__21 _77_/Q X_77__a_1059_315# VGND VGND sky130_fd_pr__nfet_01v8 w=650000u l=150000u
** [instance X22 of sky130_fd_pr__pfet_01v8_hvt, params={'w': '640000u', 'l': '150000u'} connections=['d: [connection X22/d =>[signal: VPWR w=1]]', 'g: [connection X22/g =>[signal: a_27_47# w=1]]', 's: [connection X22/s =>[signal: a_193_47# w=1]]', 'b: [connection X22/b =>[signal: VPB w=1]]']]
X_X_77__22 VPWR X_77__a_27_47# X_77__a_193_47# VPWR sky130_fd_pr__pfet_01v8_hvt w=640000u l=150000u
** [instance X23 of sky130_fd_pr__nfet_01v8, params={'w': '420000u', 'l': '150000u'} connections=['d: [connection X23/d =>[signal: VGND w=1]]', 'g: [connection X23/g =>[signal: D w=1]]', 's: [connection X23/s =>[signal: a_381_47# w=1]]', 'b: [connection X23/b =>[signal: VNB w=1]]']]
X_X_77__23 VGND _77_/D X_77__a_381_47# VGND sky130_fd_pr__nfet_01v8 w=420000u l=150000u
** [instance X24 of sky130_fd_pr__pfet_01v8_hvt, params={'w': '420000u', 'l': '150000u'} connections=['d: [connection X24/d =>[signal: a_975_413# w=1]]', 'g: [connection X24/g =>[signal: a_1059_315# w=1]]', 's: [connection X24/s =>[signal: VPWR w=1]]', 'b: [connection X24/b =>[signal: VPB w=1]]']]
X_X_77__24 X_77__a_975_413# X_77__a_1059_315# VPWR VPWR sky130_fd_pr__pfet_01v8_hvt w=420000u l=150000u
** [instance X25 of sky130_fd_pr__nfet_01v8, params={'w': '650000u', 'l': '150000u'} connections=['d: [connection X25/d =>[signal: VGND w=1]]', 'g: [connection X25/g =>[signal: a_1059_315# w=1]]', 's: [connection X25/s =>[signal: Q w=1]]', 'b: [connection X25/b =>[signal: VNB w=1]]']]
X_X_77__25 VGND X_77__a_1059_315# _77_/Q VGND sky130_fd_pr__nfet_01v8 w=650000u l=150000u

** replacing XFILLER_5_80 with the contents of sky130_fd_sc_hd__decap_3
** [instance X0 of sky130_fd_pr__pfet_01v8_hvt, params={'w': '870000u', 'l': '590000u'} connections=['d: [connection X0/d =>[signal: VPWR w=1]]', 'g: [connection X0/g =>[signal: VGND w=1]]', 's: [connection X0/s =>[signal: VPWR w=1]]', 'b: [connection X0/b =>[signal: VPB w=1]]']]
X_XFILLER_5_80_0 VPWR VGND VPWR VPWR sky130_fd_pr__pfet_01v8_hvt w=870000u l=590000u
** [instance X1 of sky130_fd_pr__nfet_01v8, params={'w': '550000u', 'l': '590000u'} connections=['d: [connection X1/d =>[signal: VGND w=1]]', 'g: [connection X1/g =>[signal: VPWR w=1]]', 's: [connection X1/s =>[signal: VGND w=1]]', 'b: [connection X1/b =>[signal: VNB w=1]]']]
X_XFILLER_5_80_1 VGND VPWR VGND VGND sky130_fd_pr__nfet_01v8 w=550000u l=590000u

** replacing XFILLER_6_3 with the contents of sky130_fd_sc_hd__decap_3
** [instance X0 of sky130_fd_pr__pfet_01v8_hvt, params={'w': '870000u', 'l': '590000u'} connections=['d: [connection X0/d =>[signal: VPWR w=1]]', 'g: [connection X0/g =>[signal: VGND w=1]]', 's: [connection X0/s =>[signal: VPWR w=1]]', 'b: [connection X0/b =>[signal: VPB w=1]]']]
X_XFILLER_6_3_0 VPWR VGND VPWR VPWR sky130_fd_pr__pfet_01v8_hvt w=870000u l=590000u
** [instance X1 of sky130_fd_pr__nfet_01v8, params={'w': '550000u', 'l': '590000u'} connections=['d: [connection X1/d =>[signal: VGND w=1]]', 'g: [connection X1/g =>[signal: VPWR w=1]]', 's: [connection X1/s =>[signal: VGND w=1]]', 'b: [connection X1/b =>[signal: VNB w=1]]']]
X_XFILLER_6_3_1 VGND VPWR VGND VGND sky130_fd_pr__nfet_01v8 w=550000u l=590000u

** replacing XTAP_TAPCELL_ROW_0_28 with the contents of sky130_fd_sc_hd__tapvpwrvgnd_1

** replacing Xinput5 with the contents of sky130_fd_sc_hd__clkdlybuf4s25_1
** [instance X0 of sky130_fd_pr__pfet_01v8_hvt, params={'w': '820000u', 'l': '250000u'} connections=['d: [connection X0/d =>[signal: a_355_47# w=1]]', 'g: [connection X0/g =>[signal: a_244_47# w=1]]', 's: [connection X0/s =>[signal: VPWR w=1]]', 'b: [connection X0/b =>[signal: VPB w=1]]']]
X_Xinput5_0 Xinput5_a_355_47# Xinput5_a_244_47# VPWR VPWR sky130_fd_pr__pfet_01v8_hvt w=820000u l=250000u
** [instance X1 of sky130_fd_pr__pfet_01v8_hvt, params={'w': '820000u', 'l': '250000u'} connections=['d: [connection X1/d =>[signal: VPWR w=1]]', 'g: [connection X1/g =>[signal: a_27_47# w=1]]', 's: [connection X1/s =>[signal: a_244_47# w=1]]', 'b: [connection X1/b =>[signal: VPB w=1]]']]
X_Xinput5_1 VPWR Xinput5_a_27_47# Xinput5_a_244_47# VPWR sky130_fd_pr__pfet_01v8_hvt w=820000u l=250000u
** [instance X2 of sky130_fd_pr__pfet_01v8_hvt, params={'w': '1e+06u', 'l': '150000u'} connections=['d: [connection X2/d =>[signal: VPWR w=1]]', 'g: [connection X2/g =>[signal: a_355_47# w=1]]', 's: [connection X2/s =>[signal: X w=1]]', 'b: [connection X2/b =>[signal: VPB w=1]]']]
X_Xinput5_2 VPWR Xinput5_a_355_47# input5/X VPWR sky130_fd_pr__pfet_01v8_hvt w=1e+06u l=150000u
** [instance X3 of sky130_fd_pr__pfet_01v8_hvt, params={'w': '1e+06u', 'l': '150000u'} connections=['d: [connection X3/d =>[signal: a_27_47# w=1]]', 'g: [connection X3/g =>[signal: A w=1]]', 's: [connection X3/s =>[signal: VPWR w=1]]', 'b: [connection X3/b =>[signal: VPB w=1]]']]
X_Xinput5_3 Xinput5_a_27_47# clk VPWR VPWR sky130_fd_pr__pfet_01v8_hvt w=1e+06u l=150000u
** [instance X4 of sky130_fd_pr__nfet_01v8, params={'w': '650000u', 'l': '250000u'} connections=['d: [connection X4/d =>[signal: a_355_47# w=1]]', 'g: [connection X4/g =>[signal: a_244_47# w=1]]', 's: [connection X4/s =>[signal: VGND w=1]]', 'b: [connection X4/b =>[signal: VNB w=1]]']]
X_Xinput5_4 Xinput5_a_355_47# Xinput5_a_244_47# VGND VGND sky130_fd_pr__nfet_01v8 w=650000u l=250000u
** [instance X5 of sky130_fd_pr__nfet_01v8, params={'w': '650000u', 'l': '250000u'} connections=['d: [connection X5/d =>[signal: VGND w=1]]', 'g: [connection X5/g =>[signal: a_27_47# w=1]]', 's: [connection X5/s =>[signal: a_244_47# w=1]]', 'b: [connection X5/b =>[signal: VNB w=1]]']]
X_Xinput5_5 VGND Xinput5_a_27_47# Xinput5_a_244_47# VGND sky130_fd_pr__nfet_01v8 w=650000u l=250000u
** [instance X6 of sky130_fd_pr__nfet_01v8, params={'w': '420000u', 'l': '150000u'} connections=['d: [connection X6/d =>[signal: VGND w=1]]', 'g: [connection X6/g =>[signal: a_355_47# w=1]]', 's: [connection X6/s =>[signal: X w=1]]', 'b: [connection X6/b =>[signal: VNB w=1]]']]
X_Xinput5_6 VGND Xinput5_a_355_47# input5/X VGND sky130_fd_pr__nfet_01v8 w=420000u l=150000u
** [instance X7 of sky130_fd_pr__nfet_01v8, params={'w': '420000u', 'l': '150000u'} connections=['d: [connection X7/d =>[signal: a_27_47# w=1]]', 'g: [connection X7/g =>[signal: A w=1]]', 's: [connection X7/s =>[signal: VGND w=1]]', 'b: [connection X7/b =>[signal: VNB w=1]]']]
X_Xinput5_7 Xinput5_a_27_47# clk VGND VGND sky130_fd_pr__nfet_01v8 w=420000u l=150000u

** replacing X_76_ with the contents of sky130_fd_sc_hd__dfxtp_2
** [instance X0 of sky130_fd_pr__pfet_01v8_hvt, params={'w': '420000u', 'l': '150000u'} connections=['d: [connection X0/d =>[signal: a_891_413# w=1]]', 'g: [connection X0/g =>[signal: a_193_47# w=1]]', 's: [connection X0/s =>[signal: a_975_413# w=1]]', 'b: [connection X0/b =>[signal: VPB w=1]]']]
X_X_76__0 X_76__a_891_413# X_76__a_193_47# X_76__a_975_413# VPWR sky130_fd_pr__pfet_01v8_hvt w=420000u l=150000u
** [instance X1 of sky130_fd_pr__nfet_01v8, params={'w': '650000u', 'l': '150000u'} connections=['d: [connection X1/d =>[signal: a_1059_315# w=1]]', 'g: [connection X1/g =>[signal: a_891_413# w=1]]', 's: [connection X1/s =>[signal: VGND w=1]]', 'b: [connection X1/b =>[signal: VNB w=1]]']]
X_X_76__1 X_76__a_1059_315# X_76__a_891_413# VGND VGND sky130_fd_pr__nfet_01v8 w=650000u l=150000u
** [instance X2 of sky130_fd_pr__pfet_01v8_hvt, params={'w': '420000u', 'l': '150000u'} connections=['d: [connection X2/d =>[signal: a_466_413# w=1]]', 'g: [connection X2/g =>[signal: a_27_47# w=1]]', 's: [connection X2/s =>[signal: a_561_413# w=1]]', 'b: [connection X2/b =>[signal: VPB w=1]]']]
X_X_76__2 X_76__a_466_413# X_76__a_27_47# X_76__a_561_413# VPWR sky130_fd_pr__pfet_01v8_hvt w=420000u l=150000u
** [instance X3 of sky130_fd_pr__pfet_01v8_hvt, params={'w': '420000u', 'l': '150000u'} connections=['d: [connection X3/d =>[signal: a_634_159# w=1]]', 'g: [connection X3/g =>[signal: a_27_47# w=1]]', 's: [connection X3/s =>[signal: a_891_413# w=1]]', 'b: [connection X3/b =>[signal: VPB w=1]]']]
X_X_76__3 X_76__a_634_159# X_76__a_27_47# X_76__a_891_413# VPWR sky130_fd_pr__pfet_01v8_hvt w=420000u l=150000u
** [instance X4 of sky130_fd_pr__pfet_01v8_hvt, params={'w': '420000u', 'l': '150000u'} connections=['d: [connection X4/d =>[signal: a_381_47# w=1]]', 'g: [connection X4/g =>[signal: a_193_47# w=1]]', 's: [connection X4/s =>[signal: a_466_413# w=1]]', 'b: [connection X4/b =>[signal: VPB w=1]]']]
X_X_76__4 X_76__a_381_47# X_76__a_193_47# X_76__a_466_413# VPWR sky130_fd_pr__pfet_01v8_hvt w=420000u l=150000u
** [instance X5 of sky130_fd_pr__pfet_01v8_hvt, params={'w': '420000u', 'l': '150000u'} connections=['d: [connection X5/d =>[signal: VPWR w=1]]', 'g: [connection X5/g =>[signal: D w=1]]', 's: [connection X5/s =>[signal: a_381_47# w=1]]', 'b: [connection X5/b =>[signal: VPB w=1]]']]
X_X_76__5 VPWR _76_/D X_76__a_381_47# VPWR sky130_fd_pr__pfet_01v8_hvt w=420000u l=150000u
** [instance X6 of sky130_fd_pr__pfet_01v8_hvt, params={'w': '750000u', 'l': '150000u'} connections=['d: [connection X6/d =>[signal: VPWR w=1]]', 'g: [connection X6/g =>[signal: a_466_413# w=1]]', 's: [connection X6/s =>[signal: a_634_159# w=1]]', 'b: [connection X6/b =>[signal: VPB w=1]]']]
X_X_76__6 VPWR X_76__a_466_413# X_76__a_634_159# VPWR sky130_fd_pr__pfet_01v8_hvt w=750000u l=150000u
** [instance X7 of sky130_fd_pr__nfet_01v8, params={'w': '640000u', 'l': '150000u'} connections=['d: [connection X7/d =>[signal: VGND w=1]]', 'g: [connection X7/g =>[signal: a_466_413# w=1]]', 's: [connection X7/s =>[signal: a_634_159# w=1]]', 'b: [connection X7/b =>[signal: VNB w=1]]']]
X_X_76__7 VGND X_76__a_466_413# X_76__a_634_159# VGND sky130_fd_pr__nfet_01v8 w=640000u l=150000u
** [instance X8 of sky130_fd_pr__nfet_01v8, params={'w': '420000u', 'l': '150000u'} connections=['d: [connection X8/d =>[signal: a_1017_47# w=1]]', 'g: [connection X8/g =>[signal: a_1059_315# w=1]]', 's: [connection X8/s =>[signal: VGND w=1]]', 'b: [connection X8/b =>[signal: VNB w=1]]']]
X_X_76__8 X_76__a_1017_47# X_76__a_1059_315# VGND VGND sky130_fd_pr__nfet_01v8 w=420000u l=150000u
** [instance X9 of sky130_fd_pr__pfet_01v8_hvt, params={'w': '1e+06u', 'l': '150000u'} connections=['d: [connection X9/d =>[signal: a_1059_315# w=1]]', 'g: [connection X9/g =>[signal: a_891_413# w=1]]', 's: [connection X9/s =>[signal: VPWR w=1]]', 'b: [connection X9/b =>[signal: VPB w=1]]']]
X_X_76__9 X_76__a_1059_315# X_76__a_891_413# VPWR VPWR sky130_fd_pr__pfet_01v8_hvt w=1e+06u l=150000u
** [instance X10 of sky130_fd_pr__pfet_01v8_hvt, params={'w': '1e+06u', 'l': '150000u'} connections=['d: [connection X10/d =>[signal: Q w=1]]', 'g: [connection X10/g =>[signal: a_1059_315# w=1]]', 's: [connection X10/s =>[signal: VPWR w=1]]', 'b: [connection X10/b =>[signal: VPB w=1]]']]
X_X_76__10 _76_/Q X_76__a_1059_315# VPWR VPWR sky130_fd_pr__pfet_01v8_hvt w=1e+06u l=150000u
** [instance X11 of sky130_fd_pr__pfet_01v8_hvt, params={'w': '420000u', 'l': '150000u'} connections=['d: [connection X11/d =>[signal: a_561_413# w=1]]', 'g: [connection X11/g =>[signal: a_634_159# w=1]]', 's: [connection X11/s =>[signal: VPWR w=1]]', 'b: [connection X11/b =>[signal: VPB w=1]]']]
X_X_76__11 X_76__a_561_413# X_76__a_634_159# VPWR VPWR sky130_fd_pr__pfet_01v8_hvt w=420000u l=150000u
** [instance X12 of sky130_fd_pr__pfet_01v8_hvt, params={'w': '1e+06u', 'l': '150000u'} connections=['d: [connection X12/d =>[signal: VPWR w=1]]', 'g: [connection X12/g =>[signal: a_1059_315# w=1]]', 's: [connection X12/s =>[signal: Q w=1]]', 'b: [connection X12/b =>[signal: VPB w=1]]']]
X_X_76__12 VPWR X_76__a_1059_315# _76_/Q VPWR sky130_fd_pr__pfet_01v8_hvt w=1e+06u l=150000u
** [instance X13 of sky130_fd_pr__nfet_01v8, params={'w': '360000u', 'l': '150000u'} connections=['d: [connection X13/d =>[signal: a_891_413# w=1]]', 'g: [connection X13/g =>[signal: a_27_47# w=1]]', 's: [connection X13/s =>[signal: a_1017_47# w=1]]', 'b: [connection X13/b =>[signal: VNB w=1]]']]
X_X_76__13 X_76__a_891_413# X_76__a_27_47# X_76__a_1017_47# VGND sky130_fd_pr__nfet_01v8 w=360000u l=150000u
** [instance X14 of sky130_fd_pr__nfet_01v8, params={'w': '360000u', 'l': '150000u'} connections=['d: [connection X14/d =>[signal: a_634_159# w=1]]', 'g: [connection X14/g =>[signal: a_193_47# w=1]]', 's: [connection X14/s =>[signal: a_891_413# w=1]]', 'b: [connection X14/b =>[signal: VNB w=1]]']]
X_X_76__14 X_76__a_634_159# X_76__a_193_47# X_76__a_891_413# VGND sky130_fd_pr__nfet_01v8 w=360000u l=150000u
** [instance X15 of sky130_fd_pr__nfet_01v8, params={'w': '420000u', 'l': '150000u'} connections=['d: [connection X15/d =>[signal: a_592_47# w=1]]', 'g: [connection X15/g =>[signal: a_634_159# w=1]]', 's: [connection X15/s =>[signal: VGND w=1]]', 'b: [connection X15/b =>[signal: VNB w=1]]']]
X_X_76__15 X_76__a_592_47# X_76__a_634_159# VGND VGND sky130_fd_pr__nfet_01v8 w=420000u l=150000u
** [instance X16 of sky130_fd_pr__nfet_01v8, params={'w': '360000u', 'l': '150000u'} connections=['d: [connection X16/d =>[signal: a_466_413# w=1]]', 'g: [connection X16/g =>[signal: a_193_47# w=1]]', 's: [connection X16/s =>[signal: a_592_47# w=1]]', 'b: [connection X16/b =>[signal: VNB w=1]]']]
X_X_76__16 X_76__a_466_413# X_76__a_193_47# X_76__a_592_47# VGND sky130_fd_pr__nfet_01v8 w=360000u l=150000u
** [instance X17 of sky130_fd_pr__nfet_01v8, params={'w': '420000u', 'l': '150000u'} connections=['d: [connection X17/d =>[signal: VGND w=1]]', 'g: [connection X17/g =>[signal: a_27_47# w=1]]', 's: [connection X17/s =>[signal: a_193_47# w=1]]', 'b: [connection X17/b =>[signal: VNB w=1]]']]
X_X_76__17 VGND X_76__a_27_47# X_76__a_193_47# VGND sky130_fd_pr__nfet_01v8 w=420000u l=150000u
** [instance X18 of sky130_fd_pr__nfet_01v8, params={'w': '360000u', 'l': '150000u'} connections=['d: [connection X18/d =>[signal: a_381_47# w=1]]', 'g: [connection X18/g =>[signal: a_27_47# w=1]]', 's: [connection X18/s =>[signal: a_466_413# w=1]]', 'b: [connection X18/b =>[signal: VNB w=1]]']]
X_X_76__18 X_76__a_381_47# X_76__a_27_47# X_76__a_466_413# VGND sky130_fd_pr__nfet_01v8 w=360000u l=150000u
** [instance X19 of sky130_fd_pr__nfet_01v8, params={'w': '420000u', 'l': '150000u'} connections=['d: [connection X19/d =>[signal: a_27_47# w=1]]', 'g: [connection X19/g =>[signal: CLK w=1]]', 's: [connection X19/s =>[signal: VGND w=1]]', 'b: [connection X19/b =>[signal: VNB w=1]]']]
X_X_76__19 X_76__a_27_47# _76_/CLK VGND VGND sky130_fd_pr__nfet_01v8 w=420000u l=150000u
** [instance X20 of sky130_fd_pr__pfet_01v8_hvt, params={'w': '640000u', 'l': '150000u'} connections=['d: [connection X20/d =>[signal: a_27_47# w=1]]', 'g: [connection X20/g =>[signal: CLK w=1]]', 's: [connection X20/s =>[signal: VPWR w=1]]', 'b: [connection X20/b =>[signal: VPB w=1]]']]
X_X_76__20 X_76__a_27_47# _76_/CLK VPWR VPWR sky130_fd_pr__pfet_01v8_hvt w=640000u l=150000u
** [instance X21 of sky130_fd_pr__nfet_01v8, params={'w': '650000u', 'l': '150000u'} connections=['d: [connection X21/d =>[signal: Q w=1]]', 'g: [connection X21/g =>[signal: a_1059_315# w=1]]', 's: [connection X21/s =>[signal: VGND w=1]]', 'b: [connection X21/b =>[signal: VNB w=1]]']]
X_X_76__21 _76_/Q X_76__a_1059_315# VGND VGND sky130_fd_pr__nfet_01v8 w=650000u l=150000u
** [instance X22 of sky130_fd_pr__pfet_01v8_hvt, params={'w': '640000u', 'l': '150000u'} connections=['d: [connection X22/d =>[signal: VPWR w=1]]', 'g: [connection X22/g =>[signal: a_27_47# w=1]]', 's: [connection X22/s =>[signal: a_193_47# w=1]]', 'b: [connection X22/b =>[signal: VPB w=1]]']]
X_X_76__22 VPWR X_76__a_27_47# X_76__a_193_47# VPWR sky130_fd_pr__pfet_01v8_hvt w=640000u l=150000u
** [instance X23 of sky130_fd_pr__nfet_01v8, params={'w': '420000u', 'l': '150000u'} connections=['d: [connection X23/d =>[signal: VGND w=1]]', 'g: [connection X23/g =>[signal: D w=1]]', 's: [connection X23/s =>[signal: a_381_47# w=1]]', 'b: [connection X23/b =>[signal: VNB w=1]]']]
X_X_76__23 VGND _76_/D X_76__a_381_47# VGND sky130_fd_pr__nfet_01v8 w=420000u l=150000u
** [instance X24 of sky130_fd_pr__pfet_01v8_hvt, params={'w': '420000u', 'l': '150000u'} connections=['d: [connection X24/d =>[signal: a_975_413# w=1]]', 'g: [connection X24/g =>[signal: a_1059_315# w=1]]', 's: [connection X24/s =>[signal: VPWR w=1]]', 'b: [connection X24/b =>[signal: VPB w=1]]']]
X_X_76__24 X_76__a_975_413# X_76__a_1059_315# VPWR VPWR sky130_fd_pr__pfet_01v8_hvt w=420000u l=150000u
** [instance X25 of sky130_fd_pr__nfet_01v8, params={'w': '650000u', 'l': '150000u'} connections=['d: [connection X25/d =>[signal: VGND w=1]]', 'g: [connection X25/g =>[signal: a_1059_315# w=1]]', 's: [connection X25/s =>[signal: Q w=1]]', 'b: [connection X25/b =>[signal: VNB w=1]]']]
X_X_76__25 VGND X_76__a_1059_315# _76_/Q VGND sky130_fd_pr__nfet_01v8 w=650000u l=150000u

** replacing X_59_ with the contents of sky130_fd_sc_hd__dfxtp_2
** [instance X0 of sky130_fd_pr__pfet_01v8_hvt, params={'w': '420000u', 'l': '150000u'} connections=['d: [connection X0/d =>[signal: a_891_413# w=1]]', 'g: [connection X0/g =>[signal: a_193_47# w=1]]', 's: [connection X0/s =>[signal: a_975_413# w=1]]', 'b: [connection X0/b =>[signal: VPB w=1]]']]
X_X_59__0 X_59__a_891_413# X_59__a_193_47# X_59__a_975_413# VPWR sky130_fd_pr__pfet_01v8_hvt w=420000u l=150000u
** [instance X1 of sky130_fd_pr__nfet_01v8, params={'w': '650000u', 'l': '150000u'} connections=['d: [connection X1/d =>[signal: a_1059_315# w=1]]', 'g: [connection X1/g =>[signal: a_891_413# w=1]]', 's: [connection X1/s =>[signal: VGND w=1]]', 'b: [connection X1/b =>[signal: VNB w=1]]']]
X_X_59__1 X_59__a_1059_315# X_59__a_891_413# VGND VGND sky130_fd_pr__nfet_01v8 w=650000u l=150000u
** [instance X2 of sky130_fd_pr__pfet_01v8_hvt, params={'w': '420000u', 'l': '150000u'} connections=['d: [connection X2/d =>[signal: a_466_413# w=1]]', 'g: [connection X2/g =>[signal: a_27_47# w=1]]', 's: [connection X2/s =>[signal: a_561_413# w=1]]', 'b: [connection X2/b =>[signal: VPB w=1]]']]
X_X_59__2 X_59__a_466_413# X_59__a_27_47# X_59__a_561_413# VPWR sky130_fd_pr__pfet_01v8_hvt w=420000u l=150000u
** [instance X3 of sky130_fd_pr__pfet_01v8_hvt, params={'w': '420000u', 'l': '150000u'} connections=['d: [connection X3/d =>[signal: a_634_159# w=1]]', 'g: [connection X3/g =>[signal: a_27_47# w=1]]', 's: [connection X3/s =>[signal: a_891_413# w=1]]', 'b: [connection X3/b =>[signal: VPB w=1]]']]
X_X_59__3 X_59__a_634_159# X_59__a_27_47# X_59__a_891_413# VPWR sky130_fd_pr__pfet_01v8_hvt w=420000u l=150000u
** [instance X4 of sky130_fd_pr__pfet_01v8_hvt, params={'w': '420000u', 'l': '150000u'} connections=['d: [connection X4/d =>[signal: a_381_47# w=1]]', 'g: [connection X4/g =>[signal: a_193_47# w=1]]', 's: [connection X4/s =>[signal: a_466_413# w=1]]', 'b: [connection X4/b =>[signal: VPB w=1]]']]
X_X_59__4 X_59__a_381_47# X_59__a_193_47# X_59__a_466_413# VPWR sky130_fd_pr__pfet_01v8_hvt w=420000u l=150000u
** [instance X5 of sky130_fd_pr__pfet_01v8_hvt, params={'w': '420000u', 'l': '150000u'} connections=['d: [connection X5/d =>[signal: VPWR w=1]]', 'g: [connection X5/g =>[signal: D w=1]]', 's: [connection X5/s =>[signal: a_381_47# w=1]]', 'b: [connection X5/b =>[signal: VPB w=1]]']]
X_X_59__5 VPWR _59_/D X_59__a_381_47# VPWR sky130_fd_pr__pfet_01v8_hvt w=420000u l=150000u
** [instance X6 of sky130_fd_pr__pfet_01v8_hvt, params={'w': '750000u', 'l': '150000u'} connections=['d: [connection X6/d =>[signal: VPWR w=1]]', 'g: [connection X6/g =>[signal: a_466_413# w=1]]', 's: [connection X6/s =>[signal: a_634_159# w=1]]', 'b: [connection X6/b =>[signal: VPB w=1]]']]
X_X_59__6 VPWR X_59__a_466_413# X_59__a_634_159# VPWR sky130_fd_pr__pfet_01v8_hvt w=750000u l=150000u
** [instance X7 of sky130_fd_pr__nfet_01v8, params={'w': '640000u', 'l': '150000u'} connections=['d: [connection X7/d =>[signal: VGND w=1]]', 'g: [connection X7/g =>[signal: a_466_413# w=1]]', 's: [connection X7/s =>[signal: a_634_159# w=1]]', 'b: [connection X7/b =>[signal: VNB w=1]]']]
X_X_59__7 VGND X_59__a_466_413# X_59__a_634_159# VGND sky130_fd_pr__nfet_01v8 w=640000u l=150000u
** [instance X8 of sky130_fd_pr__nfet_01v8, params={'w': '420000u', 'l': '150000u'} connections=['d: [connection X8/d =>[signal: a_1017_47# w=1]]', 'g: [connection X8/g =>[signal: a_1059_315# w=1]]', 's: [connection X8/s =>[signal: VGND w=1]]', 'b: [connection X8/b =>[signal: VNB w=1]]']]
X_X_59__8 X_59__a_1017_47# X_59__a_1059_315# VGND VGND sky130_fd_pr__nfet_01v8 w=420000u l=150000u
** [instance X9 of sky130_fd_pr__pfet_01v8_hvt, params={'w': '1e+06u', 'l': '150000u'} connections=['d: [connection X9/d =>[signal: a_1059_315# w=1]]', 'g: [connection X9/g =>[signal: a_891_413# w=1]]', 's: [connection X9/s =>[signal: VPWR w=1]]', 'b: [connection X9/b =>[signal: VPB w=1]]']]
X_X_59__9 X_59__a_1059_315# X_59__a_891_413# VPWR VPWR sky130_fd_pr__pfet_01v8_hvt w=1e+06u l=150000u
** [instance X10 of sky130_fd_pr__pfet_01v8_hvt, params={'w': '1e+06u', 'l': '150000u'} connections=['d: [connection X10/d =>[signal: Q w=1]]', 'g: [connection X10/g =>[signal: a_1059_315# w=1]]', 's: [connection X10/s =>[signal: VPWR w=1]]', 'b: [connection X10/b =>[signal: VPB w=1]]']]
X_X_59__10 _59_/Q X_59__a_1059_315# VPWR VPWR sky130_fd_pr__pfet_01v8_hvt w=1e+06u l=150000u
** [instance X11 of sky130_fd_pr__pfet_01v8_hvt, params={'w': '420000u', 'l': '150000u'} connections=['d: [connection X11/d =>[signal: a_561_413# w=1]]', 'g: [connection X11/g =>[signal: a_634_159# w=1]]', 's: [connection X11/s =>[signal: VPWR w=1]]', 'b: [connection X11/b =>[signal: VPB w=1]]']]
X_X_59__11 X_59__a_561_413# X_59__a_634_159# VPWR VPWR sky130_fd_pr__pfet_01v8_hvt w=420000u l=150000u
** [instance X12 of sky130_fd_pr__pfet_01v8_hvt, params={'w': '1e+06u', 'l': '150000u'} connections=['d: [connection X12/d =>[signal: VPWR w=1]]', 'g: [connection X12/g =>[signal: a_1059_315# w=1]]', 's: [connection X12/s =>[signal: Q w=1]]', 'b: [connection X12/b =>[signal: VPB w=1]]']]
X_X_59__12 VPWR X_59__a_1059_315# _59_/Q VPWR sky130_fd_pr__pfet_01v8_hvt w=1e+06u l=150000u
** [instance X13 of sky130_fd_pr__nfet_01v8, params={'w': '360000u', 'l': '150000u'} connections=['d: [connection X13/d =>[signal: a_891_413# w=1]]', 'g: [connection X13/g =>[signal: a_27_47# w=1]]', 's: [connection X13/s =>[signal: a_1017_47# w=1]]', 'b: [connection X13/b =>[signal: VNB w=1]]']]
X_X_59__13 X_59__a_891_413# X_59__a_27_47# X_59__a_1017_47# VGND sky130_fd_pr__nfet_01v8 w=360000u l=150000u
** [instance X14 of sky130_fd_pr__nfet_01v8, params={'w': '360000u', 'l': '150000u'} connections=['d: [connection X14/d =>[signal: a_634_159# w=1]]', 'g: [connection X14/g =>[signal: a_193_47# w=1]]', 's: [connection X14/s =>[signal: a_891_413# w=1]]', 'b: [connection X14/b =>[signal: VNB w=1]]']]
X_X_59__14 X_59__a_634_159# X_59__a_193_47# X_59__a_891_413# VGND sky130_fd_pr__nfet_01v8 w=360000u l=150000u
** [instance X15 of sky130_fd_pr__nfet_01v8, params={'w': '420000u', 'l': '150000u'} connections=['d: [connection X15/d =>[signal: a_592_47# w=1]]', 'g: [connection X15/g =>[signal: a_634_159# w=1]]', 's: [connection X15/s =>[signal: VGND w=1]]', 'b: [connection X15/b =>[signal: VNB w=1]]']]
X_X_59__15 X_59__a_592_47# X_59__a_634_159# VGND VGND sky130_fd_pr__nfet_01v8 w=420000u l=150000u
** [instance X16 of sky130_fd_pr__nfet_01v8, params={'w': '360000u', 'l': '150000u'} connections=['d: [connection X16/d =>[signal: a_466_413# w=1]]', 'g: [connection X16/g =>[signal: a_193_47# w=1]]', 's: [connection X16/s =>[signal: a_592_47# w=1]]', 'b: [connection X16/b =>[signal: VNB w=1]]']]
X_X_59__16 X_59__a_466_413# X_59__a_193_47# X_59__a_592_47# VGND sky130_fd_pr__nfet_01v8 w=360000u l=150000u
** [instance X17 of sky130_fd_pr__nfet_01v8, params={'w': '420000u', 'l': '150000u'} connections=['d: [connection X17/d =>[signal: VGND w=1]]', 'g: [connection X17/g =>[signal: a_27_47# w=1]]', 's: [connection X17/s =>[signal: a_193_47# w=1]]', 'b: [connection X17/b =>[signal: VNB w=1]]']]
X_X_59__17 VGND X_59__a_27_47# X_59__a_193_47# VGND sky130_fd_pr__nfet_01v8 w=420000u l=150000u
** [instance X18 of sky130_fd_pr__nfet_01v8, params={'w': '360000u', 'l': '150000u'} connections=['d: [connection X18/d =>[signal: a_381_47# w=1]]', 'g: [connection X18/g =>[signal: a_27_47# w=1]]', 's: [connection X18/s =>[signal: a_466_413# w=1]]', 'b: [connection X18/b =>[signal: VNB w=1]]']]
X_X_59__18 X_59__a_381_47# X_59__a_27_47# X_59__a_466_413# VGND sky130_fd_pr__nfet_01v8 w=360000u l=150000u
** [instance X19 of sky130_fd_pr__nfet_01v8, params={'w': '420000u', 'l': '150000u'} connections=['d: [connection X19/d =>[signal: a_27_47# w=1]]', 'g: [connection X19/g =>[signal: CLK w=1]]', 's: [connection X19/s =>[signal: VGND w=1]]', 'b: [connection X19/b =>[signal: VNB w=1]]']]
X_X_59__19 X_59__a_27_47# _76_/CLK VGND VGND sky130_fd_pr__nfet_01v8 w=420000u l=150000u
** [instance X20 of sky130_fd_pr__pfet_01v8_hvt, params={'w': '640000u', 'l': '150000u'} connections=['d: [connection X20/d =>[signal: a_27_47# w=1]]', 'g: [connection X20/g =>[signal: CLK w=1]]', 's: [connection X20/s =>[signal: VPWR w=1]]', 'b: [connection X20/b =>[signal: VPB w=1]]']]
X_X_59__20 X_59__a_27_47# _76_/CLK VPWR VPWR sky130_fd_pr__pfet_01v8_hvt w=640000u l=150000u
** [instance X21 of sky130_fd_pr__nfet_01v8, params={'w': '650000u', 'l': '150000u'} connections=['d: [connection X21/d =>[signal: Q w=1]]', 'g: [connection X21/g =>[signal: a_1059_315# w=1]]', 's: [connection X21/s =>[signal: VGND w=1]]', 'b: [connection X21/b =>[signal: VNB w=1]]']]
X_X_59__21 _59_/Q X_59__a_1059_315# VGND VGND sky130_fd_pr__nfet_01v8 w=650000u l=150000u
** [instance X22 of sky130_fd_pr__pfet_01v8_hvt, params={'w': '640000u', 'l': '150000u'} connections=['d: [connection X22/d =>[signal: VPWR w=1]]', 'g: [connection X22/g =>[signal: a_27_47# w=1]]', 's: [connection X22/s =>[signal: a_193_47# w=1]]', 'b: [connection X22/b =>[signal: VPB w=1]]']]
X_X_59__22 VPWR X_59__a_27_47# X_59__a_193_47# VPWR sky130_fd_pr__pfet_01v8_hvt w=640000u l=150000u
** [instance X23 of sky130_fd_pr__nfet_01v8, params={'w': '420000u', 'l': '150000u'} connections=['d: [connection X23/d =>[signal: VGND w=1]]', 'g: [connection X23/g =>[signal: D w=1]]', 's: [connection X23/s =>[signal: a_381_47# w=1]]', 'b: [connection X23/b =>[signal: VNB w=1]]']]
X_X_59__23 VGND _59_/D X_59__a_381_47# VGND sky130_fd_pr__nfet_01v8 w=420000u l=150000u
** [instance X24 of sky130_fd_pr__pfet_01v8_hvt, params={'w': '420000u', 'l': '150000u'} connections=['d: [connection X24/d =>[signal: a_975_413# w=1]]', 'g: [connection X24/g =>[signal: a_1059_315# w=1]]', 's: [connection X24/s =>[signal: VPWR w=1]]', 'b: [connection X24/b =>[signal: VPB w=1]]']]
X_X_59__24 X_59__a_975_413# X_59__a_1059_315# VPWR VPWR sky130_fd_pr__pfet_01v8_hvt w=420000u l=150000u
** [instance X25 of sky130_fd_pr__nfet_01v8, params={'w': '650000u', 'l': '150000u'} connections=['d: [connection X25/d =>[signal: VGND w=1]]', 'g: [connection X25/g =>[signal: a_1059_315# w=1]]', 's: [connection X25/s =>[signal: Q w=1]]', 'b: [connection X25/b =>[signal: VNB w=1]]']]
X_X_59__25 VGND X_59__a_1059_315# _59_/Q VGND sky130_fd_pr__nfet_01v8 w=650000u l=150000u

** replacing XFILLER_13_48 with the contents of sky130_fd_sc_hd__decap_3
** [instance X0 of sky130_fd_pr__pfet_01v8_hvt, params={'w': '870000u', 'l': '590000u'} connections=['d: [connection X0/d =>[signal: VPWR w=1]]', 'g: [connection X0/g =>[signal: VGND w=1]]', 's: [connection X0/s =>[signal: VPWR w=1]]', 'b: [connection X0/b =>[signal: VPB w=1]]']]
X_XFILLER_13_48_0 VPWR VGND VPWR VPWR sky130_fd_pr__pfet_01v8_hvt w=870000u l=590000u
** [instance X1 of sky130_fd_pr__nfet_01v8, params={'w': '550000u', 'l': '590000u'} connections=['d: [connection X1/d =>[signal: VGND w=1]]', 'g: [connection X1/g =>[signal: VPWR w=1]]', 's: [connection X1/s =>[signal: VGND w=1]]', 'b: [connection X1/b =>[signal: VNB w=1]]']]
X_XFILLER_13_48_1 VGND VPWR VGND VGND sky130_fd_pr__nfet_01v8 w=550000u l=590000u

** replacing XTAP_TAPCELL_ROW_9_38 with the contents of sky130_fd_sc_hd__tapvpwrvgnd_1

** replacing XTAP_TAPCELL_ROW_0_29 with the contents of sky130_fd_sc_hd__tapvpwrvgnd_1

** replacing Xinput6 with the contents of sky130_fd_sc_hd__clkdlybuf4s25_1
** [instance X0 of sky130_fd_pr__pfet_01v8_hvt, params={'w': '820000u', 'l': '250000u'} connections=['d: [connection X0/d =>[signal: a_355_47# w=1]]', 'g: [connection X0/g =>[signal: a_244_47# w=1]]', 's: [connection X0/s =>[signal: VPWR w=1]]', 'b: [connection X0/b =>[signal: VPB w=1]]']]
X_Xinput6_0 Xinput6_a_355_47# Xinput6_a_244_47# VPWR VPWR sky130_fd_pr__pfet_01v8_hvt w=820000u l=250000u
** [instance X1 of sky130_fd_pr__pfet_01v8_hvt, params={'w': '820000u', 'l': '250000u'} connections=['d: [connection X1/d =>[signal: VPWR w=1]]', 'g: [connection X1/g =>[signal: a_27_47# w=1]]', 's: [connection X1/s =>[signal: a_244_47# w=1]]', 'b: [connection X1/b =>[signal: VPB w=1]]']]
X_Xinput6_1 VPWR Xinput6_a_27_47# Xinput6_a_244_47# VPWR sky130_fd_pr__pfet_01v8_hvt w=820000u l=250000u
** [instance X2 of sky130_fd_pr__pfet_01v8_hvt, params={'w': '1e+06u', 'l': '150000u'} connections=['d: [connection X2/d =>[signal: VPWR w=1]]', 'g: [connection X2/g =>[signal: a_355_47# w=1]]', 's: [connection X2/s =>[signal: X w=1]]', 'b: [connection X2/b =>[signal: VPB w=1]]']]
X_Xinput6_2 VPWR Xinput6_a_355_47# input6/X VPWR sky130_fd_pr__pfet_01v8_hvt w=1e+06u l=150000u
** [instance X3 of sky130_fd_pr__pfet_01v8_hvt, params={'w': '1e+06u', 'l': '150000u'} connections=['d: [connection X3/d =>[signal: a_27_47# w=1]]', 'g: [connection X3/g =>[signal: A w=1]]', 's: [connection X3/s =>[signal: VPWR w=1]]', 'b: [connection X3/b =>[signal: VPB w=1]]']]
X_Xinput6_3 Xinput6_a_27_47# scan_en VPWR VPWR sky130_fd_pr__pfet_01v8_hvt w=1e+06u l=150000u
** [instance X4 of sky130_fd_pr__nfet_01v8, params={'w': '650000u', 'l': '250000u'} connections=['d: [connection X4/d =>[signal: a_355_47# w=1]]', 'g: [connection X4/g =>[signal: a_244_47# w=1]]', 's: [connection X4/s =>[signal: VGND w=1]]', 'b: [connection X4/b =>[signal: VNB w=1]]']]
X_Xinput6_4 Xinput6_a_355_47# Xinput6_a_244_47# VGND VGND sky130_fd_pr__nfet_01v8 w=650000u l=250000u
** [instance X5 of sky130_fd_pr__nfet_01v8, params={'w': '650000u', 'l': '250000u'} connections=['d: [connection X5/d =>[signal: VGND w=1]]', 'g: [connection X5/g =>[signal: a_27_47# w=1]]', 's: [connection X5/s =>[signal: a_244_47# w=1]]', 'b: [connection X5/b =>[signal: VNB w=1]]']]
X_Xinput6_5 VGND Xinput6_a_27_47# Xinput6_a_244_47# VGND sky130_fd_pr__nfet_01v8 w=650000u l=250000u
** [instance X6 of sky130_fd_pr__nfet_01v8, params={'w': '420000u', 'l': '150000u'} connections=['d: [connection X6/d =>[signal: VGND w=1]]', 'g: [connection X6/g =>[signal: a_355_47# w=1]]', 's: [connection X6/s =>[signal: X w=1]]', 'b: [connection X6/b =>[signal: VNB w=1]]']]
X_Xinput6_6 VGND Xinput6_a_355_47# input6/X VGND sky130_fd_pr__nfet_01v8 w=420000u l=150000u
** [instance X7 of sky130_fd_pr__nfet_01v8, params={'w': '420000u', 'l': '150000u'} connections=['d: [connection X7/d =>[signal: a_27_47# w=1]]', 'g: [connection X7/g =>[signal: A w=1]]', 's: [connection X7/s =>[signal: VGND w=1]]', 'b: [connection X7/b =>[signal: VNB w=1]]']]
X_Xinput6_7 Xinput6_a_27_47# scan_en VGND VGND sky130_fd_pr__nfet_01v8 w=420000u l=150000u

** replacing XFILLER_10_27 with the contents of sky130_fd_sc_hd__fill_1

** replacing X_58_ with the contents of sky130_fd_sc_hd__mux2_1
** [instance X0 of sky130_fd_pr__pfet_01v8_hvt, params={'w': '420000u', 'l': '150000u'} connections=['d: [connection X0/d =>[signal: VPWR w=1]]', 'g: [connection X0/g =>[signal: S w=1]]', 's: [connection X0/s =>[signal: a_218_374# w=1]]', 'b: [connection X0/b =>[signal: VPB w=1]]']]
X_X_58__0 VPWR _58_/S X_58__a_218_374# VPWR sky130_fd_pr__pfet_01v8_hvt w=420000u l=150000u
** [instance X1 of sky130_fd_pr__nfet_01v8, params={'w': '420000u', 'l': '150000u'} connections=['d: [connection X1/d =>[signal: a_76_199# w=1]]', 'g: [connection X1/g =>[signal: A0 w=1]]', 's: [connection X1/s =>[signal: a_439_47# w=1]]', 'b: [connection X1/b =>[signal: VNB w=1]]']]
X_X_58__1 X_58__a_76_199# _58_/A0 X_58__a_439_47# VGND sky130_fd_pr__nfet_01v8 w=420000u l=150000u
** [instance X2 of sky130_fd_pr__pfet_01v8_hvt, params={'w': '420000u', 'l': '150000u'} connections=['d: [connection X2/d =>[signal: a_535_374# w=1]]', 'g: [connection X2/g =>[signal: a_505_21# w=1]]', 's: [connection X2/s =>[signal: VPWR w=1]]', 'b: [connection X2/b =>[signal: VPB w=1]]']]
X_X_58__2 X_58__a_535_374# X_58__a_505_21# VPWR VPWR sky130_fd_pr__pfet_01v8_hvt w=420000u l=150000u
** [instance X3 of sky130_fd_pr__pfet_01v8_hvt, params={'w': '420000u', 'l': '150000u'} connections=['d: [connection X3/d =>[signal: VPWR w=1]]', 'g: [connection X3/g =>[signal: S w=1]]', 's: [connection X3/s =>[signal: a_505_21# w=1]]', 'b: [connection X3/b =>[signal: VPB w=1]]']]
X_X_58__3 VPWR _58_/S X_58__a_505_21# VPWR sky130_fd_pr__pfet_01v8_hvt w=420000u l=150000u
** [instance X4 of sky130_fd_pr__pfet_01v8_hvt, params={'w': '420000u', 'l': '150000u'} connections=['d: [connection X4/d =>[signal: a_76_199# w=1]]', 'g: [connection X4/g =>[signal: A1 w=1]]', 's: [connection X4/s =>[signal: a_535_374# w=1]]', 'b: [connection X4/b =>[signal: VPB w=1]]']]
X_X_58__4 X_58__a_76_199# _58_/A1 X_58__a_535_374# VPWR sky130_fd_pr__pfet_01v8_hvt w=420000u l=150000u
** [instance X5 of sky130_fd_pr__nfet_01v8, params={'w': '420000u', 'l': '150000u'} connections=['d: [connection X5/d =>[signal: a_218_47# w=1]]', 'g: [connection X5/g =>[signal: A1 w=1]]', 's: [connection X5/s =>[signal: a_76_199# w=1]]', 'b: [connection X5/b =>[signal: VNB w=1]]']]
X_X_58__5 X_58__a_218_47# _58_/A1 X_58__a_76_199# VGND sky130_fd_pr__nfet_01v8 w=420000u l=150000u
** [instance X6 of sky130_fd_pr__pfet_01v8_hvt, params={'w': '420000u', 'l': '150000u'} connections=['d: [connection X6/d =>[signal: a_218_374# w=1]]', 'g: [connection X6/g =>[signal: A0 w=1]]', 's: [connection X6/s =>[signal: a_76_199# w=1]]', 'b: [connection X6/b =>[signal: VPB w=1]]']]
X_X_58__6 X_58__a_218_374# _58_/A0 X_58__a_76_199# VPWR sky130_fd_pr__pfet_01v8_hvt w=420000u l=150000u
** [instance X7 of sky130_fd_pr__nfet_01v8, params={'w': '650000u', 'l': '150000u'} connections=['d: [connection X7/d =>[signal: X w=1]]', 'g: [connection X7/g =>[signal: a_76_199# w=1]]', 's: [connection X7/s =>[signal: VGND w=1]]', 'b: [connection X7/b =>[signal: VNB w=1]]']]
X_X_58__7 _76_/D X_58__a_76_199# VGND VGND sky130_fd_pr__nfet_01v8 w=650000u l=150000u
** [instance X8 of sky130_fd_pr__pfet_01v8_hvt, params={'w': '1e+06u', 'l': '150000u'} connections=['d: [connection X8/d =>[signal: X w=1]]', 'g: [connection X8/g =>[signal: a_76_199# w=1]]', 's: [connection X8/s =>[signal: VPWR w=1]]', 'b: [connection X8/b =>[signal: VPB w=1]]']]
X_X_58__8 _76_/D X_58__a_76_199# VPWR VPWR sky130_fd_pr__pfet_01v8_hvt w=1e+06u l=150000u
** [instance X9 of sky130_fd_pr__nfet_01v8, params={'w': '420000u', 'l': '150000u'} connections=['d: [connection X9/d =>[signal: VGND w=1]]', 'g: [connection X9/g =>[signal: S w=1]]', 's: [connection X9/s =>[signal: a_218_47# w=1]]', 'b: [connection X9/b =>[signal: VNB w=1]]']]
X_X_58__9 VGND _58_/S X_58__a_218_47# VGND sky130_fd_pr__nfet_01v8 w=420000u l=150000u
** [instance X10 of sky130_fd_pr__nfet_01v8, params={'w': '420000u', 'l': '150000u'} connections=['d: [connection X10/d =>[signal: VGND w=1]]', 'g: [connection X10/g =>[signal: S w=1]]', 's: [connection X10/s =>[signal: a_505_21# w=1]]', 'b: [connection X10/b =>[signal: VNB w=1]]']]
X_X_58__10 VGND _58_/S X_58__a_505_21# VGND sky130_fd_pr__nfet_01v8 w=420000u l=150000u
** [instance X11 of sky130_fd_pr__nfet_01v8, params={'w': '420000u', 'l': '150000u'} connections=['d: [connection X11/d =>[signal: a_439_47# w=1]]', 'g: [connection X11/g =>[signal: a_505_21# w=1]]', 's: [connection X11/s =>[signal: VGND w=1]]', 'b: [connection X11/b =>[signal: VNB w=1]]']]
X_X_58__11 X_58__a_439_47# X_58__a_505_21# VGND VGND sky130_fd_pr__nfet_01v8 w=420000u l=150000u

** replacing X_75_ with the contents of sky130_fd_sc_hd__dfxtp_2
** [instance X0 of sky130_fd_pr__pfet_01v8_hvt, params={'w': '420000u', 'l': '150000u'} connections=['d: [connection X0/d =>[signal: a_891_413# w=1]]', 'g: [connection X0/g =>[signal: a_193_47# w=1]]', 's: [connection X0/s =>[signal: a_975_413# w=1]]', 'b: [connection X0/b =>[signal: VPB w=1]]']]
X_X_75__0 X_75__a_891_413# X_75__a_193_47# X_75__a_975_413# VPWR sky130_fd_pr__pfet_01v8_hvt w=420000u l=150000u
** [instance X1 of sky130_fd_pr__nfet_01v8, params={'w': '650000u', 'l': '150000u'} connections=['d: [connection X1/d =>[signal: a_1059_315# w=1]]', 'g: [connection X1/g =>[signal: a_891_413# w=1]]', 's: [connection X1/s =>[signal: VGND w=1]]', 'b: [connection X1/b =>[signal: VNB w=1]]']]
X_X_75__1 X_75__a_1059_315# X_75__a_891_413# VGND VGND sky130_fd_pr__nfet_01v8 w=650000u l=150000u
** [instance X2 of sky130_fd_pr__pfet_01v8_hvt, params={'w': '420000u', 'l': '150000u'} connections=['d: [connection X2/d =>[signal: a_466_413# w=1]]', 'g: [connection X2/g =>[signal: a_27_47# w=1]]', 's: [connection X2/s =>[signal: a_561_413# w=1]]', 'b: [connection X2/b =>[signal: VPB w=1]]']]
X_X_75__2 X_75__a_466_413# X_75__a_27_47# X_75__a_561_413# VPWR sky130_fd_pr__pfet_01v8_hvt w=420000u l=150000u
** [instance X3 of sky130_fd_pr__pfet_01v8_hvt, params={'w': '420000u', 'l': '150000u'} connections=['d: [connection X3/d =>[signal: a_634_159# w=1]]', 'g: [connection X3/g =>[signal: a_27_47# w=1]]', 's: [connection X3/s =>[signal: a_891_413# w=1]]', 'b: [connection X3/b =>[signal: VPB w=1]]']]
X_X_75__3 X_75__a_634_159# X_75__a_27_47# X_75__a_891_413# VPWR sky130_fd_pr__pfet_01v8_hvt w=420000u l=150000u
** [instance X4 of sky130_fd_pr__pfet_01v8_hvt, params={'w': '420000u', 'l': '150000u'} connections=['d: [connection X4/d =>[signal: a_381_47# w=1]]', 'g: [connection X4/g =>[signal: a_193_47# w=1]]', 's: [connection X4/s =>[signal: a_466_413# w=1]]', 'b: [connection X4/b =>[signal: VPB w=1]]']]
X_X_75__4 X_75__a_381_47# X_75__a_193_47# X_75__a_466_413# VPWR sky130_fd_pr__pfet_01v8_hvt w=420000u l=150000u
** [instance X5 of sky130_fd_pr__pfet_01v8_hvt, params={'w': '420000u', 'l': '150000u'} connections=['d: [connection X5/d =>[signal: VPWR w=1]]', 'g: [connection X5/g =>[signal: D w=1]]', 's: [connection X5/s =>[signal: a_381_47# w=1]]', 'b: [connection X5/b =>[signal: VPB w=1]]']]
X_X_75__5 VPWR _75_/D X_75__a_381_47# VPWR sky130_fd_pr__pfet_01v8_hvt w=420000u l=150000u
** [instance X6 of sky130_fd_pr__pfet_01v8_hvt, params={'w': '750000u', 'l': '150000u'} connections=['d: [connection X6/d =>[signal: VPWR w=1]]', 'g: [connection X6/g =>[signal: a_466_413# w=1]]', 's: [connection X6/s =>[signal: a_634_159# w=1]]', 'b: [connection X6/b =>[signal: VPB w=1]]']]
X_X_75__6 VPWR X_75__a_466_413# X_75__a_634_159# VPWR sky130_fd_pr__pfet_01v8_hvt w=750000u l=150000u
** [instance X7 of sky130_fd_pr__nfet_01v8, params={'w': '640000u', 'l': '150000u'} connections=['d: [connection X7/d =>[signal: VGND w=1]]', 'g: [connection X7/g =>[signal: a_466_413# w=1]]', 's: [connection X7/s =>[signal: a_634_159# w=1]]', 'b: [connection X7/b =>[signal: VNB w=1]]']]
X_X_75__7 VGND X_75__a_466_413# X_75__a_634_159# VGND sky130_fd_pr__nfet_01v8 w=640000u l=150000u
** [instance X8 of sky130_fd_pr__nfet_01v8, params={'w': '420000u', 'l': '150000u'} connections=['d: [connection X8/d =>[signal: a_1017_47# w=1]]', 'g: [connection X8/g =>[signal: a_1059_315# w=1]]', 's: [connection X8/s =>[signal: VGND w=1]]', 'b: [connection X8/b =>[signal: VNB w=1]]']]
X_X_75__8 X_75__a_1017_47# X_75__a_1059_315# VGND VGND sky130_fd_pr__nfet_01v8 w=420000u l=150000u
** [instance X9 of sky130_fd_pr__pfet_01v8_hvt, params={'w': '1e+06u', 'l': '150000u'} connections=['d: [connection X9/d =>[signal: a_1059_315# w=1]]', 'g: [connection X9/g =>[signal: a_891_413# w=1]]', 's: [connection X9/s =>[signal: VPWR w=1]]', 'b: [connection X9/b =>[signal: VPB w=1]]']]
X_X_75__9 X_75__a_1059_315# X_75__a_891_413# VPWR VPWR sky130_fd_pr__pfet_01v8_hvt w=1e+06u l=150000u
** [instance X10 of sky130_fd_pr__pfet_01v8_hvt, params={'w': '1e+06u', 'l': '150000u'} connections=['d: [connection X10/d =>[signal: Q w=1]]', 'g: [connection X10/g =>[signal: a_1059_315# w=1]]', 's: [connection X10/s =>[signal: VPWR w=1]]', 'b: [connection X10/b =>[signal: VPB w=1]]']]
X_X_75__10 _75_/Q X_75__a_1059_315# VPWR VPWR sky130_fd_pr__pfet_01v8_hvt w=1e+06u l=150000u
** [instance X11 of sky130_fd_pr__pfet_01v8_hvt, params={'w': '420000u', 'l': '150000u'} connections=['d: [connection X11/d =>[signal: a_561_413# w=1]]', 'g: [connection X11/g =>[signal: a_634_159# w=1]]', 's: [connection X11/s =>[signal: VPWR w=1]]', 'b: [connection X11/b =>[signal: VPB w=1]]']]
X_X_75__11 X_75__a_561_413# X_75__a_634_159# VPWR VPWR sky130_fd_pr__pfet_01v8_hvt w=420000u l=150000u
** [instance X12 of sky130_fd_pr__pfet_01v8_hvt, params={'w': '1e+06u', 'l': '150000u'} connections=['d: [connection X12/d =>[signal: VPWR w=1]]', 'g: [connection X12/g =>[signal: a_1059_315# w=1]]', 's: [connection X12/s =>[signal: Q w=1]]', 'b: [connection X12/b =>[signal: VPB w=1]]']]
X_X_75__12 VPWR X_75__a_1059_315# _75_/Q VPWR sky130_fd_pr__pfet_01v8_hvt w=1e+06u l=150000u
** [instance X13 of sky130_fd_pr__nfet_01v8, params={'w': '360000u', 'l': '150000u'} connections=['d: [connection X13/d =>[signal: a_891_413# w=1]]', 'g: [connection X13/g =>[signal: a_27_47# w=1]]', 's: [connection X13/s =>[signal: a_1017_47# w=1]]', 'b: [connection X13/b =>[signal: VNB w=1]]']]
X_X_75__13 X_75__a_891_413# X_75__a_27_47# X_75__a_1017_47# VGND sky130_fd_pr__nfet_01v8 w=360000u l=150000u
** [instance X14 of sky130_fd_pr__nfet_01v8, params={'w': '360000u', 'l': '150000u'} connections=['d: [connection X14/d =>[signal: a_634_159# w=1]]', 'g: [connection X14/g =>[signal: a_193_47# w=1]]', 's: [connection X14/s =>[signal: a_891_413# w=1]]', 'b: [connection X14/b =>[signal: VNB w=1]]']]
X_X_75__14 X_75__a_634_159# X_75__a_193_47# X_75__a_891_413# VGND sky130_fd_pr__nfet_01v8 w=360000u l=150000u
** [instance X15 of sky130_fd_pr__nfet_01v8, params={'w': '420000u', 'l': '150000u'} connections=['d: [connection X15/d =>[signal: a_592_47# w=1]]', 'g: [connection X15/g =>[signal: a_634_159# w=1]]', 's: [connection X15/s =>[signal: VGND w=1]]', 'b: [connection X15/b =>[signal: VNB w=1]]']]
X_X_75__15 X_75__a_592_47# X_75__a_634_159# VGND VGND sky130_fd_pr__nfet_01v8 w=420000u l=150000u
** [instance X16 of sky130_fd_pr__nfet_01v8, params={'w': '360000u', 'l': '150000u'} connections=['d: [connection X16/d =>[signal: a_466_413# w=1]]', 'g: [connection X16/g =>[signal: a_193_47# w=1]]', 's: [connection X16/s =>[signal: a_592_47# w=1]]', 'b: [connection X16/b =>[signal: VNB w=1]]']]
X_X_75__16 X_75__a_466_413# X_75__a_193_47# X_75__a_592_47# VGND sky130_fd_pr__nfet_01v8 w=360000u l=150000u
** [instance X17 of sky130_fd_pr__nfet_01v8, params={'w': '420000u', 'l': '150000u'} connections=['d: [connection X17/d =>[signal: VGND w=1]]', 'g: [connection X17/g =>[signal: a_27_47# w=1]]', 's: [connection X17/s =>[signal: a_193_47# w=1]]', 'b: [connection X17/b =>[signal: VNB w=1]]']]
X_X_75__17 VGND X_75__a_27_47# X_75__a_193_47# VGND sky130_fd_pr__nfet_01v8 w=420000u l=150000u
** [instance X18 of sky130_fd_pr__nfet_01v8, params={'w': '360000u', 'l': '150000u'} connections=['d: [connection X18/d =>[signal: a_381_47# w=1]]', 'g: [connection X18/g =>[signal: a_27_47# w=1]]', 's: [connection X18/s =>[signal: a_466_413# w=1]]', 'b: [connection X18/b =>[signal: VNB w=1]]']]
X_X_75__18 X_75__a_381_47# X_75__a_27_47# X_75__a_466_413# VGND sky130_fd_pr__nfet_01v8 w=360000u l=150000u
** [instance X19 of sky130_fd_pr__nfet_01v8, params={'w': '420000u', 'l': '150000u'} connections=['d: [connection X19/d =>[signal: a_27_47# w=1]]', 'g: [connection X19/g =>[signal: CLK w=1]]', 's: [connection X19/s =>[signal: VGND w=1]]', 'b: [connection X19/b =>[signal: VNB w=1]]']]
X_X_75__19 X_75__a_27_47# _76_/CLK VGND VGND sky130_fd_pr__nfet_01v8 w=420000u l=150000u
** [instance X20 of sky130_fd_pr__pfet_01v8_hvt, params={'w': '640000u', 'l': '150000u'} connections=['d: [connection X20/d =>[signal: a_27_47# w=1]]', 'g: [connection X20/g =>[signal: CLK w=1]]', 's: [connection X20/s =>[signal: VPWR w=1]]', 'b: [connection X20/b =>[signal: VPB w=1]]']]
X_X_75__20 X_75__a_27_47# _76_/CLK VPWR VPWR sky130_fd_pr__pfet_01v8_hvt w=640000u l=150000u
** [instance X21 of sky130_fd_pr__nfet_01v8, params={'w': '650000u', 'l': '150000u'} connections=['d: [connection X21/d =>[signal: Q w=1]]', 'g: [connection X21/g =>[signal: a_1059_315# w=1]]', 's: [connection X21/s =>[signal: VGND w=1]]', 'b: [connection X21/b =>[signal: VNB w=1]]']]
X_X_75__21 _75_/Q X_75__a_1059_315# VGND VGND sky130_fd_pr__nfet_01v8 w=650000u l=150000u
** [instance X22 of sky130_fd_pr__pfet_01v8_hvt, params={'w': '640000u', 'l': '150000u'} connections=['d: [connection X22/d =>[signal: VPWR w=1]]', 'g: [connection X22/g =>[signal: a_27_47# w=1]]', 's: [connection X22/s =>[signal: a_193_47# w=1]]', 'b: [connection X22/b =>[signal: VPB w=1]]']]
X_X_75__22 VPWR X_75__a_27_47# X_75__a_193_47# VPWR sky130_fd_pr__pfet_01v8_hvt w=640000u l=150000u
** [instance X23 of sky130_fd_pr__nfet_01v8, params={'w': '420000u', 'l': '150000u'} connections=['d: [connection X23/d =>[signal: VGND w=1]]', 'g: [connection X23/g =>[signal: D w=1]]', 's: [connection X23/s =>[signal: a_381_47# w=1]]', 'b: [connection X23/b =>[signal: VNB w=1]]']]
X_X_75__23 VGND _75_/D X_75__a_381_47# VGND sky130_fd_pr__nfet_01v8 w=420000u l=150000u
** [instance X24 of sky130_fd_pr__pfet_01v8_hvt, params={'w': '420000u', 'l': '150000u'} connections=['d: [connection X24/d =>[signal: a_975_413# w=1]]', 'g: [connection X24/g =>[signal: a_1059_315# w=1]]', 's: [connection X24/s =>[signal: VPWR w=1]]', 'b: [connection X24/b =>[signal: VPB w=1]]']]
X_X_75__24 X_75__a_975_413# X_75__a_1059_315# VPWR VPWR sky130_fd_pr__pfet_01v8_hvt w=420000u l=150000u
** [instance X25 of sky130_fd_pr__nfet_01v8, params={'w': '650000u', 'l': '150000u'} connections=['d: [connection X25/d =>[signal: VGND w=1]]', 'g: [connection X25/g =>[signal: a_1059_315# w=1]]', 's: [connection X25/s =>[signal: Q w=1]]', 'b: [connection X25/b =>[signal: VNB w=1]]']]
X_X_75__25 VGND X_75__a_1059_315# _75_/Q VGND sky130_fd_pr__nfet_01v8 w=650000u l=150000u

** replacing XPHY_EDGE_ROW_10_Left_24 with the contents of sky130_fd_sc_hd__decap_3
** [instance X0 of sky130_fd_pr__pfet_01v8_hvt, params={'w': '870000u', 'l': '590000u'} connections=['d: [connection X0/d =>[signal: VPWR w=1]]', 'g: [connection X0/g =>[signal: VGND w=1]]', 's: [connection X0/s =>[signal: VPWR w=1]]', 'b: [connection X0/b =>[signal: VPB w=1]]']]
X_XPHY_EDGE_ROW_10_Left_24_0 VPWR VGND VPWR VPWR sky130_fd_pr__pfet_01v8_hvt w=870000u l=590000u
** [instance X1 of sky130_fd_pr__nfet_01v8, params={'w': '550000u', 'l': '590000u'} connections=['d: [connection X1/d =>[signal: VGND w=1]]', 'g: [connection X1/g =>[signal: VPWR w=1]]', 's: [connection X1/s =>[signal: VGND w=1]]', 'b: [connection X1/b =>[signal: VNB w=1]]']]
X_XPHY_EDGE_ROW_10_Left_24_1 VGND VPWR VGND VGND sky130_fd_pr__nfet_01v8 w=550000u l=590000u

** replacing XFILLER_8_82 with the contents of sky130_fd_sc_hd__fill_1

** replacing XPHY_EDGE_ROW_4_Right_4 with the contents of sky130_fd_sc_hd__decap_3
** [instance X0 of sky130_fd_pr__pfet_01v8_hvt, params={'w': '870000u', 'l': '590000u'} connections=['d: [connection X0/d =>[signal: VPWR w=1]]', 'g: [connection X0/g =>[signal: VGND w=1]]', 's: [connection X0/s =>[signal: VPWR w=1]]', 'b: [connection X0/b =>[signal: VPB w=1]]']]
X_XPHY_EDGE_ROW_4_Right_4_0 VPWR VGND VPWR VPWR sky130_fd_pr__pfet_01v8_hvt w=870000u l=590000u
** [instance X1 of sky130_fd_pr__nfet_01v8, params={'w': '550000u', 'l': '590000u'} connections=['d: [connection X1/d =>[signal: VGND w=1]]', 'g: [connection X1/g =>[signal: VPWR w=1]]', 's: [connection X1/s =>[signal: VGND w=1]]', 'b: [connection X1/b =>[signal: VNB w=1]]']]
X_XPHY_EDGE_ROW_4_Right_4_1 VGND VPWR VGND VGND sky130_fd_pr__nfet_01v8 w=550000u l=590000u

** replacing XFILLER_13_27 with the contents of sky130_fd_sc_hd__fill_1

** replacing XFILLER_4_29 with the contents of sky130_fd_sc_hd__fill_1

** replacing Xinput7 with the contents of sky130_fd_sc_hd__clkdlybuf4s25_1
** [instance X0 of sky130_fd_pr__pfet_01v8_hvt, params={'w': '820000u', 'l': '250000u'} connections=['d: [connection X0/d =>[signal: a_355_47# w=1]]', 'g: [connection X0/g =>[signal: a_244_47# w=1]]', 's: [connection X0/s =>[signal: VPWR w=1]]', 'b: [connection X0/b =>[signal: VPB w=1]]']]
X_Xinput7_0 Xinput7_a_355_47# Xinput7_a_244_47# VPWR VPWR sky130_fd_pr__pfet_01v8_hvt w=820000u l=250000u
** [instance X1 of sky130_fd_pr__pfet_01v8_hvt, params={'w': '820000u', 'l': '250000u'} connections=['d: [connection X1/d =>[signal: VPWR w=1]]', 'g: [connection X1/g =>[signal: a_27_47# w=1]]', 's: [connection X1/s =>[signal: a_244_47# w=1]]', 'b: [connection X1/b =>[signal: VPB w=1]]']]
X_Xinput7_1 VPWR Xinput7_a_27_47# Xinput7_a_244_47# VPWR sky130_fd_pr__pfet_01v8_hvt w=820000u l=250000u
** [instance X2 of sky130_fd_pr__pfet_01v8_hvt, params={'w': '1e+06u', 'l': '150000u'} connections=['d: [connection X2/d =>[signal: VPWR w=1]]', 'g: [connection X2/g =>[signal: a_355_47# w=1]]', 's: [connection X2/s =>[signal: X w=1]]', 'b: [connection X2/b =>[signal: VPB w=1]]']]
X_Xinput7_2 VPWR Xinput7_a_355_47# _56_/A1 VPWR sky130_fd_pr__pfet_01v8_hvt w=1e+06u l=150000u
** [instance X3 of sky130_fd_pr__pfet_01v8_hvt, params={'w': '1e+06u', 'l': '150000u'} connections=['d: [connection X3/d =>[signal: a_27_47# w=1]]', 'g: [connection X3/g =>[signal: A w=1]]', 's: [connection X3/s =>[signal: VPWR w=1]]', 'b: [connection X3/b =>[signal: VPB w=1]]']]
X_Xinput7_3 Xinput7_a_27_47# scan_in VPWR VPWR sky130_fd_pr__pfet_01v8_hvt w=1e+06u l=150000u
** [instance X4 of sky130_fd_pr__nfet_01v8, params={'w': '650000u', 'l': '250000u'} connections=['d: [connection X4/d =>[signal: a_355_47# w=1]]', 'g: [connection X4/g =>[signal: a_244_47# w=1]]', 's: [connection X4/s =>[signal: VGND w=1]]', 'b: [connection X4/b =>[signal: VNB w=1]]']]
X_Xinput7_4 Xinput7_a_355_47# Xinput7_a_244_47# VGND VGND sky130_fd_pr__nfet_01v8 w=650000u l=250000u
** [instance X5 of sky130_fd_pr__nfet_01v8, params={'w': '650000u', 'l': '250000u'} connections=['d: [connection X5/d =>[signal: VGND w=1]]', 'g: [connection X5/g =>[signal: a_27_47# w=1]]', 's: [connection X5/s =>[signal: a_244_47# w=1]]', 'b: [connection X5/b =>[signal: VNB w=1]]']]
X_Xinput7_5 VGND Xinput7_a_27_47# Xinput7_a_244_47# VGND sky130_fd_pr__nfet_01v8 w=650000u l=250000u
** [instance X6 of sky130_fd_pr__nfet_01v8, params={'w': '420000u', 'l': '150000u'} connections=['d: [connection X6/d =>[signal: VGND w=1]]', 'g: [connection X6/g =>[signal: a_355_47# w=1]]', 's: [connection X6/s =>[signal: X w=1]]', 'b: [connection X6/b =>[signal: VNB w=1]]']]
X_Xinput7_6 VGND Xinput7_a_355_47# _56_/A1 VGND sky130_fd_pr__nfet_01v8 w=420000u l=150000u
** [instance X7 of sky130_fd_pr__nfet_01v8, params={'w': '420000u', 'l': '150000u'} connections=['d: [connection X7/d =>[signal: a_27_47# w=1]]', 'g: [connection X7/g =>[signal: A w=1]]', 's: [connection X7/s =>[signal: VGND w=1]]', 'b: [connection X7/b =>[signal: VNB w=1]]']]
X_Xinput7_7 Xinput7_a_27_47# scan_in VGND VGND sky130_fd_pr__nfet_01v8 w=420000u l=150000u

** replacing XTAP_TAPCELL_ROW_10_39 with the contents of sky130_fd_sc_hd__tapvpwrvgnd_1

** replacing XFILLER_4_3 with the contents of sky130_fd_sc_hd__fill_2

** replacing X_74_ with the contents of sky130_fd_sc_hd__dfxtp_2
** [instance X0 of sky130_fd_pr__pfet_01v8_hvt, params={'w': '420000u', 'l': '150000u'} connections=['d: [connection X0/d =>[signal: a_891_413# w=1]]', 'g: [connection X0/g =>[signal: a_193_47# w=1]]', 's: [connection X0/s =>[signal: a_975_413# w=1]]', 'b: [connection X0/b =>[signal: VPB w=1]]']]
X_X_74__0 X_74__a_891_413# X_74__a_193_47# X_74__a_975_413# VPWR sky130_fd_pr__pfet_01v8_hvt w=420000u l=150000u
** [instance X1 of sky130_fd_pr__nfet_01v8, params={'w': '650000u', 'l': '150000u'} connections=['d: [connection X1/d =>[signal: a_1059_315# w=1]]', 'g: [connection X1/g =>[signal: a_891_413# w=1]]', 's: [connection X1/s =>[signal: VGND w=1]]', 'b: [connection X1/b =>[signal: VNB w=1]]']]
X_X_74__1 X_74__a_1059_315# X_74__a_891_413# VGND VGND sky130_fd_pr__nfet_01v8 w=650000u l=150000u
** [instance X2 of sky130_fd_pr__pfet_01v8_hvt, params={'w': '420000u', 'l': '150000u'} connections=['d: [connection X2/d =>[signal: a_466_413# w=1]]', 'g: [connection X2/g =>[signal: a_27_47# w=1]]', 's: [connection X2/s =>[signal: a_561_413# w=1]]', 'b: [connection X2/b =>[signal: VPB w=1]]']]
X_X_74__2 X_74__a_466_413# X_74__a_27_47# X_74__a_561_413# VPWR sky130_fd_pr__pfet_01v8_hvt w=420000u l=150000u
** [instance X3 of sky130_fd_pr__pfet_01v8_hvt, params={'w': '420000u', 'l': '150000u'} connections=['d: [connection X3/d =>[signal: a_634_159# w=1]]', 'g: [connection X3/g =>[signal: a_27_47# w=1]]', 's: [connection X3/s =>[signal: a_891_413# w=1]]', 'b: [connection X3/b =>[signal: VPB w=1]]']]
X_X_74__3 X_74__a_634_159# X_74__a_27_47# X_74__a_891_413# VPWR sky130_fd_pr__pfet_01v8_hvt w=420000u l=150000u
** [instance X4 of sky130_fd_pr__pfet_01v8_hvt, params={'w': '420000u', 'l': '150000u'} connections=['d: [connection X4/d =>[signal: a_381_47# w=1]]', 'g: [connection X4/g =>[signal: a_193_47# w=1]]', 's: [connection X4/s =>[signal: a_466_413# w=1]]', 'b: [connection X4/b =>[signal: VPB w=1]]']]
X_X_74__4 X_74__a_381_47# X_74__a_193_47# X_74__a_466_413# VPWR sky130_fd_pr__pfet_01v8_hvt w=420000u l=150000u
** [instance X5 of sky130_fd_pr__pfet_01v8_hvt, params={'w': '420000u', 'l': '150000u'} connections=['d: [connection X5/d =>[signal: VPWR w=1]]', 'g: [connection X5/g =>[signal: D w=1]]', 's: [connection X5/s =>[signal: a_381_47# w=1]]', 'b: [connection X5/b =>[signal: VPB w=1]]']]
X_X_74__5 VPWR _74_/D X_74__a_381_47# VPWR sky130_fd_pr__pfet_01v8_hvt w=420000u l=150000u
** [instance X6 of sky130_fd_pr__pfet_01v8_hvt, params={'w': '750000u', 'l': '150000u'} connections=['d: [connection X6/d =>[signal: VPWR w=1]]', 'g: [connection X6/g =>[signal: a_466_413# w=1]]', 's: [connection X6/s =>[signal: a_634_159# w=1]]', 'b: [connection X6/b =>[signal: VPB w=1]]']]
X_X_74__6 VPWR X_74__a_466_413# X_74__a_634_159# VPWR sky130_fd_pr__pfet_01v8_hvt w=750000u l=150000u
** [instance X7 of sky130_fd_pr__nfet_01v8, params={'w': '640000u', 'l': '150000u'} connections=['d: [connection X7/d =>[signal: VGND w=1]]', 'g: [connection X7/g =>[signal: a_466_413# w=1]]', 's: [connection X7/s =>[signal: a_634_159# w=1]]', 'b: [connection X7/b =>[signal: VNB w=1]]']]
X_X_74__7 VGND X_74__a_466_413# X_74__a_634_159# VGND sky130_fd_pr__nfet_01v8 w=640000u l=150000u
** [instance X8 of sky130_fd_pr__nfet_01v8, params={'w': '420000u', 'l': '150000u'} connections=['d: [connection X8/d =>[signal: a_1017_47# w=1]]', 'g: [connection X8/g =>[signal: a_1059_315# w=1]]', 's: [connection X8/s =>[signal: VGND w=1]]', 'b: [connection X8/b =>[signal: VNB w=1]]']]
X_X_74__8 X_74__a_1017_47# X_74__a_1059_315# VGND VGND sky130_fd_pr__nfet_01v8 w=420000u l=150000u
** [instance X9 of sky130_fd_pr__pfet_01v8_hvt, params={'w': '1e+06u', 'l': '150000u'} connections=['d: [connection X9/d =>[signal: a_1059_315# w=1]]', 'g: [connection X9/g =>[signal: a_891_413# w=1]]', 's: [connection X9/s =>[signal: VPWR w=1]]', 'b: [connection X9/b =>[signal: VPB w=1]]']]
X_X_74__9 X_74__a_1059_315# X_74__a_891_413# VPWR VPWR sky130_fd_pr__pfet_01v8_hvt w=1e+06u l=150000u
** [instance X10 of sky130_fd_pr__pfet_01v8_hvt, params={'w': '1e+06u', 'l': '150000u'} connections=['d: [connection X10/d =>[signal: Q w=1]]', 'g: [connection X10/g =>[signal: a_1059_315# w=1]]', 's: [connection X10/s =>[signal: VPWR w=1]]', 'b: [connection X10/b =>[signal: VPB w=1]]']]
X_X_74__10 _74_/Q X_74__a_1059_315# VPWR VPWR sky130_fd_pr__pfet_01v8_hvt w=1e+06u l=150000u
** [instance X11 of sky130_fd_pr__pfet_01v8_hvt, params={'w': '420000u', 'l': '150000u'} connections=['d: [connection X11/d =>[signal: a_561_413# w=1]]', 'g: [connection X11/g =>[signal: a_634_159# w=1]]', 's: [connection X11/s =>[signal: VPWR w=1]]', 'b: [connection X11/b =>[signal: VPB w=1]]']]
X_X_74__11 X_74__a_561_413# X_74__a_634_159# VPWR VPWR sky130_fd_pr__pfet_01v8_hvt w=420000u l=150000u
** [instance X12 of sky130_fd_pr__pfet_01v8_hvt, params={'w': '1e+06u', 'l': '150000u'} connections=['d: [connection X12/d =>[signal: VPWR w=1]]', 'g: [connection X12/g =>[signal: a_1059_315# w=1]]', 's: [connection X12/s =>[signal: Q w=1]]', 'b: [connection X12/b =>[signal: VPB w=1]]']]
X_X_74__12 VPWR X_74__a_1059_315# _74_/Q VPWR sky130_fd_pr__pfet_01v8_hvt w=1e+06u l=150000u
** [instance X13 of sky130_fd_pr__nfet_01v8, params={'w': '360000u', 'l': '150000u'} connections=['d: [connection X13/d =>[signal: a_891_413# w=1]]', 'g: [connection X13/g =>[signal: a_27_47# w=1]]', 's: [connection X13/s =>[signal: a_1017_47# w=1]]', 'b: [connection X13/b =>[signal: VNB w=1]]']]
X_X_74__13 X_74__a_891_413# X_74__a_27_47# X_74__a_1017_47# VGND sky130_fd_pr__nfet_01v8 w=360000u l=150000u
** [instance X14 of sky130_fd_pr__nfet_01v8, params={'w': '360000u', 'l': '150000u'} connections=['d: [connection X14/d =>[signal: a_634_159# w=1]]', 'g: [connection X14/g =>[signal: a_193_47# w=1]]', 's: [connection X14/s =>[signal: a_891_413# w=1]]', 'b: [connection X14/b =>[signal: VNB w=1]]']]
X_X_74__14 X_74__a_634_159# X_74__a_193_47# X_74__a_891_413# VGND sky130_fd_pr__nfet_01v8 w=360000u l=150000u
** [instance X15 of sky130_fd_pr__nfet_01v8, params={'w': '420000u', 'l': '150000u'} connections=['d: [connection X15/d =>[signal: a_592_47# w=1]]', 'g: [connection X15/g =>[signal: a_634_159# w=1]]', 's: [connection X15/s =>[signal: VGND w=1]]', 'b: [connection X15/b =>[signal: VNB w=1]]']]
X_X_74__15 X_74__a_592_47# X_74__a_634_159# VGND VGND sky130_fd_pr__nfet_01v8 w=420000u l=150000u
** [instance X16 of sky130_fd_pr__nfet_01v8, params={'w': '360000u', 'l': '150000u'} connections=['d: [connection X16/d =>[signal: a_466_413# w=1]]', 'g: [connection X16/g =>[signal: a_193_47# w=1]]', 's: [connection X16/s =>[signal: a_592_47# w=1]]', 'b: [connection X16/b =>[signal: VNB w=1]]']]
X_X_74__16 X_74__a_466_413# X_74__a_193_47# X_74__a_592_47# VGND sky130_fd_pr__nfet_01v8 w=360000u l=150000u
** [instance X17 of sky130_fd_pr__nfet_01v8, params={'w': '420000u', 'l': '150000u'} connections=['d: [connection X17/d =>[signal: VGND w=1]]', 'g: [connection X17/g =>[signal: a_27_47# w=1]]', 's: [connection X17/s =>[signal: a_193_47# w=1]]', 'b: [connection X17/b =>[signal: VNB w=1]]']]
X_X_74__17 VGND X_74__a_27_47# X_74__a_193_47# VGND sky130_fd_pr__nfet_01v8 w=420000u l=150000u
** [instance X18 of sky130_fd_pr__nfet_01v8, params={'w': '360000u', 'l': '150000u'} connections=['d: [connection X18/d =>[signal: a_381_47# w=1]]', 'g: [connection X18/g =>[signal: a_27_47# w=1]]', 's: [connection X18/s =>[signal: a_466_413# w=1]]', 'b: [connection X18/b =>[signal: VNB w=1]]']]
X_X_74__18 X_74__a_381_47# X_74__a_27_47# X_74__a_466_413# VGND sky130_fd_pr__nfet_01v8 w=360000u l=150000u
** [instance X19 of sky130_fd_pr__nfet_01v8, params={'w': '420000u', 'l': '150000u'} connections=['d: [connection X19/d =>[signal: a_27_47# w=1]]', 'g: [connection X19/g =>[signal: CLK w=1]]', 's: [connection X19/s =>[signal: VGND w=1]]', 'b: [connection X19/b =>[signal: VNB w=1]]']]
X_X_74__19 X_74__a_27_47# _76_/CLK VGND VGND sky130_fd_pr__nfet_01v8 w=420000u l=150000u
** [instance X20 of sky130_fd_pr__pfet_01v8_hvt, params={'w': '640000u', 'l': '150000u'} connections=['d: [connection X20/d =>[signal: a_27_47# w=1]]', 'g: [connection X20/g =>[signal: CLK w=1]]', 's: [connection X20/s =>[signal: VPWR w=1]]', 'b: [connection X20/b =>[signal: VPB w=1]]']]
X_X_74__20 X_74__a_27_47# _76_/CLK VPWR VPWR sky130_fd_pr__pfet_01v8_hvt w=640000u l=150000u
** [instance X21 of sky130_fd_pr__nfet_01v8, params={'w': '650000u', 'l': '150000u'} connections=['d: [connection X21/d =>[signal: Q w=1]]', 'g: [connection X21/g =>[signal: a_1059_315# w=1]]', 's: [connection X21/s =>[signal: VGND w=1]]', 'b: [connection X21/b =>[signal: VNB w=1]]']]
X_X_74__21 _74_/Q X_74__a_1059_315# VGND VGND sky130_fd_pr__nfet_01v8 w=650000u l=150000u
** [instance X22 of sky130_fd_pr__pfet_01v8_hvt, params={'w': '640000u', 'l': '150000u'} connections=['d: [connection X22/d =>[signal: VPWR w=1]]', 'g: [connection X22/g =>[signal: a_27_47# w=1]]', 's: [connection X22/s =>[signal: a_193_47# w=1]]', 'b: [connection X22/b =>[signal: VPB w=1]]']]
X_X_74__22 VPWR X_74__a_27_47# X_74__a_193_47# VPWR sky130_fd_pr__pfet_01v8_hvt w=640000u l=150000u
** [instance X23 of sky130_fd_pr__nfet_01v8, params={'w': '420000u', 'l': '150000u'} connections=['d: [connection X23/d =>[signal: VGND w=1]]', 'g: [connection X23/g =>[signal: D w=1]]', 's: [connection X23/s =>[signal: a_381_47# w=1]]', 'b: [connection X23/b =>[signal: VNB w=1]]']]
X_X_74__23 VGND _74_/D X_74__a_381_47# VGND sky130_fd_pr__nfet_01v8 w=420000u l=150000u
** [instance X24 of sky130_fd_pr__pfet_01v8_hvt, params={'w': '420000u', 'l': '150000u'} connections=['d: [connection X24/d =>[signal: a_975_413# w=1]]', 'g: [connection X24/g =>[signal: a_1059_315# w=1]]', 's: [connection X24/s =>[signal: VPWR w=1]]', 'b: [connection X24/b =>[signal: VPB w=1]]']]
X_X_74__24 X_74__a_975_413# X_74__a_1059_315# VPWR VPWR sky130_fd_pr__pfet_01v8_hvt w=420000u l=150000u
** [instance X25 of sky130_fd_pr__nfet_01v8, params={'w': '650000u', 'l': '150000u'} connections=['d: [connection X25/d =>[signal: VGND w=1]]', 'g: [connection X25/g =>[signal: a_1059_315# w=1]]', 's: [connection X25/s =>[signal: Q w=1]]', 'b: [connection X25/b =>[signal: VNB w=1]]']]
X_X_74__25 VGND X_74__a_1059_315# _74_/Q VGND sky130_fd_pr__nfet_01v8 w=650000u l=150000u

** replacing XFILLER_6_6 with the contents of sky130_fd_sc_hd__fill_1

** replacing XFILLER_2_62 with the contents of sky130_fd_sc_hd__fill_1

** replacing X_57_ with the contents of sky130_fd_sc_hd__mux2_1
** [instance X0 of sky130_fd_pr__pfet_01v8_hvt, params={'w': '420000u', 'l': '150000u'} connections=['d: [connection X0/d =>[signal: VPWR w=1]]', 'g: [connection X0/g =>[signal: S w=1]]', 's: [connection X0/s =>[signal: a_218_374# w=1]]', 'b: [connection X0/b =>[signal: VPB w=1]]']]
X_X_57__0 VPWR _58_/S X_57__a_218_374# VPWR sky130_fd_pr__pfet_01v8_hvt w=420000u l=150000u
** [instance X1 of sky130_fd_pr__nfet_01v8, params={'w': '420000u', 'l': '150000u'} connections=['d: [connection X1/d =>[signal: a_76_199# w=1]]', 'g: [connection X1/g =>[signal: A0 w=1]]', 's: [connection X1/s =>[signal: a_439_47# w=1]]', 'b: [connection X1/b =>[signal: VNB w=1]]']]
X_X_57__1 X_57__a_76_199# _57_/A0 X_57__a_439_47# VGND sky130_fd_pr__nfet_01v8 w=420000u l=150000u
** [instance X2 of sky130_fd_pr__pfet_01v8_hvt, params={'w': '420000u', 'l': '150000u'} connections=['d: [connection X2/d =>[signal: a_535_374# w=1]]', 'g: [connection X2/g =>[signal: a_505_21# w=1]]', 's: [connection X2/s =>[signal: VPWR w=1]]', 'b: [connection X2/b =>[signal: VPB w=1]]']]
X_X_57__2 X_57__a_535_374# X_57__a_505_21# VPWR VPWR sky130_fd_pr__pfet_01v8_hvt w=420000u l=150000u
** [instance X3 of sky130_fd_pr__pfet_01v8_hvt, params={'w': '420000u', 'l': '150000u'} connections=['d: [connection X3/d =>[signal: VPWR w=1]]', 'g: [connection X3/g =>[signal: S w=1]]', 's: [connection X3/s =>[signal: a_505_21# w=1]]', 'b: [connection X3/b =>[signal: VPB w=1]]']]
X_X_57__3 VPWR _58_/S X_57__a_505_21# VPWR sky130_fd_pr__pfet_01v8_hvt w=420000u l=150000u
** [instance X4 of sky130_fd_pr__pfet_01v8_hvt, params={'w': '420000u', 'l': '150000u'} connections=['d: [connection X4/d =>[signal: a_76_199# w=1]]', 'g: [connection X4/g =>[signal: A1 w=1]]', 's: [connection X4/s =>[signal: a_535_374# w=1]]', 'b: [connection X4/b =>[signal: VPB w=1]]']]
X_X_57__4 X_57__a_76_199# _74_/Q X_57__a_535_374# VPWR sky130_fd_pr__pfet_01v8_hvt w=420000u l=150000u
** [instance X5 of sky130_fd_pr__nfet_01v8, params={'w': '420000u', 'l': '150000u'} connections=['d: [connection X5/d =>[signal: a_218_47# w=1]]', 'g: [connection X5/g =>[signal: A1 w=1]]', 's: [connection X5/s =>[signal: a_76_199# w=1]]', 'b: [connection X5/b =>[signal: VNB w=1]]']]
X_X_57__5 X_57__a_218_47# _74_/Q X_57__a_76_199# VGND sky130_fd_pr__nfet_01v8 w=420000u l=150000u
** [instance X6 of sky130_fd_pr__pfet_01v8_hvt, params={'w': '420000u', 'l': '150000u'} connections=['d: [connection X6/d =>[signal: a_218_374# w=1]]', 'g: [connection X6/g =>[signal: A0 w=1]]', 's: [connection X6/s =>[signal: a_76_199# w=1]]', 'b: [connection X6/b =>[signal: VPB w=1]]']]
X_X_57__6 X_57__a_218_374# _57_/A0 X_57__a_76_199# VPWR sky130_fd_pr__pfet_01v8_hvt w=420000u l=150000u
** [instance X7 of sky130_fd_pr__nfet_01v8, params={'w': '650000u', 'l': '150000u'} connections=['d: [connection X7/d =>[signal: X w=1]]', 'g: [connection X7/g =>[signal: a_76_199# w=1]]', 's: [connection X7/s =>[signal: VGND w=1]]', 'b: [connection X7/b =>[signal: VNB w=1]]']]
X_X_57__7 _57_/X X_57__a_76_199# VGND VGND sky130_fd_pr__nfet_01v8 w=650000u l=150000u
** [instance X8 of sky130_fd_pr__pfet_01v8_hvt, params={'w': '1e+06u', 'l': '150000u'} connections=['d: [connection X8/d =>[signal: X w=1]]', 'g: [connection X8/g =>[signal: a_76_199# w=1]]', 's: [connection X8/s =>[signal: VPWR w=1]]', 'b: [connection X8/b =>[signal: VPB w=1]]']]
X_X_57__8 _57_/X X_57__a_76_199# VPWR VPWR sky130_fd_pr__pfet_01v8_hvt w=1e+06u l=150000u
** [instance X9 of sky130_fd_pr__nfet_01v8, params={'w': '420000u', 'l': '150000u'} connections=['d: [connection X9/d =>[signal: VGND w=1]]', 'g: [connection X9/g =>[signal: S w=1]]', 's: [connection X9/s =>[signal: a_218_47# w=1]]', 'b: [connection X9/b =>[signal: VNB w=1]]']]
X_X_57__9 VGND _58_/S X_57__a_218_47# VGND sky130_fd_pr__nfet_01v8 w=420000u l=150000u
** [instance X10 of sky130_fd_pr__nfet_01v8, params={'w': '420000u', 'l': '150000u'} connections=['d: [connection X10/d =>[signal: VGND w=1]]', 'g: [connection X10/g =>[signal: S w=1]]', 's: [connection X10/s =>[signal: a_505_21# w=1]]', 'b: [connection X10/b =>[signal: VNB w=1]]']]
X_X_57__10 VGND _58_/S X_57__a_505_21# VGND sky130_fd_pr__nfet_01v8 w=420000u l=150000u
** [instance X11 of sky130_fd_pr__nfet_01v8, params={'w': '420000u', 'l': '150000u'} connections=['d: [connection X11/d =>[signal: a_439_47# w=1]]', 'g: [connection X11/g =>[signal: a_505_21# w=1]]', 's: [connection X11/s =>[signal: VGND w=1]]', 'b: [connection X11/b =>[signal: VNB w=1]]']]
X_X_57__11 X_57__a_439_47# X_57__a_505_21# VGND VGND sky130_fd_pr__nfet_01v8 w=420000u l=150000u

** replacing Xinput8 with the contents of sky130_fd_sc_hd__clkdlybuf4s25_1
** [instance X0 of sky130_fd_pr__pfet_01v8_hvt, params={'w': '820000u', 'l': '250000u'} connections=['d: [connection X0/d =>[signal: a_355_47# w=1]]', 'g: [connection X0/g =>[signal: a_244_47# w=1]]', 's: [connection X0/s =>[signal: VPWR w=1]]', 'b: [connection X0/b =>[signal: VPB w=1]]']]
X_Xinput8_0 Xinput8_a_355_47# Xinput8_a_244_47# VPWR VPWR sky130_fd_pr__pfet_01v8_hvt w=820000u l=250000u
** [instance X1 of sky130_fd_pr__pfet_01v8_hvt, params={'w': '820000u', 'l': '250000u'} connections=['d: [connection X1/d =>[signal: VPWR w=1]]', 'g: [connection X1/g =>[signal: a_27_47# w=1]]', 's: [connection X1/s =>[signal: a_244_47# w=1]]', 'b: [connection X1/b =>[signal: VPB w=1]]']]
X_Xinput8_1 VPWR Xinput8_a_27_47# Xinput8_a_244_47# VPWR sky130_fd_pr__pfet_01v8_hvt w=820000u l=250000u
** [instance X2 of sky130_fd_pr__pfet_01v8_hvt, params={'w': '1e+06u', 'l': '150000u'} connections=['d: [connection X2/d =>[signal: VPWR w=1]]', 'g: [connection X2/g =>[signal: a_355_47# w=1]]', 's: [connection X2/s =>[signal: X w=1]]', 'b: [connection X2/b =>[signal: VPB w=1]]']]
X_Xinput8_2 VPWR Xinput8_a_355_47# _40_/A1 VPWR sky130_fd_pr__pfet_01v8_hvt w=1e+06u l=150000u
** [instance X3 of sky130_fd_pr__pfet_01v8_hvt, params={'w': '1e+06u', 'l': '150000u'} connections=['d: [connection X3/d =>[signal: a_27_47# w=1]]', 'g: [connection X3/g =>[signal: A w=1]]', 's: [connection X3/s =>[signal: VPWR w=1]]', 'b: [connection X3/b =>[signal: VPB w=1]]']]
X_Xinput8_3 Xinput8_a_27_47# x VPWR VPWR sky130_fd_pr__pfet_01v8_hvt w=1e+06u l=150000u
** [instance X4 of sky130_fd_pr__nfet_01v8, params={'w': '650000u', 'l': '250000u'} connections=['d: [connection X4/d =>[signal: a_355_47# w=1]]', 'g: [connection X4/g =>[signal: a_244_47# w=1]]', 's: [connection X4/s =>[signal: VGND w=1]]', 'b: [connection X4/b =>[signal: VNB w=1]]']]
X_Xinput8_4 Xinput8_a_355_47# Xinput8_a_244_47# VGND VGND sky130_fd_pr__nfet_01v8 w=650000u l=250000u
** [instance X5 of sky130_fd_pr__nfet_01v8, params={'w': '650000u', 'l': '250000u'} connections=['d: [connection X5/d =>[signal: VGND w=1]]', 'g: [connection X5/g =>[signal: a_27_47# w=1]]', 's: [connection X5/s =>[signal: a_244_47# w=1]]', 'b: [connection X5/b =>[signal: VNB w=1]]']]
X_Xinput8_5 VGND Xinput8_a_27_47# Xinput8_a_244_47# VGND sky130_fd_pr__nfet_01v8 w=650000u l=250000u
** [instance X6 of sky130_fd_pr__nfet_01v8, params={'w': '420000u', 'l': '150000u'} connections=['d: [connection X6/d =>[signal: VGND w=1]]', 'g: [connection X6/g =>[signal: a_355_47# w=1]]', 's: [connection X6/s =>[signal: X w=1]]', 'b: [connection X6/b =>[signal: VNB w=1]]']]
X_Xinput8_6 VGND Xinput8_a_355_47# _40_/A1 VGND sky130_fd_pr__nfet_01v8 w=420000u l=150000u
** [instance X7 of sky130_fd_pr__nfet_01v8, params={'w': '420000u', 'l': '150000u'} connections=['d: [connection X7/d =>[signal: a_27_47# w=1]]', 'g: [connection X7/g =>[signal: A w=1]]', 's: [connection X7/s =>[signal: VGND w=1]]', 'b: [connection X7/b =>[signal: VNB w=1]]']]
X_Xinput8_7 Xinput8_a_27_47# x VGND VGND sky130_fd_pr__nfet_01v8 w=420000u l=150000u

** replacing XTAP_TAPCELL_ROW_1_30 with the contents of sky130_fd_sc_hd__tapvpwrvgnd_1

** replacing X_73_ with the contents of sky130_fd_sc_hd__dfxtp_2
** [instance X0 of sky130_fd_pr__pfet_01v8_hvt, params={'w': '420000u', 'l': '150000u'} connections=['d: [connection X0/d =>[signal: a_891_413# w=1]]', 'g: [connection X0/g =>[signal: a_193_47# w=1]]', 's: [connection X0/s =>[signal: a_975_413# w=1]]', 'b: [connection X0/b =>[signal: VPB w=1]]']]
X_X_73__0 X_73__a_891_413# X_73__a_193_47# X_73__a_975_413# VPWR sky130_fd_pr__pfet_01v8_hvt w=420000u l=150000u
** [instance X1 of sky130_fd_pr__nfet_01v8, params={'w': '650000u', 'l': '150000u'} connections=['d: [connection X1/d =>[signal: a_1059_315# w=1]]', 'g: [connection X1/g =>[signal: a_891_413# w=1]]', 's: [connection X1/s =>[signal: VGND w=1]]', 'b: [connection X1/b =>[signal: VNB w=1]]']]
X_X_73__1 X_73__a_1059_315# X_73__a_891_413# VGND VGND sky130_fd_pr__nfet_01v8 w=650000u l=150000u
** [instance X2 of sky130_fd_pr__pfet_01v8_hvt, params={'w': '420000u', 'l': '150000u'} connections=['d: [connection X2/d =>[signal: a_466_413# w=1]]', 'g: [connection X2/g =>[signal: a_27_47# w=1]]', 's: [connection X2/s =>[signal: a_561_413# w=1]]', 'b: [connection X2/b =>[signal: VPB w=1]]']]
X_X_73__2 X_73__a_466_413# X_73__a_27_47# X_73__a_561_413# VPWR sky130_fd_pr__pfet_01v8_hvt w=420000u l=150000u
** [instance X3 of sky130_fd_pr__pfet_01v8_hvt, params={'w': '420000u', 'l': '150000u'} connections=['d: [connection X3/d =>[signal: a_634_159# w=1]]', 'g: [connection X3/g =>[signal: a_27_47# w=1]]', 's: [connection X3/s =>[signal: a_891_413# w=1]]', 'b: [connection X3/b =>[signal: VPB w=1]]']]
X_X_73__3 X_73__a_634_159# X_73__a_27_47# X_73__a_891_413# VPWR sky130_fd_pr__pfet_01v8_hvt w=420000u l=150000u
** [instance X4 of sky130_fd_pr__pfet_01v8_hvt, params={'w': '420000u', 'l': '150000u'} connections=['d: [connection X4/d =>[signal: a_381_47# w=1]]', 'g: [connection X4/g =>[signal: a_193_47# w=1]]', 's: [connection X4/s =>[signal: a_466_413# w=1]]', 'b: [connection X4/b =>[signal: VPB w=1]]']]
X_X_73__4 X_73__a_381_47# X_73__a_193_47# X_73__a_466_413# VPWR sky130_fd_pr__pfet_01v8_hvt w=420000u l=150000u
** [instance X5 of sky130_fd_pr__pfet_01v8_hvt, params={'w': '420000u', 'l': '150000u'} connections=['d: [connection X5/d =>[signal: VPWR w=1]]', 'g: [connection X5/g =>[signal: D w=1]]', 's: [connection X5/s =>[signal: a_381_47# w=1]]', 'b: [connection X5/b =>[signal: VPB w=1]]']]
X_X_73__5 VPWR _73_/D X_73__a_381_47# VPWR sky130_fd_pr__pfet_01v8_hvt w=420000u l=150000u
** [instance X6 of sky130_fd_pr__pfet_01v8_hvt, params={'w': '750000u', 'l': '150000u'} connections=['d: [connection X6/d =>[signal: VPWR w=1]]', 'g: [connection X6/g =>[signal: a_466_413# w=1]]', 's: [connection X6/s =>[signal: a_634_159# w=1]]', 'b: [connection X6/b =>[signal: VPB w=1]]']]
X_X_73__6 VPWR X_73__a_466_413# X_73__a_634_159# VPWR sky130_fd_pr__pfet_01v8_hvt w=750000u l=150000u
** [instance X7 of sky130_fd_pr__nfet_01v8, params={'w': '640000u', 'l': '150000u'} connections=['d: [connection X7/d =>[signal: VGND w=1]]', 'g: [connection X7/g =>[signal: a_466_413# w=1]]', 's: [connection X7/s =>[signal: a_634_159# w=1]]', 'b: [connection X7/b =>[signal: VNB w=1]]']]
X_X_73__7 VGND X_73__a_466_413# X_73__a_634_159# VGND sky130_fd_pr__nfet_01v8 w=640000u l=150000u
** [instance X8 of sky130_fd_pr__nfet_01v8, params={'w': '420000u', 'l': '150000u'} connections=['d: [connection X8/d =>[signal: a_1017_47# w=1]]', 'g: [connection X8/g =>[signal: a_1059_315# w=1]]', 's: [connection X8/s =>[signal: VGND w=1]]', 'b: [connection X8/b =>[signal: VNB w=1]]']]
X_X_73__8 X_73__a_1017_47# X_73__a_1059_315# VGND VGND sky130_fd_pr__nfet_01v8 w=420000u l=150000u
** [instance X9 of sky130_fd_pr__pfet_01v8_hvt, params={'w': '1e+06u', 'l': '150000u'} connections=['d: [connection X9/d =>[signal: a_1059_315# w=1]]', 'g: [connection X9/g =>[signal: a_891_413# w=1]]', 's: [connection X9/s =>[signal: VPWR w=1]]', 'b: [connection X9/b =>[signal: VPB w=1]]']]
X_X_73__9 X_73__a_1059_315# X_73__a_891_413# VPWR VPWR sky130_fd_pr__pfet_01v8_hvt w=1e+06u l=150000u
** [instance X10 of sky130_fd_pr__pfet_01v8_hvt, params={'w': '1e+06u', 'l': '150000u'} connections=['d: [connection X10/d =>[signal: Q w=1]]', 'g: [connection X10/g =>[signal: a_1059_315# w=1]]', 's: [connection X10/s =>[signal: VPWR w=1]]', 'b: [connection X10/b =>[signal: VPB w=1]]']]
X_X_73__10 _73_/Q X_73__a_1059_315# VPWR VPWR sky130_fd_pr__pfet_01v8_hvt w=1e+06u l=150000u
** [instance X11 of sky130_fd_pr__pfet_01v8_hvt, params={'w': '420000u', 'l': '150000u'} connections=['d: [connection X11/d =>[signal: a_561_413# w=1]]', 'g: [connection X11/g =>[signal: a_634_159# w=1]]', 's: [connection X11/s =>[signal: VPWR w=1]]', 'b: [connection X11/b =>[signal: VPB w=1]]']]
X_X_73__11 X_73__a_561_413# X_73__a_634_159# VPWR VPWR sky130_fd_pr__pfet_01v8_hvt w=420000u l=150000u
** [instance X12 of sky130_fd_pr__pfet_01v8_hvt, params={'w': '1e+06u', 'l': '150000u'} connections=['d: [connection X12/d =>[signal: VPWR w=1]]', 'g: [connection X12/g =>[signal: a_1059_315# w=1]]', 's: [connection X12/s =>[signal: Q w=1]]', 'b: [connection X12/b =>[signal: VPB w=1]]']]
X_X_73__12 VPWR X_73__a_1059_315# _73_/Q VPWR sky130_fd_pr__pfet_01v8_hvt w=1e+06u l=150000u
** [instance X13 of sky130_fd_pr__nfet_01v8, params={'w': '360000u', 'l': '150000u'} connections=['d: [connection X13/d =>[signal: a_891_413# w=1]]', 'g: [connection X13/g =>[signal: a_27_47# w=1]]', 's: [connection X13/s =>[signal: a_1017_47# w=1]]', 'b: [connection X13/b =>[signal: VNB w=1]]']]
X_X_73__13 X_73__a_891_413# X_73__a_27_47# X_73__a_1017_47# VGND sky130_fd_pr__nfet_01v8 w=360000u l=150000u
** [instance X14 of sky130_fd_pr__nfet_01v8, params={'w': '360000u', 'l': '150000u'} connections=['d: [connection X14/d =>[signal: a_634_159# w=1]]', 'g: [connection X14/g =>[signal: a_193_47# w=1]]', 's: [connection X14/s =>[signal: a_891_413# w=1]]', 'b: [connection X14/b =>[signal: VNB w=1]]']]
X_X_73__14 X_73__a_634_159# X_73__a_193_47# X_73__a_891_413# VGND sky130_fd_pr__nfet_01v8 w=360000u l=150000u
** [instance X15 of sky130_fd_pr__nfet_01v8, params={'w': '420000u', 'l': '150000u'} connections=['d: [connection X15/d =>[signal: a_592_47# w=1]]', 'g: [connection X15/g =>[signal: a_634_159# w=1]]', 's: [connection X15/s =>[signal: VGND w=1]]', 'b: [connection X15/b =>[signal: VNB w=1]]']]
X_X_73__15 X_73__a_592_47# X_73__a_634_159# VGND VGND sky130_fd_pr__nfet_01v8 w=420000u l=150000u
** [instance X16 of sky130_fd_pr__nfet_01v8, params={'w': '360000u', 'l': '150000u'} connections=['d: [connection X16/d =>[signal: a_466_413# w=1]]', 'g: [connection X16/g =>[signal: a_193_47# w=1]]', 's: [connection X16/s =>[signal: a_592_47# w=1]]', 'b: [connection X16/b =>[signal: VNB w=1]]']]
X_X_73__16 X_73__a_466_413# X_73__a_193_47# X_73__a_592_47# VGND sky130_fd_pr__nfet_01v8 w=360000u l=150000u
** [instance X17 of sky130_fd_pr__nfet_01v8, params={'w': '420000u', 'l': '150000u'} connections=['d: [connection X17/d =>[signal: VGND w=1]]', 'g: [connection X17/g =>[signal: a_27_47# w=1]]', 's: [connection X17/s =>[signal: a_193_47# w=1]]', 'b: [connection X17/b =>[signal: VNB w=1]]']]
X_X_73__17 VGND X_73__a_27_47# X_73__a_193_47# VGND sky130_fd_pr__nfet_01v8 w=420000u l=150000u
** [instance X18 of sky130_fd_pr__nfet_01v8, params={'w': '360000u', 'l': '150000u'} connections=['d: [connection X18/d =>[signal: a_381_47# w=1]]', 'g: [connection X18/g =>[signal: a_27_47# w=1]]', 's: [connection X18/s =>[signal: a_466_413# w=1]]', 'b: [connection X18/b =>[signal: VNB w=1]]']]
X_X_73__18 X_73__a_381_47# X_73__a_27_47# X_73__a_466_413# VGND sky130_fd_pr__nfet_01v8 w=360000u l=150000u
** [instance X19 of sky130_fd_pr__nfet_01v8, params={'w': '420000u', 'l': '150000u'} connections=['d: [connection X19/d =>[signal: a_27_47# w=1]]', 'g: [connection X19/g =>[signal: CLK w=1]]', 's: [connection X19/s =>[signal: VGND w=1]]', 'b: [connection X19/b =>[signal: VNB w=1]]']]
X_X_73__19 X_73__a_27_47# _76_/CLK VGND VGND sky130_fd_pr__nfet_01v8 w=420000u l=150000u
** [instance X20 of sky130_fd_pr__pfet_01v8_hvt, params={'w': '640000u', 'l': '150000u'} connections=['d: [connection X20/d =>[signal: a_27_47# w=1]]', 'g: [connection X20/g =>[signal: CLK w=1]]', 's: [connection X20/s =>[signal: VPWR w=1]]', 'b: [connection X20/b =>[signal: VPB w=1]]']]
X_X_73__20 X_73__a_27_47# _76_/CLK VPWR VPWR sky130_fd_pr__pfet_01v8_hvt w=640000u l=150000u
** [instance X21 of sky130_fd_pr__nfet_01v8, params={'w': '650000u', 'l': '150000u'} connections=['d: [connection X21/d =>[signal: Q w=1]]', 'g: [connection X21/g =>[signal: a_1059_315# w=1]]', 's: [connection X21/s =>[signal: VGND w=1]]', 'b: [connection X21/b =>[signal: VNB w=1]]']]
X_X_73__21 _73_/Q X_73__a_1059_315# VGND VGND sky130_fd_pr__nfet_01v8 w=650000u l=150000u
** [instance X22 of sky130_fd_pr__pfet_01v8_hvt, params={'w': '640000u', 'l': '150000u'} connections=['d: [connection X22/d =>[signal: VPWR w=1]]', 'g: [connection X22/g =>[signal: a_27_47# w=1]]', 's: [connection X22/s =>[signal: a_193_47# w=1]]', 'b: [connection X22/b =>[signal: VPB w=1]]']]
X_X_73__22 VPWR X_73__a_27_47# X_73__a_193_47# VPWR sky130_fd_pr__pfet_01v8_hvt w=640000u l=150000u
** [instance X23 of sky130_fd_pr__nfet_01v8, params={'w': '420000u', 'l': '150000u'} connections=['d: [connection X23/d =>[signal: VGND w=1]]', 'g: [connection X23/g =>[signal: D w=1]]', 's: [connection X23/s =>[signal: a_381_47# w=1]]', 'b: [connection X23/b =>[signal: VNB w=1]]']]
X_X_73__23 VGND _73_/D X_73__a_381_47# VGND sky130_fd_pr__nfet_01v8 w=420000u l=150000u
** [instance X24 of sky130_fd_pr__pfet_01v8_hvt, params={'w': '420000u', 'l': '150000u'} connections=['d: [connection X24/d =>[signal: a_975_413# w=1]]', 'g: [connection X24/g =>[signal: a_1059_315# w=1]]', 's: [connection X24/s =>[signal: VPWR w=1]]', 'b: [connection X24/b =>[signal: VPB w=1]]']]
X_X_73__24 X_73__a_975_413# X_73__a_1059_315# VPWR VPWR sky130_fd_pr__pfet_01v8_hvt w=420000u l=150000u
** [instance X25 of sky130_fd_pr__nfet_01v8, params={'w': '650000u', 'l': '150000u'} connections=['d: [connection X25/d =>[signal: VGND w=1]]', 'g: [connection X25/g =>[signal: a_1059_315# w=1]]', 's: [connection X25/s =>[signal: Q w=1]]', 'b: [connection X25/b =>[signal: VNB w=1]]']]
X_X_73__25 VGND X_73__a_1059_315# _73_/Q VGND sky130_fd_pr__nfet_01v8 w=650000u l=150000u

** replacing X_56_ with the contents of sky130_fd_sc_hd__mux2_1
** [instance X0 of sky130_fd_pr__pfet_01v8_hvt, params={'w': '420000u', 'l': '150000u'} connections=['d: [connection X0/d =>[signal: VPWR w=1]]', 'g: [connection X0/g =>[signal: S w=1]]', 's: [connection X0/s =>[signal: a_218_374# w=1]]', 'b: [connection X0/b =>[signal: VPB w=1]]']]
X_X_56__0 VPWR _58_/S X_56__a_218_374# VPWR sky130_fd_pr__pfet_01v8_hvt w=420000u l=150000u
** [instance X1 of sky130_fd_pr__nfet_01v8, params={'w': '420000u', 'l': '150000u'} connections=['d: [connection X1/d =>[signal: a_76_199# w=1]]', 'g: [connection X1/g =>[signal: A0 w=1]]', 's: [connection X1/s =>[signal: a_439_47# w=1]]', 'b: [connection X1/b =>[signal: VNB w=1]]']]
X_X_56__1 X_56__a_76_199# _56_/A0 X_56__a_439_47# VGND sky130_fd_pr__nfet_01v8 w=420000u l=150000u
** [instance X2 of sky130_fd_pr__pfet_01v8_hvt, params={'w': '420000u', 'l': '150000u'} connections=['d: [connection X2/d =>[signal: a_535_374# w=1]]', 'g: [connection X2/g =>[signal: a_505_21# w=1]]', 's: [connection X2/s =>[signal: VPWR w=1]]', 'b: [connection X2/b =>[signal: VPB w=1]]']]
X_X_56__2 X_56__a_535_374# X_56__a_505_21# VPWR VPWR sky130_fd_pr__pfet_01v8_hvt w=420000u l=150000u
** [instance X3 of sky130_fd_pr__pfet_01v8_hvt, params={'w': '420000u', 'l': '150000u'} connections=['d: [connection X3/d =>[signal: VPWR w=1]]', 'g: [connection X3/g =>[signal: S w=1]]', 's: [connection X3/s =>[signal: a_505_21# w=1]]', 'b: [connection X3/b =>[signal: VPB w=1]]']]
X_X_56__3 VPWR _58_/S X_56__a_505_21# VPWR sky130_fd_pr__pfet_01v8_hvt w=420000u l=150000u
** [instance X4 of sky130_fd_pr__pfet_01v8_hvt, params={'w': '420000u', 'l': '150000u'} connections=['d: [connection X4/d =>[signal: a_76_199# w=1]]', 'g: [connection X4/g =>[signal: A1 w=1]]', 's: [connection X4/s =>[signal: a_535_374# w=1]]', 'b: [connection X4/b =>[signal: VPB w=1]]']]
X_X_56__4 X_56__a_76_199# _56_/A1 X_56__a_535_374# VPWR sky130_fd_pr__pfet_01v8_hvt w=420000u l=150000u
** [instance X5 of sky130_fd_pr__nfet_01v8, params={'w': '420000u', 'l': '150000u'} connections=['d: [connection X5/d =>[signal: a_218_47# w=1]]', 'g: [connection X5/g =>[signal: A1 w=1]]', 's: [connection X5/s =>[signal: a_76_199# w=1]]', 'b: [connection X5/b =>[signal: VNB w=1]]']]
X_X_56__5 X_56__a_218_47# _56_/A1 X_56__a_76_199# VGND sky130_fd_pr__nfet_01v8 w=420000u l=150000u
** [instance X6 of sky130_fd_pr__pfet_01v8_hvt, params={'w': '420000u', 'l': '150000u'} connections=['d: [connection X6/d =>[signal: a_218_374# w=1]]', 'g: [connection X6/g =>[signal: A0 w=1]]', 's: [connection X6/s =>[signal: a_76_199# w=1]]', 'b: [connection X6/b =>[signal: VPB w=1]]']]
X_X_56__6 X_56__a_218_374# _56_/A0 X_56__a_76_199# VPWR sky130_fd_pr__pfet_01v8_hvt w=420000u l=150000u
** [instance X7 of sky130_fd_pr__nfet_01v8, params={'w': '650000u', 'l': '150000u'} connections=['d: [connection X7/d =>[signal: X w=1]]', 'g: [connection X7/g =>[signal: a_76_199# w=1]]', 's: [connection X7/s =>[signal: VGND w=1]]', 'b: [connection X7/b =>[signal: VNB w=1]]']]
X_X_56__7 _74_/D X_56__a_76_199# VGND VGND sky130_fd_pr__nfet_01v8 w=650000u l=150000u
** [instance X8 of sky130_fd_pr__pfet_01v8_hvt, params={'w': '1e+06u', 'l': '150000u'} connections=['d: [connection X8/d =>[signal: X w=1]]', 'g: [connection X8/g =>[signal: a_76_199# w=1]]', 's: [connection X8/s =>[signal: VPWR w=1]]', 'b: [connection X8/b =>[signal: VPB w=1]]']]
X_X_56__8 _74_/D X_56__a_76_199# VPWR VPWR sky130_fd_pr__pfet_01v8_hvt w=1e+06u l=150000u
** [instance X9 of sky130_fd_pr__nfet_01v8, params={'w': '420000u', 'l': '150000u'} connections=['d: [connection X9/d =>[signal: VGND w=1]]', 'g: [connection X9/g =>[signal: S w=1]]', 's: [connection X9/s =>[signal: a_218_47# w=1]]', 'b: [connection X9/b =>[signal: VNB w=1]]']]
X_X_56__9 VGND _58_/S X_56__a_218_47# VGND sky130_fd_pr__nfet_01v8 w=420000u l=150000u
** [instance X10 of sky130_fd_pr__nfet_01v8, params={'w': '420000u', 'l': '150000u'} connections=['d: [connection X10/d =>[signal: VGND w=1]]', 'g: [connection X10/g =>[signal: S w=1]]', 's: [connection X10/s =>[signal: a_505_21# w=1]]', 'b: [connection X10/b =>[signal: VNB w=1]]']]
X_X_56__10 VGND _58_/S X_56__a_505_21# VGND sky130_fd_pr__nfet_01v8 w=420000u l=150000u
** [instance X11 of sky130_fd_pr__nfet_01v8, params={'w': '420000u', 'l': '150000u'} connections=['d: [connection X11/d =>[signal: a_439_47# w=1]]', 'g: [connection X11/g =>[signal: a_505_21# w=1]]', 's: [connection X11/s =>[signal: VGND w=1]]', 'b: [connection X11/b =>[signal: VNB w=1]]']]
X_X_56__11 X_56__a_439_47# X_56__a_505_21# VGND VGND sky130_fd_pr__nfet_01v8 w=420000u l=150000u

** replacing X_39_ with the contents of sky130_fd_sc_hd__mux2_1
** [instance X0 of sky130_fd_pr__pfet_01v8_hvt, params={'w': '420000u', 'l': '150000u'} connections=['d: [connection X0/d =>[signal: VPWR w=1]]', 'g: [connection X0/g =>[signal: S w=1]]', 's: [connection X0/s =>[signal: a_218_374# w=1]]', 'b: [connection X0/b =>[signal: VPB w=1]]']]
X_X_39__0 VPWR _74_/Q X_39__a_218_374# VPWR sky130_fd_pr__pfet_01v8_hvt w=420000u l=150000u
** [instance X1 of sky130_fd_pr__nfet_01v8, params={'w': '420000u', 'l': '150000u'} connections=['d: [connection X1/d =>[signal: a_76_199# w=1]]', 'g: [connection X1/g =>[signal: A0 w=1]]', 's: [connection X1/s =>[signal: a_439_47# w=1]]', 'b: [connection X1/b =>[signal: VNB w=1]]']]
X_X_39__1 X_39__a_76_199# _38_/X X_39__a_439_47# VGND sky130_fd_pr__nfet_01v8 w=420000u l=150000u
** [instance X2 of sky130_fd_pr__pfet_01v8_hvt, params={'w': '420000u', 'l': '150000u'} connections=['d: [connection X2/d =>[signal: a_535_374# w=1]]', 'g: [connection X2/g =>[signal: a_505_21# w=1]]', 's: [connection X2/s =>[signal: VPWR w=1]]', 'b: [connection X2/b =>[signal: VPB w=1]]']]
X_X_39__2 X_39__a_535_374# X_39__a_505_21# VPWR VPWR sky130_fd_pr__pfet_01v8_hvt w=420000u l=150000u
** [instance X3 of sky130_fd_pr__pfet_01v8_hvt, params={'w': '420000u', 'l': '150000u'} connections=['d: [connection X3/d =>[signal: VPWR w=1]]', 'g: [connection X3/g =>[signal: S w=1]]', 's: [connection X3/s =>[signal: a_505_21# w=1]]', 'b: [connection X3/b =>[signal: VPB w=1]]']]
X_X_39__3 VPWR _74_/Q X_39__a_505_21# VPWR sky130_fd_pr__pfet_01v8_hvt w=420000u l=150000u
** [instance X4 of sky130_fd_pr__pfet_01v8_hvt, params={'w': '420000u', 'l': '150000u'} connections=['d: [connection X4/d =>[signal: a_76_199# w=1]]', 'g: [connection X4/g =>[signal: A1 w=1]]', 's: [connection X4/s =>[signal: a_535_374# w=1]]', 'b: [connection X4/b =>[signal: VPB w=1]]']]
X_X_39__4 X_39__a_76_199# _40_/A1 X_39__a_535_374# VPWR sky130_fd_pr__pfet_01v8_hvt w=420000u l=150000u
** [instance X5 of sky130_fd_pr__nfet_01v8, params={'w': '420000u', 'l': '150000u'} connections=['d: [connection X5/d =>[signal: a_218_47# w=1]]', 'g: [connection X5/g =>[signal: A1 w=1]]', 's: [connection X5/s =>[signal: a_76_199# w=1]]', 'b: [connection X5/b =>[signal: VNB w=1]]']]
X_X_39__5 X_39__a_218_47# _40_/A1 X_39__a_76_199# VGND sky130_fd_pr__nfet_01v8 w=420000u l=150000u
** [instance X6 of sky130_fd_pr__pfet_01v8_hvt, params={'w': '420000u', 'l': '150000u'} connections=['d: [connection X6/d =>[signal: a_218_374# w=1]]', 'g: [connection X6/g =>[signal: A0 w=1]]', 's: [connection X6/s =>[signal: a_76_199# w=1]]', 'b: [connection X6/b =>[signal: VPB w=1]]']]
X_X_39__6 X_39__a_218_374# _38_/X X_39__a_76_199# VPWR sky130_fd_pr__pfet_01v8_hvt w=420000u l=150000u
** [instance X7 of sky130_fd_pr__nfet_01v8, params={'w': '650000u', 'l': '150000u'} connections=['d: [connection X7/d =>[signal: X w=1]]', 'g: [connection X7/g =>[signal: a_76_199# w=1]]', 's: [connection X7/s =>[signal: VGND w=1]]', 'b: [connection X7/b =>[signal: VNB w=1]]']]
X_X_39__7 _77_/D X_39__a_76_199# VGND VGND sky130_fd_pr__nfet_01v8 w=650000u l=150000u
** [instance X8 of sky130_fd_pr__pfet_01v8_hvt, params={'w': '1e+06u', 'l': '150000u'} connections=['d: [connection X8/d =>[signal: X w=1]]', 'g: [connection X8/g =>[signal: a_76_199# w=1]]', 's: [connection X8/s =>[signal: VPWR w=1]]', 'b: [connection X8/b =>[signal: VPB w=1]]']]
X_X_39__8 _77_/D X_39__a_76_199# VPWR VPWR sky130_fd_pr__pfet_01v8_hvt w=1e+06u l=150000u
** [instance X9 of sky130_fd_pr__nfet_01v8, params={'w': '420000u', 'l': '150000u'} connections=['d: [connection X9/d =>[signal: VGND w=1]]', 'g: [connection X9/g =>[signal: S w=1]]', 's: [connection X9/s =>[signal: a_218_47# w=1]]', 'b: [connection X9/b =>[signal: VNB w=1]]']]
X_X_39__9 VGND _74_/Q X_39__a_218_47# VGND sky130_fd_pr__nfet_01v8 w=420000u l=150000u
** [instance X10 of sky130_fd_pr__nfet_01v8, params={'w': '420000u', 'l': '150000u'} connections=['d: [connection X10/d =>[signal: VGND w=1]]', 'g: [connection X10/g =>[signal: S w=1]]', 's: [connection X10/s =>[signal: a_505_21# w=1]]', 'b: [connection X10/b =>[signal: VNB w=1]]']]
X_X_39__10 VGND _74_/Q X_39__a_505_21# VGND sky130_fd_pr__nfet_01v8 w=420000u l=150000u
** [instance X11 of sky130_fd_pr__nfet_01v8, params={'w': '420000u', 'l': '150000u'} connections=['d: [connection X11/d =>[signal: a_439_47# w=1]]', 'g: [connection X11/g =>[signal: a_505_21# w=1]]', 's: [connection X11/s =>[signal: VGND w=1]]', 'b: [connection X11/b =>[signal: VNB w=1]]']]
X_X_39__11 X_39__a_439_47# X_39__a_505_21# VGND VGND sky130_fd_pr__nfet_01v8 w=420000u l=150000u

** replacing XFILLER_12_3 with the contents of sky130_fd_sc_hd__decap_3
** [instance X0 of sky130_fd_pr__pfet_01v8_hvt, params={'w': '870000u', 'l': '590000u'} connections=['d: [connection X0/d =>[signal: VPWR w=1]]', 'g: [connection X0/g =>[signal: VGND w=1]]', 's: [connection X0/s =>[signal: VPWR w=1]]', 'b: [connection X0/b =>[signal: VPB w=1]]']]
X_XFILLER_12_3_0 VPWR VGND VPWR VPWR sky130_fd_pr__pfet_01v8_hvt w=870000u l=590000u
** [instance X1 of sky130_fd_pr__nfet_01v8, params={'w': '550000u', 'l': '590000u'} connections=['d: [connection X1/d =>[signal: VGND w=1]]', 'g: [connection X1/g =>[signal: VPWR w=1]]', 's: [connection X1/s =>[signal: VGND w=1]]', 'b: [connection X1/b =>[signal: VNB w=1]]']]
X_XFILLER_12_3_1 VGND VPWR VGND VGND sky130_fd_pr__nfet_01v8 w=550000u l=590000u

** replacing X_72_ with the contents of sky130_fd_sc_hd__dfxtp_2
** [instance X0 of sky130_fd_pr__pfet_01v8_hvt, params={'w': '420000u', 'l': '150000u'} connections=['d: [connection X0/d =>[signal: a_891_413# w=1]]', 'g: [connection X0/g =>[signal: a_193_47# w=1]]', 's: [connection X0/s =>[signal: a_975_413# w=1]]', 'b: [connection X0/b =>[signal: VPB w=1]]']]
X_X_72__0 X_72__a_891_413# X_72__a_193_47# X_72__a_975_413# VPWR sky130_fd_pr__pfet_01v8_hvt w=420000u l=150000u
** [instance X1 of sky130_fd_pr__nfet_01v8, params={'w': '650000u', 'l': '150000u'} connections=['d: [connection X1/d =>[signal: a_1059_315# w=1]]', 'g: [connection X1/g =>[signal: a_891_413# w=1]]', 's: [connection X1/s =>[signal: VGND w=1]]', 'b: [connection X1/b =>[signal: VNB w=1]]']]
X_X_72__1 X_72__a_1059_315# X_72__a_891_413# VGND VGND sky130_fd_pr__nfet_01v8 w=650000u l=150000u
** [instance X2 of sky130_fd_pr__pfet_01v8_hvt, params={'w': '420000u', 'l': '150000u'} connections=['d: [connection X2/d =>[signal: a_466_413# w=1]]', 'g: [connection X2/g =>[signal: a_27_47# w=1]]', 's: [connection X2/s =>[signal: a_561_413# w=1]]', 'b: [connection X2/b =>[signal: VPB w=1]]']]
X_X_72__2 X_72__a_466_413# X_72__a_27_47# X_72__a_561_413# VPWR sky130_fd_pr__pfet_01v8_hvt w=420000u l=150000u
** [instance X3 of sky130_fd_pr__pfet_01v8_hvt, params={'w': '420000u', 'l': '150000u'} connections=['d: [connection X3/d =>[signal: a_634_159# w=1]]', 'g: [connection X3/g =>[signal: a_27_47# w=1]]', 's: [connection X3/s =>[signal: a_891_413# w=1]]', 'b: [connection X3/b =>[signal: VPB w=1]]']]
X_X_72__3 X_72__a_634_159# X_72__a_27_47# X_72__a_891_413# VPWR sky130_fd_pr__pfet_01v8_hvt w=420000u l=150000u
** [instance X4 of sky130_fd_pr__pfet_01v8_hvt, params={'w': '420000u', 'l': '150000u'} connections=['d: [connection X4/d =>[signal: a_381_47# w=1]]', 'g: [connection X4/g =>[signal: a_193_47# w=1]]', 's: [connection X4/s =>[signal: a_466_413# w=1]]', 'b: [connection X4/b =>[signal: VPB w=1]]']]
X_X_72__4 X_72__a_381_47# X_72__a_193_47# X_72__a_466_413# VPWR sky130_fd_pr__pfet_01v8_hvt w=420000u l=150000u
** [instance X5 of sky130_fd_pr__pfet_01v8_hvt, params={'w': '420000u', 'l': '150000u'} connections=['d: [connection X5/d =>[signal: VPWR w=1]]', 'g: [connection X5/g =>[signal: D w=1]]', 's: [connection X5/s =>[signal: a_381_47# w=1]]', 'b: [connection X5/b =>[signal: VPB w=1]]']]
X_X_72__5 VPWR _72_/D X_72__a_381_47# VPWR sky130_fd_pr__pfet_01v8_hvt w=420000u l=150000u
** [instance X6 of sky130_fd_pr__pfet_01v8_hvt, params={'w': '750000u', 'l': '150000u'} connections=['d: [connection X6/d =>[signal: VPWR w=1]]', 'g: [connection X6/g =>[signal: a_466_413# w=1]]', 's: [connection X6/s =>[signal: a_634_159# w=1]]', 'b: [connection X6/b =>[signal: VPB w=1]]']]
X_X_72__6 VPWR X_72__a_466_413# X_72__a_634_159# VPWR sky130_fd_pr__pfet_01v8_hvt w=750000u l=150000u
** [instance X7 of sky130_fd_pr__nfet_01v8, params={'w': '640000u', 'l': '150000u'} connections=['d: [connection X7/d =>[signal: VGND w=1]]', 'g: [connection X7/g =>[signal: a_466_413# w=1]]', 's: [connection X7/s =>[signal: a_634_159# w=1]]', 'b: [connection X7/b =>[signal: VNB w=1]]']]
X_X_72__7 VGND X_72__a_466_413# X_72__a_634_159# VGND sky130_fd_pr__nfet_01v8 w=640000u l=150000u
** [instance X8 of sky130_fd_pr__nfet_01v8, params={'w': '420000u', 'l': '150000u'} connections=['d: [connection X8/d =>[signal: a_1017_47# w=1]]', 'g: [connection X8/g =>[signal: a_1059_315# w=1]]', 's: [connection X8/s =>[signal: VGND w=1]]', 'b: [connection X8/b =>[signal: VNB w=1]]']]
X_X_72__8 X_72__a_1017_47# X_72__a_1059_315# VGND VGND sky130_fd_pr__nfet_01v8 w=420000u l=150000u
** [instance X9 of sky130_fd_pr__pfet_01v8_hvt, params={'w': '1e+06u', 'l': '150000u'} connections=['d: [connection X9/d =>[signal: a_1059_315# w=1]]', 'g: [connection X9/g =>[signal: a_891_413# w=1]]', 's: [connection X9/s =>[signal: VPWR w=1]]', 'b: [connection X9/b =>[signal: VPB w=1]]']]
X_X_72__9 X_72__a_1059_315# X_72__a_891_413# VPWR VPWR sky130_fd_pr__pfet_01v8_hvt w=1e+06u l=150000u
** [instance X10 of sky130_fd_pr__pfet_01v8_hvt, params={'w': '1e+06u', 'l': '150000u'} connections=['d: [connection X10/d =>[signal: Q w=1]]', 'g: [connection X10/g =>[signal: a_1059_315# w=1]]', 's: [connection X10/s =>[signal: VPWR w=1]]', 'b: [connection X10/b =>[signal: VPB w=1]]']]
X_X_72__10 _72_/Q X_72__a_1059_315# VPWR VPWR sky130_fd_pr__pfet_01v8_hvt w=1e+06u l=150000u
** [instance X11 of sky130_fd_pr__pfet_01v8_hvt, params={'w': '420000u', 'l': '150000u'} connections=['d: [connection X11/d =>[signal: a_561_413# w=1]]', 'g: [connection X11/g =>[signal: a_634_159# w=1]]', 's: [connection X11/s =>[signal: VPWR w=1]]', 'b: [connection X11/b =>[signal: VPB w=1]]']]
X_X_72__11 X_72__a_561_413# X_72__a_634_159# VPWR VPWR sky130_fd_pr__pfet_01v8_hvt w=420000u l=150000u
** [instance X12 of sky130_fd_pr__pfet_01v8_hvt, params={'w': '1e+06u', 'l': '150000u'} connections=['d: [connection X12/d =>[signal: VPWR w=1]]', 'g: [connection X12/g =>[signal: a_1059_315# w=1]]', 's: [connection X12/s =>[signal: Q w=1]]', 'b: [connection X12/b =>[signal: VPB w=1]]']]
X_X_72__12 VPWR X_72__a_1059_315# _72_/Q VPWR sky130_fd_pr__pfet_01v8_hvt w=1e+06u l=150000u
** [instance X13 of sky130_fd_pr__nfet_01v8, params={'w': '360000u', 'l': '150000u'} connections=['d: [connection X13/d =>[signal: a_891_413# w=1]]', 'g: [connection X13/g =>[signal: a_27_47# w=1]]', 's: [connection X13/s =>[signal: a_1017_47# w=1]]', 'b: [connection X13/b =>[signal: VNB w=1]]']]
X_X_72__13 X_72__a_891_413# X_72__a_27_47# X_72__a_1017_47# VGND sky130_fd_pr__nfet_01v8 w=360000u l=150000u
** [instance X14 of sky130_fd_pr__nfet_01v8, params={'w': '360000u', 'l': '150000u'} connections=['d: [connection X14/d =>[signal: a_634_159# w=1]]', 'g: [connection X14/g =>[signal: a_193_47# w=1]]', 's: [connection X14/s =>[signal: a_891_413# w=1]]', 'b: [connection X14/b =>[signal: VNB w=1]]']]
X_X_72__14 X_72__a_634_159# X_72__a_193_47# X_72__a_891_413# VGND sky130_fd_pr__nfet_01v8 w=360000u l=150000u
** [instance X15 of sky130_fd_pr__nfet_01v8, params={'w': '420000u', 'l': '150000u'} connections=['d: [connection X15/d =>[signal: a_592_47# w=1]]', 'g: [connection X15/g =>[signal: a_634_159# w=1]]', 's: [connection X15/s =>[signal: VGND w=1]]', 'b: [connection X15/b =>[signal: VNB w=1]]']]
X_X_72__15 X_72__a_592_47# X_72__a_634_159# VGND VGND sky130_fd_pr__nfet_01v8 w=420000u l=150000u
** [instance X16 of sky130_fd_pr__nfet_01v8, params={'w': '360000u', 'l': '150000u'} connections=['d: [connection X16/d =>[signal: a_466_413# w=1]]', 'g: [connection X16/g =>[signal: a_193_47# w=1]]', 's: [connection X16/s =>[signal: a_592_47# w=1]]', 'b: [connection X16/b =>[signal: VNB w=1]]']]
X_X_72__16 X_72__a_466_413# X_72__a_193_47# X_72__a_592_47# VGND sky130_fd_pr__nfet_01v8 w=360000u l=150000u
** [instance X17 of sky130_fd_pr__nfet_01v8, params={'w': '420000u', 'l': '150000u'} connections=['d: [connection X17/d =>[signal: VGND w=1]]', 'g: [connection X17/g =>[signal: a_27_47# w=1]]', 's: [connection X17/s =>[signal: a_193_47# w=1]]', 'b: [connection X17/b =>[signal: VNB w=1]]']]
X_X_72__17 VGND X_72__a_27_47# X_72__a_193_47# VGND sky130_fd_pr__nfet_01v8 w=420000u l=150000u
** [instance X18 of sky130_fd_pr__nfet_01v8, params={'w': '360000u', 'l': '150000u'} connections=['d: [connection X18/d =>[signal: a_381_47# w=1]]', 'g: [connection X18/g =>[signal: a_27_47# w=1]]', 's: [connection X18/s =>[signal: a_466_413# w=1]]', 'b: [connection X18/b =>[signal: VNB w=1]]']]
X_X_72__18 X_72__a_381_47# X_72__a_27_47# X_72__a_466_413# VGND sky130_fd_pr__nfet_01v8 w=360000u l=150000u
** [instance X19 of sky130_fd_pr__nfet_01v8, params={'w': '420000u', 'l': '150000u'} connections=['d: [connection X19/d =>[signal: a_27_47# w=1]]', 'g: [connection X19/g =>[signal: CLK w=1]]', 's: [connection X19/s =>[signal: VGND w=1]]', 'b: [connection X19/b =>[signal: VNB w=1]]']]
X_X_72__19 X_72__a_27_47# _76_/CLK VGND VGND sky130_fd_pr__nfet_01v8 w=420000u l=150000u
** [instance X20 of sky130_fd_pr__pfet_01v8_hvt, params={'w': '640000u', 'l': '150000u'} connections=['d: [connection X20/d =>[signal: a_27_47# w=1]]', 'g: [connection X20/g =>[signal: CLK w=1]]', 's: [connection X20/s =>[signal: VPWR w=1]]', 'b: [connection X20/b =>[signal: VPB w=1]]']]
X_X_72__20 X_72__a_27_47# _76_/CLK VPWR VPWR sky130_fd_pr__pfet_01v8_hvt w=640000u l=150000u
** [instance X21 of sky130_fd_pr__nfet_01v8, params={'w': '650000u', 'l': '150000u'} connections=['d: [connection X21/d =>[signal: Q w=1]]', 'g: [connection X21/g =>[signal: a_1059_315# w=1]]', 's: [connection X21/s =>[signal: VGND w=1]]', 'b: [connection X21/b =>[signal: VNB w=1]]']]
X_X_72__21 _72_/Q X_72__a_1059_315# VGND VGND sky130_fd_pr__nfet_01v8 w=650000u l=150000u
** [instance X22 of sky130_fd_pr__pfet_01v8_hvt, params={'w': '640000u', 'l': '150000u'} connections=['d: [connection X22/d =>[signal: VPWR w=1]]', 'g: [connection X22/g =>[signal: a_27_47# w=1]]', 's: [connection X22/s =>[signal: a_193_47# w=1]]', 'b: [connection X22/b =>[signal: VPB w=1]]']]
X_X_72__22 VPWR X_72__a_27_47# X_72__a_193_47# VPWR sky130_fd_pr__pfet_01v8_hvt w=640000u l=150000u
** [instance X23 of sky130_fd_pr__nfet_01v8, params={'w': '420000u', 'l': '150000u'} connections=['d: [connection X23/d =>[signal: VGND w=1]]', 'g: [connection X23/g =>[signal: D w=1]]', 's: [connection X23/s =>[signal: a_381_47# w=1]]', 'b: [connection X23/b =>[signal: VNB w=1]]']]
X_X_72__23 VGND _72_/D X_72__a_381_47# VGND sky130_fd_pr__nfet_01v8 w=420000u l=150000u
** [instance X24 of sky130_fd_pr__pfet_01v8_hvt, params={'w': '420000u', 'l': '150000u'} connections=['d: [connection X24/d =>[signal: a_975_413# w=1]]', 'g: [connection X24/g =>[signal: a_1059_315# w=1]]', 's: [connection X24/s =>[signal: VPWR w=1]]', 'b: [connection X24/b =>[signal: VPB w=1]]']]
X_X_72__24 X_72__a_975_413# X_72__a_1059_315# VPWR VPWR sky130_fd_pr__pfet_01v8_hvt w=420000u l=150000u
** [instance X25 of sky130_fd_pr__nfet_01v8, params={'w': '650000u', 'l': '150000u'} connections=['d: [connection X25/d =>[signal: VGND w=1]]', 'g: [connection X25/g =>[signal: a_1059_315# w=1]]', 's: [connection X25/s =>[signal: Q w=1]]', 'b: [connection X25/b =>[signal: VNB w=1]]']]
X_X_72__25 VGND X_72__a_1059_315# _72_/Q VGND sky130_fd_pr__nfet_01v8 w=650000u l=150000u

** replacing XTAP_TAPCELL_ROW_11_40 with the contents of sky130_fd_sc_hd__tapvpwrvgnd_1

** replacing XPHY_EDGE_ROW_10_Right_10 with the contents of sky130_fd_sc_hd__decap_3
** [instance X0 of sky130_fd_pr__pfet_01v8_hvt, params={'w': '870000u', 'l': '590000u'} connections=['d: [connection X0/d =>[signal: VPWR w=1]]', 'g: [connection X0/g =>[signal: VGND w=1]]', 's: [connection X0/s =>[signal: VPWR w=1]]', 'b: [connection X0/b =>[signal: VPB w=1]]']]
X_XPHY_EDGE_ROW_10_Right_10_0 VPWR VGND VPWR VPWR sky130_fd_pr__pfet_01v8_hvt w=870000u l=590000u
** [instance X1 of sky130_fd_pr__nfet_01v8, params={'w': '550000u', 'l': '590000u'} connections=['d: [connection X1/d =>[signal: VGND w=1]]', 'g: [connection X1/g =>[signal: VPWR w=1]]', 's: [connection X1/s =>[signal: VGND w=1]]', 'b: [connection X1/b =>[signal: VNB w=1]]']]
X_XPHY_EDGE_ROW_10_Right_10_1 VGND VPWR VGND VGND sky130_fd_pr__nfet_01v8 w=550000u l=590000u

** replacing X_55_ with the contents of sky130_fd_sc_hd__mux2_1
** [instance X0 of sky130_fd_pr__pfet_01v8_hvt, params={'w': '420000u', 'l': '150000u'} connections=['d: [connection X0/d =>[signal: VPWR w=1]]', 'g: [connection X0/g =>[signal: S w=1]]', 's: [connection X0/s =>[signal: a_218_374# w=1]]', 'b: [connection X0/b =>[signal: VPB w=1]]']]
X_X_55__0 VPWR _58_/S X_55__a_218_374# VPWR sky130_fd_pr__pfet_01v8_hvt w=420000u l=150000u
** [instance X1 of sky130_fd_pr__nfet_01v8, params={'w': '420000u', 'l': '150000u'} connections=['d: [connection X1/d =>[signal: a_76_199# w=1]]', 'g: [connection X1/g =>[signal: A0 w=1]]', 's: [connection X1/s =>[signal: a_439_47# w=1]]', 'b: [connection X1/b =>[signal: VNB w=1]]']]
X_X_55__1 X_55__a_76_199# _55_/A0 X_55__a_439_47# VGND sky130_fd_pr__nfet_01v8 w=420000u l=150000u
** [instance X2 of sky130_fd_pr__pfet_01v8_hvt, params={'w': '420000u', 'l': '150000u'} connections=['d: [connection X2/d =>[signal: a_535_374# w=1]]', 'g: [connection X2/g =>[signal: a_505_21# w=1]]', 's: [connection X2/s =>[signal: VPWR w=1]]', 'b: [connection X2/b =>[signal: VPB w=1]]']]
X_X_55__2 X_55__a_535_374# X_55__a_505_21# VPWR VPWR sky130_fd_pr__pfet_01v8_hvt w=420000u l=150000u
** [instance X3 of sky130_fd_pr__pfet_01v8_hvt, params={'w': '420000u', 'l': '150000u'} connections=['d: [connection X3/d =>[signal: VPWR w=1]]', 'g: [connection X3/g =>[signal: S w=1]]', 's: [connection X3/s =>[signal: a_505_21# w=1]]', 'b: [connection X3/b =>[signal: VPB w=1]]']]
X_X_55__3 VPWR _58_/S X_55__a_505_21# VPWR sky130_fd_pr__pfet_01v8_hvt w=420000u l=150000u
** [instance X4 of sky130_fd_pr__pfet_01v8_hvt, params={'w': '420000u', 'l': '150000u'} connections=['d: [connection X4/d =>[signal: a_76_199# w=1]]', 'g: [connection X4/g =>[signal: A1 w=1]]', 's: [connection X4/s =>[signal: a_535_374# w=1]]', 'b: [connection X4/b =>[signal: VPB w=1]]']]
X_X_55__4 X_55__a_76_199# _57_/A0 X_55__a_535_374# VPWR sky130_fd_pr__pfet_01v8_hvt w=420000u l=150000u
** [instance X5 of sky130_fd_pr__nfet_01v8, params={'w': '420000u', 'l': '150000u'} connections=['d: [connection X5/d =>[signal: a_218_47# w=1]]', 'g: [connection X5/g =>[signal: A1 w=1]]', 's: [connection X5/s =>[signal: a_76_199# w=1]]', 'b: [connection X5/b =>[signal: VNB w=1]]']]
X_X_55__5 X_55__a_218_47# _57_/A0 X_55__a_76_199# VGND sky130_fd_pr__nfet_01v8 w=420000u l=150000u
** [instance X6 of sky130_fd_pr__pfet_01v8_hvt, params={'w': '420000u', 'l': '150000u'} connections=['d: [connection X6/d =>[signal: a_218_374# w=1]]', 'g: [connection X6/g =>[signal: A0 w=1]]', 's: [connection X6/s =>[signal: a_76_199# w=1]]', 'b: [connection X6/b =>[signal: VPB w=1]]']]
X_X_55__6 X_55__a_218_374# _55_/A0 X_55__a_76_199# VPWR sky130_fd_pr__pfet_01v8_hvt w=420000u l=150000u
** [instance X7 of sky130_fd_pr__nfet_01v8, params={'w': '650000u', 'l': '150000u'} connections=['d: [connection X7/d =>[signal: X w=1]]', 'g: [connection X7/g =>[signal: a_76_199# w=1]]', 's: [connection X7/s =>[signal: VGND w=1]]', 'b: [connection X7/b =>[signal: VNB w=1]]']]
X_X_55__7 _73_/D X_55__a_76_199# VGND VGND sky130_fd_pr__nfet_01v8 w=650000u l=150000u
** [instance X8 of sky130_fd_pr__pfet_01v8_hvt, params={'w': '1e+06u', 'l': '150000u'} connections=['d: [connection X8/d =>[signal: X w=1]]', 'g: [connection X8/g =>[signal: a_76_199# w=1]]', 's: [connection X8/s =>[signal: VPWR w=1]]', 'b: [connection X8/b =>[signal: VPB w=1]]']]
X_X_55__8 _73_/D X_55__a_76_199# VPWR VPWR sky130_fd_pr__pfet_01v8_hvt w=1e+06u l=150000u
** [instance X9 of sky130_fd_pr__nfet_01v8, params={'w': '420000u', 'l': '150000u'} connections=['d: [connection X9/d =>[signal: VGND w=1]]', 'g: [connection X9/g =>[signal: S w=1]]', 's: [connection X9/s =>[signal: a_218_47# w=1]]', 'b: [connection X9/b =>[signal: VNB w=1]]']]
X_X_55__9 VGND _58_/S X_55__a_218_47# VGND sky130_fd_pr__nfet_01v8 w=420000u l=150000u
** [instance X10 of sky130_fd_pr__nfet_01v8, params={'w': '420000u', 'l': '150000u'} connections=['d: [connection X10/d =>[signal: VGND w=1]]', 'g: [connection X10/g =>[signal: S w=1]]', 's: [connection X10/s =>[signal: a_505_21# w=1]]', 'b: [connection X10/b =>[signal: VNB w=1]]']]
X_X_55__10 VGND _58_/S X_55__a_505_21# VGND sky130_fd_pr__nfet_01v8 w=420000u l=150000u
** [instance X11 of sky130_fd_pr__nfet_01v8, params={'w': '420000u', 'l': '150000u'} connections=['d: [connection X11/d =>[signal: a_439_47# w=1]]', 'g: [connection X11/g =>[signal: a_505_21# w=1]]', 's: [connection X11/s =>[signal: VGND w=1]]', 'b: [connection X11/b =>[signal: VNB w=1]]']]
X_X_55__11 X_55__a_439_47# X_55__a_505_21# VGND VGND sky130_fd_pr__nfet_01v8 w=420000u l=150000u

** replacing X_38_ with the contents of sky130_fd_sc_hd__a22o_2
** [instance X0 of sky130_fd_pr__pfet_01v8_hvt, params={'w': '1e+06u', 'l': '150000u'} connections=['d: [connection X0/d =>[signal: VPWR w=1]]', 'g: [connection X0/g =>[signal: a_27_297# w=1]]', 's: [connection X0/s =>[signal: X w=1]]', 'b: [connection X0/b =>[signal: VPB w=1]]']]
X_X_38__0 VPWR X_38__a_27_297# _38_/X VPWR sky130_fd_pr__pfet_01v8_hvt w=1e+06u l=150000u
** [instance X1 of sky130_fd_pr__pfet_01v8_hvt, params={'w': '1e+06u', 'l': '150000u'} connections=['d: [connection X1/d =>[signal: a_109_297# w=1]]', 'g: [connection X1/g =>[signal: A2 w=1]]', 's: [connection X1/s =>[signal: VPWR w=1]]', 'b: [connection X1/b =>[signal: VPB w=1]]']]
X_X_38__1 X_38__a_109_297# _34_/X VPWR VPWR sky130_fd_pr__pfet_01v8_hvt w=1e+06u l=150000u
** [instance X2 of sky130_fd_pr__nfet_01v8, params={'w': '650000u', 'l': '150000u'} connections=['d: [connection X2/d =>[signal: a_109_47# w=1]]', 'g: [connection X2/g =>[signal: B1 w=1]]', 's: [connection X2/s =>[signal: a_27_297# w=1]]', 'b: [connection X2/b =>[signal: VNB w=1]]']]
X_X_38__2 X_38__a_109_47# _37_/X X_38__a_27_297# VGND sky130_fd_pr__nfet_01v8 w=650000u l=150000u
** [instance X3 of sky130_fd_pr__pfet_01v8_hvt, params={'w': '1e+06u', 'l': '150000u'} connections=['d: [connection X3/d =>[signal: VPWR w=1]]', 'g: [connection X3/g =>[signal: A1 w=1]]', 's: [connection X3/s =>[signal: a_109_297# w=1]]', 'b: [connection X3/b =>[signal: VPB w=1]]']]
X_X_38__3 VPWR _32_/X X_38__a_109_297# VPWR sky130_fd_pr__pfet_01v8_hvt w=1e+06u l=150000u
** [instance X4 of sky130_fd_pr__nfet_01v8, params={'w': '650000u', 'l': '150000u'} connections=['d: [connection X4/d =>[signal: X w=1]]', 'g: [connection X4/g =>[signal: a_27_297# w=1]]', 's: [connection X4/s =>[signal: VGND w=1]]', 'b: [connection X4/b =>[signal: VNB w=1]]']]
X_X_38__4 _38_/X X_38__a_27_297# VGND VGND sky130_fd_pr__nfet_01v8 w=650000u l=150000u
** [instance X5 of sky130_fd_pr__nfet_01v8, params={'w': '650000u', 'l': '150000u'} connections=['d: [connection X5/d =>[signal: VGND w=1]]', 'g: [connection X5/g =>[signal: a_27_297# w=1]]', 's: [connection X5/s =>[signal: X w=1]]', 'b: [connection X5/b =>[signal: VNB w=1]]']]
X_X_38__5 VGND X_38__a_27_297# _38_/X VGND sky130_fd_pr__nfet_01v8 w=650000u l=150000u
** [instance X6 of sky130_fd_pr__nfet_01v8, params={'w': '650000u', 'l': '150000u'} connections=['d: [connection X6/d =>[signal: VGND w=1]]', 'g: [connection X6/g =>[signal: B2 w=1]]', 's: [connection X6/s =>[signal: a_109_47# w=1]]', 'b: [connection X6/b =>[signal: VNB w=1]]']]
X_X_38__6 VGND _30_/Y X_38__a_109_47# VGND sky130_fd_pr__nfet_01v8 w=650000u l=150000u
** [instance X7 of sky130_fd_pr__pfet_01v8_hvt, params={'w': '1e+06u', 'l': '150000u'} connections=['d: [connection X7/d =>[signal: a_27_297# w=1]]', 'g: [connection X7/g =>[signal: B2 w=1]]', 's: [connection X7/s =>[signal: a_109_297# w=1]]', 'b: [connection X7/b =>[signal: VPB w=1]]']]
X_X_38__7 X_38__a_27_297# _30_/Y X_38__a_109_297# VPWR sky130_fd_pr__pfet_01v8_hvt w=1e+06u l=150000u
** [instance X8 of sky130_fd_pr__nfet_01v8, params={'w': '650000u', 'l': '150000u'} connections=['d: [connection X8/d =>[signal: a_27_297# w=1]]', 'g: [connection X8/g =>[signal: A1 w=1]]', 's: [connection X8/s =>[signal: a_381_47# w=1]]', 'b: [connection X8/b =>[signal: VNB w=1]]']]
X_X_38__8 X_38__a_27_297# _32_/X X_38__a_381_47# VGND sky130_fd_pr__nfet_01v8 w=650000u l=150000u
** [instance X9 of sky130_fd_pr__pfet_01v8_hvt, params={'w': '1e+06u', 'l': '150000u'} connections=['d: [connection X9/d =>[signal: a_109_297# w=1]]', 'g: [connection X9/g =>[signal: B1 w=1]]', 's: [connection X9/s =>[signal: a_27_297# w=1]]', 'b: [connection X9/b =>[signal: VPB w=1]]']]
X_X_38__9 X_38__a_109_297# _37_/X X_38__a_27_297# VPWR sky130_fd_pr__pfet_01v8_hvt w=1e+06u l=150000u
** [instance X10 of sky130_fd_pr__nfet_01v8, params={'w': '650000u', 'l': '150000u'} connections=['d: [connection X10/d =>[signal: a_381_47# w=1]]', 'g: [connection X10/g =>[signal: A2 w=1]]', 's: [connection X10/s =>[signal: VGND w=1]]', 'b: [connection X10/b =>[signal: VNB w=1]]']]
X_X_38__10 X_38__a_381_47# _34_/X VGND VGND sky130_fd_pr__nfet_01v8 w=650000u l=150000u
** [instance X11 of sky130_fd_pr__pfet_01v8_hvt, params={'w': '1e+06u', 'l': '150000u'} connections=['d: [connection X11/d =>[signal: X w=1]]', 'g: [connection X11/g =>[signal: a_27_297# w=1]]', 's: [connection X11/s =>[signal: VPWR w=1]]', 'b: [connection X11/b =>[signal: VPB w=1]]']]
X_X_38__11 _38_/X X_38__a_27_297# VPWR VPWR sky130_fd_pr__pfet_01v8_hvt w=1e+06u l=150000u

** replacing XPHY_EDGE_ROW_8_Right_8 with the contents of sky130_fd_sc_hd__decap_3
** [instance X0 of sky130_fd_pr__pfet_01v8_hvt, params={'w': '870000u', 'l': '590000u'} connections=['d: [connection X0/d =>[signal: VPWR w=1]]', 'g: [connection X0/g =>[signal: VGND w=1]]', 's: [connection X0/s =>[signal: VPWR w=1]]', 'b: [connection X0/b =>[signal: VPB w=1]]']]
X_XPHY_EDGE_ROW_8_Right_8_0 VPWR VGND VPWR VPWR sky130_fd_pr__pfet_01v8_hvt w=870000u l=590000u
** [instance X1 of sky130_fd_pr__nfet_01v8, params={'w': '550000u', 'l': '590000u'} connections=['d: [connection X1/d =>[signal: VGND w=1]]', 'g: [connection X1/g =>[signal: VPWR w=1]]', 's: [connection X1/s =>[signal: VGND w=1]]', 'b: [connection X1/b =>[signal: VNB w=1]]']]
X_XPHY_EDGE_ROW_8_Right_8_1 VGND VPWR VGND VGND sky130_fd_pr__nfet_01v8 w=550000u l=590000u

** replacing Xclkbuf_0_scan_clk with the contents of sky130_fd_sc_hd__clkbuf_16
** [instance X0 of sky130_fd_pr__pfet_01v8_hvt, params={'w': '1e+06u', 'l': '150000u'} connections=['d: [connection X0/d =>[signal: VPWR w=1]]', 'g: [connection X0/g =>[signal: a_110_47# w=1]]', 's: [connection X0/s =>[signal: X w=1]]', 'b: [connection X0/b =>[signal: VPB w=1]]']]
X_Xclkbuf_0_scan_clk_0 VPWR Xclkbuf_0_scan_clk_a_110_47# clkbuf_0_scan_clk/X VPWR sky130_fd_pr__pfet_01v8_hvt w=1e+06u l=150000u
** [instance X1 of sky130_fd_pr__nfet_01v8, params={'w': '420000u', 'l': '150000u'} connections=['d: [connection X1/d =>[signal: X w=1]]', 'g: [connection X1/g =>[signal: a_110_47# w=1]]', 's: [connection X1/s =>[signal: VGND w=1]]', 'b: [connection X1/b =>[signal: VNB w=1]]']]
X_Xclkbuf_0_scan_clk_1 clkbuf_0_scan_clk/X Xclkbuf_0_scan_clk_a_110_47# VGND VGND sky130_fd_pr__nfet_01v8 w=420000u l=150000u
** [instance X2 of sky130_fd_pr__nfet_01v8, params={'w': '420000u', 'l': '150000u'} connections=['d: [connection X2/d =>[signal: X w=1]]', 'g: [connection X2/g =>[signal: a_110_47# w=1]]', 's: [connection X2/s =>[signal: VGND w=1]]', 'b: [connection X2/b =>[signal: VNB w=1]]']]
X_Xclkbuf_0_scan_clk_2 clkbuf_0_scan_clk/X Xclkbuf_0_scan_clk_a_110_47# VGND VGND sky130_fd_pr__nfet_01v8 w=420000u l=150000u
** [instance X3 of sky130_fd_pr__pfet_01v8_hvt, params={'w': '1e+06u', 'l': '150000u'} connections=['d: [connection X3/d =>[signal: a_110_47# w=1]]', 'g: [connection X3/g =>[signal: A w=1]]', 's: [connection X3/s =>[signal: VPWR w=1]]', 'b: [connection X3/b =>[signal: VPB w=1]]']]
X_Xclkbuf_0_scan_clk_3 Xclkbuf_0_scan_clk_a_110_47# scan_clk VPWR VPWR sky130_fd_pr__pfet_01v8_hvt w=1e+06u l=150000u
** [instance X4 of sky130_fd_pr__pfet_01v8_hvt, params={'w': '1e+06u', 'l': '150000u'} connections=['d: [connection X4/d =>[signal: VPWR w=1]]', 'g: [connection X4/g =>[signal: a_110_47# w=1]]', 's: [connection X4/s =>[signal: X w=1]]', 'b: [connection X4/b =>[signal: VPB w=1]]']]
X_Xclkbuf_0_scan_clk_4 VPWR Xclkbuf_0_scan_clk_a_110_47# clkbuf_0_scan_clk/X VPWR sky130_fd_pr__pfet_01v8_hvt w=1e+06u l=150000u
** [instance X5 of sky130_fd_pr__pfet_01v8_hvt, params={'w': '1e+06u', 'l': '150000u'} connections=['d: [connection X5/d =>[signal: X w=1]]', 'g: [connection X5/g =>[signal: a_110_47# w=1]]', 's: [connection X5/s =>[signal: VPWR w=1]]', 'b: [connection X5/b =>[signal: VPB w=1]]']]
X_Xclkbuf_0_scan_clk_5 clkbuf_0_scan_clk/X Xclkbuf_0_scan_clk_a_110_47# VPWR VPWR sky130_fd_pr__pfet_01v8_hvt w=1e+06u l=150000u
** [instance X6 of sky130_fd_pr__nfet_01v8, params={'w': '420000u', 'l': '150000u'} connections=['d: [connection X6/d =>[signal: a_110_47# w=1]]', 'g: [connection X6/g =>[signal: A w=1]]', 's: [connection X6/s =>[signal: VGND w=1]]', 'b: [connection X6/b =>[signal: VNB w=1]]']]
X_Xclkbuf_0_scan_clk_6 Xclkbuf_0_scan_clk_a_110_47# scan_clk VGND VGND sky130_fd_pr__nfet_01v8 w=420000u l=150000u
** [instance X7 of sky130_fd_pr__pfet_01v8_hvt, params={'w': '1e+06u', 'l': '150000u'} connections=['d: [connection X7/d =>[signal: VPWR w=1]]', 'g: [connection X7/g =>[signal: A w=1]]', 's: [connection X7/s =>[signal: a_110_47# w=1]]', 'b: [connection X7/b =>[signal: VPB w=1]]']]
X_Xclkbuf_0_scan_clk_7 VPWR scan_clk Xclkbuf_0_scan_clk_a_110_47# VPWR sky130_fd_pr__pfet_01v8_hvt w=1e+06u l=150000u
** [instance X8 of sky130_fd_pr__nfet_01v8, params={'w': '420000u', 'l': '150000u'} connections=['d: [connection X8/d =>[signal: VGND w=1]]', 'g: [connection X8/g =>[signal: a_110_47# w=1]]', 's: [connection X8/s =>[signal: X w=1]]', 'b: [connection X8/b =>[signal: VNB w=1]]']]
X_Xclkbuf_0_scan_clk_8 VGND Xclkbuf_0_scan_clk_a_110_47# clkbuf_0_scan_clk/X VGND sky130_fd_pr__nfet_01v8 w=420000u l=150000u
** [instance X9 of sky130_fd_pr__nfet_01v8, params={'w': '420000u', 'l': '150000u'} connections=['d: [connection X9/d =>[signal: VGND w=1]]', 'g: [connection X9/g =>[signal: A w=1]]', 's: [connection X9/s =>[signal: a_110_47# w=1]]', 'b: [connection X9/b =>[signal: VNB w=1]]']]
X_Xclkbuf_0_scan_clk_9 VGND scan_clk Xclkbuf_0_scan_clk_a_110_47# VGND sky130_fd_pr__nfet_01v8 w=420000u l=150000u
** [instance X10 of sky130_fd_pr__nfet_01v8, params={'w': '420000u', 'l': '150000u'} connections=['d: [connection X10/d =>[signal: X w=1]]', 'g: [connection X10/g =>[signal: a_110_47# w=1]]', 's: [connection X10/s =>[signal: VGND w=1]]', 'b: [connection X10/b =>[signal: VNB w=1]]']]
X_Xclkbuf_0_scan_clk_10 clkbuf_0_scan_clk/X Xclkbuf_0_scan_clk_a_110_47# VGND VGND sky130_fd_pr__nfet_01v8 w=420000u l=150000u
** [instance X11 of sky130_fd_pr__nfet_01v8, params={'w': '420000u', 'l': '150000u'} connections=['d: [connection X11/d =>[signal: X w=1]]', 'g: [connection X11/g =>[signal: a_110_47# w=1]]', 's: [connection X11/s =>[signal: VGND w=1]]', 'b: [connection X11/b =>[signal: VNB w=1]]']]
X_Xclkbuf_0_scan_clk_11 clkbuf_0_scan_clk/X Xclkbuf_0_scan_clk_a_110_47# VGND VGND sky130_fd_pr__nfet_01v8 w=420000u l=150000u
** [instance X12 of sky130_fd_pr__pfet_01v8_hvt, params={'w': '1e+06u', 'l': '150000u'} connections=['d: [connection X12/d =>[signal: a_110_47# w=1]]', 'g: [connection X12/g =>[signal: A w=1]]', 's: [connection X12/s =>[signal: VPWR w=1]]', 'b: [connection X12/b =>[signal: VPB w=1]]']]
X_Xclkbuf_0_scan_clk_12 Xclkbuf_0_scan_clk_a_110_47# scan_clk VPWR VPWR sky130_fd_pr__pfet_01v8_hvt w=1e+06u l=150000u
** [instance X13 of sky130_fd_pr__pfet_01v8_hvt, params={'w': '1e+06u', 'l': '150000u'} connections=['d: [connection X13/d =>[signal: VPWR w=1]]', 'g: [connection X13/g =>[signal: a_110_47# w=1]]', 's: [connection X13/s =>[signal: X w=1]]', 'b: [connection X13/b =>[signal: VPB w=1]]']]
X_Xclkbuf_0_scan_clk_13 VPWR Xclkbuf_0_scan_clk_a_110_47# clkbuf_0_scan_clk/X VPWR sky130_fd_pr__pfet_01v8_hvt w=1e+06u l=150000u
** [instance X14 of sky130_fd_pr__nfet_01v8, params={'w': '420000u', 'l': '150000u'} connections=['d: [connection X14/d =>[signal: X w=1]]', 'g: [connection X14/g =>[signal: a_110_47# w=1]]', 's: [connection X14/s =>[signal: VGND w=1]]', 'b: [connection X14/b =>[signal: VNB w=1]]']]
X_Xclkbuf_0_scan_clk_14 clkbuf_0_scan_clk/X Xclkbuf_0_scan_clk_a_110_47# VGND VGND sky130_fd_pr__nfet_01v8 w=420000u l=150000u
** [instance X15 of sky130_fd_pr__pfet_01v8_hvt, params={'w': '1e+06u', 'l': '150000u'} connections=['d: [connection X15/d =>[signal: VPWR w=1]]', 'g: [connection X15/g =>[signal: A w=1]]', 's: [connection X15/s =>[signal: a_110_47# w=1]]', 'b: [connection X15/b =>[signal: VPB w=1]]']]
X_Xclkbuf_0_scan_clk_15 VPWR scan_clk Xclkbuf_0_scan_clk_a_110_47# VPWR sky130_fd_pr__pfet_01v8_hvt w=1e+06u l=150000u
** [instance X16 of sky130_fd_pr__nfet_01v8, params={'w': '420000u', 'l': '150000u'} connections=['d: [connection X16/d =>[signal: VGND w=1]]', 'g: [connection X16/g =>[signal: a_110_47# w=1]]', 's: [connection X16/s =>[signal: X w=1]]', 'b: [connection X16/b =>[signal: VNB w=1]]']]
X_Xclkbuf_0_scan_clk_16 VGND Xclkbuf_0_scan_clk_a_110_47# clkbuf_0_scan_clk/X VGND sky130_fd_pr__nfet_01v8 w=420000u l=150000u
** [instance X17 of sky130_fd_pr__nfet_01v8, params={'w': '420000u', 'l': '150000u'} connections=['d: [connection X17/d =>[signal: X w=1]]', 'g: [connection X17/g =>[signal: a_110_47# w=1]]', 's: [connection X17/s =>[signal: VGND w=1]]', 'b: [connection X17/b =>[signal: VNB w=1]]']]
X_Xclkbuf_0_scan_clk_17 clkbuf_0_scan_clk/X Xclkbuf_0_scan_clk_a_110_47# VGND VGND sky130_fd_pr__nfet_01v8 w=420000u l=150000u
** [instance X18 of sky130_fd_pr__nfet_01v8, params={'w': '420000u', 'l': '150000u'} connections=['d: [connection X18/d =>[signal: VGND w=1]]', 'g: [connection X18/g =>[signal: a_110_47# w=1]]', 's: [connection X18/s =>[signal: X w=1]]', 'b: [connection X18/b =>[signal: VNB w=1]]']]
X_Xclkbuf_0_scan_clk_18 VGND Xclkbuf_0_scan_clk_a_110_47# clkbuf_0_scan_clk/X VGND sky130_fd_pr__nfet_01v8 w=420000u l=150000u
** [instance X19 of sky130_fd_pr__nfet_01v8, params={'w': '420000u', 'l': '150000u'} connections=['d: [connection X19/d =>[signal: VGND w=1]]', 'g: [connection X19/g =>[signal: a_110_47# w=1]]', 's: [connection X19/s =>[signal: X w=1]]', 'b: [connection X19/b =>[signal: VNB w=1]]']]
X_Xclkbuf_0_scan_clk_19 VGND Xclkbuf_0_scan_clk_a_110_47# clkbuf_0_scan_clk/X VGND sky130_fd_pr__nfet_01v8 w=420000u l=150000u
** [instance X20 of sky130_fd_pr__pfet_01v8_hvt, params={'w': '1e+06u', 'l': '150000u'} connections=['d: [connection X20/d =>[signal: X w=1]]', 'g: [connection X20/g =>[signal: a_110_47# w=1]]', 's: [connection X20/s =>[signal: VPWR w=1]]', 'b: [connection X20/b =>[signal: VPB w=1]]']]
X_Xclkbuf_0_scan_clk_20 clkbuf_0_scan_clk/X Xclkbuf_0_scan_clk_a_110_47# VPWR VPWR sky130_fd_pr__pfet_01v8_hvt w=1e+06u l=150000u
** [instance X21 of sky130_fd_pr__pfet_01v8_hvt, params={'w': '1e+06u', 'l': '150000u'} connections=['d: [connection X21/d =>[signal: X w=1]]', 'g: [connection X21/g =>[signal: a_110_47# w=1]]', 's: [connection X21/s =>[signal: VPWR w=1]]', 'b: [connection X21/b =>[signal: VPB w=1]]']]
X_Xclkbuf_0_scan_clk_21 clkbuf_0_scan_clk/X Xclkbuf_0_scan_clk_a_110_47# VPWR VPWR sky130_fd_pr__pfet_01v8_hvt w=1e+06u l=150000u
** [instance X22 of sky130_fd_pr__pfet_01v8_hvt, params={'w': '1e+06u', 'l': '150000u'} connections=['d: [connection X22/d =>[signal: X w=1]]', 'g: [connection X22/g =>[signal: a_110_47# w=1]]', 's: [connection X22/s =>[signal: VPWR w=1]]', 'b: [connection X22/b =>[signal: VPB w=1]]']]
X_Xclkbuf_0_scan_clk_22 clkbuf_0_scan_clk/X Xclkbuf_0_scan_clk_a_110_47# VPWR VPWR sky130_fd_pr__pfet_01v8_hvt w=1e+06u l=150000u
** [instance X23 of sky130_fd_pr__pfet_01v8_hvt, params={'w': '1e+06u', 'l': '150000u'} connections=['d: [connection X23/d =>[signal: VPWR w=1]]', 'g: [connection X23/g =>[signal: a_110_47# w=1]]', 's: [connection X23/s =>[signal: X w=1]]', 'b: [connection X23/b =>[signal: VPB w=1]]']]
X_Xclkbuf_0_scan_clk_23 VPWR Xclkbuf_0_scan_clk_a_110_47# clkbuf_0_scan_clk/X VPWR sky130_fd_pr__pfet_01v8_hvt w=1e+06u l=150000u
** [instance X24 of sky130_fd_pr__pfet_01v8_hvt, params={'w': '1e+06u', 'l': '150000u'} connections=['d: [connection X24/d =>[signal: VPWR w=1]]', 'g: [connection X24/g =>[signal: a_110_47# w=1]]', 's: [connection X24/s =>[signal: X w=1]]', 'b: [connection X24/b =>[signal: VPB w=1]]']]
X_Xclkbuf_0_scan_clk_24 VPWR Xclkbuf_0_scan_clk_a_110_47# clkbuf_0_scan_clk/X VPWR sky130_fd_pr__pfet_01v8_hvt w=1e+06u l=150000u
** [instance X25 of sky130_fd_pr__nfet_01v8, params={'w': '420000u', 'l': '150000u'} connections=['d: [connection X25/d =>[signal: VGND w=1]]', 'g: [connection X25/g =>[signal: a_110_47# w=1]]', 's: [connection X25/s =>[signal: X w=1]]', 'b: [connection X25/b =>[signal: VNB w=1]]']]
X_Xclkbuf_0_scan_clk_25 VGND Xclkbuf_0_scan_clk_a_110_47# clkbuf_0_scan_clk/X VGND sky130_fd_pr__nfet_01v8 w=420000u l=150000u
** [instance X26 of sky130_fd_pr__pfet_01v8_hvt, params={'w': '1e+06u', 'l': '150000u'} connections=['d: [connection X26/d =>[signal: X w=1]]', 'g: [connection X26/g =>[signal: a_110_47# w=1]]', 's: [connection X26/s =>[signal: VPWR w=1]]', 'b: [connection X26/b =>[signal: VPB w=1]]']]
X_Xclkbuf_0_scan_clk_26 clkbuf_0_scan_clk/X Xclkbuf_0_scan_clk_a_110_47# VPWR VPWR sky130_fd_pr__pfet_01v8_hvt w=1e+06u l=150000u
** [instance X27 of sky130_fd_pr__nfet_01v8, params={'w': '420000u', 'l': '150000u'} connections=['d: [connection X27/d =>[signal: X w=1]]', 'g: [connection X27/g =>[signal: a_110_47# w=1]]', 's: [connection X27/s =>[signal: VGND w=1]]', 'b: [connection X27/b =>[signal: VNB w=1]]']]
X_Xclkbuf_0_scan_clk_27 clkbuf_0_scan_clk/X Xclkbuf_0_scan_clk_a_110_47# VGND VGND sky130_fd_pr__nfet_01v8 w=420000u l=150000u
** [instance X28 of sky130_fd_pr__pfet_01v8_hvt, params={'w': '1e+06u', 'l': '150000u'} connections=['d: [connection X28/d =>[signal: VPWR w=1]]', 'g: [connection X28/g =>[signal: a_110_47# w=1]]', 's: [connection X28/s =>[signal: X w=1]]', 'b: [connection X28/b =>[signal: VPB w=1]]']]
X_Xclkbuf_0_scan_clk_28 VPWR Xclkbuf_0_scan_clk_a_110_47# clkbuf_0_scan_clk/X VPWR sky130_fd_pr__pfet_01v8_hvt w=1e+06u l=150000u
** [instance X29 of sky130_fd_pr__nfet_01v8, params={'w': '420000u', 'l': '150000u'} connections=['d: [connection X29/d =>[signal: VGND w=1]]', 'g: [connection X29/g =>[signal: a_110_47# w=1]]', 's: [connection X29/s =>[signal: X w=1]]', 'b: [connection X29/b =>[signal: VNB w=1]]']]
X_Xclkbuf_0_scan_clk_29 VGND Xclkbuf_0_scan_clk_a_110_47# clkbuf_0_scan_clk/X VGND sky130_fd_pr__nfet_01v8 w=420000u l=150000u
** [instance X30 of sky130_fd_pr__nfet_01v8, params={'w': '420000u', 'l': '150000u'} connections=['d: [connection X30/d =>[signal: X w=1]]', 'g: [connection X30/g =>[signal: a_110_47# w=1]]', 's: [connection X30/s =>[signal: VGND w=1]]', 'b: [connection X30/b =>[signal: VNB w=1]]']]
X_Xclkbuf_0_scan_clk_30 clkbuf_0_scan_clk/X Xclkbuf_0_scan_clk_a_110_47# VGND VGND sky130_fd_pr__nfet_01v8 w=420000u l=150000u
** [instance X31 of sky130_fd_pr__pfet_01v8_hvt, params={'w': '1e+06u', 'l': '150000u'} connections=['d: [connection X31/d =>[signal: X w=1]]', 'g: [connection X31/g =>[signal: a_110_47# w=1]]', 's: [connection X31/s =>[signal: VPWR w=1]]', 'b: [connection X31/b =>[signal: VPB w=1]]']]
X_Xclkbuf_0_scan_clk_31 clkbuf_0_scan_clk/X Xclkbuf_0_scan_clk_a_110_47# VPWR VPWR sky130_fd_pr__pfet_01v8_hvt w=1e+06u l=150000u
** [instance X32 of sky130_fd_pr__pfet_01v8_hvt, params={'w': '1e+06u', 'l': '150000u'} connections=['d: [connection X32/d =>[signal: X w=1]]', 'g: [connection X32/g =>[signal: a_110_47# w=1]]', 's: [connection X32/s =>[signal: VPWR w=1]]', 'b: [connection X32/b =>[signal: VPB w=1]]']]
X_Xclkbuf_0_scan_clk_32 clkbuf_0_scan_clk/X Xclkbuf_0_scan_clk_a_110_47# VPWR VPWR sky130_fd_pr__pfet_01v8_hvt w=1e+06u l=150000u
** [instance X33 of sky130_fd_pr__pfet_01v8_hvt, params={'w': '1e+06u', 'l': '150000u'} connections=['d: [connection X33/d =>[signal: X w=1]]', 'g: [connection X33/g =>[signal: a_110_47# w=1]]', 's: [connection X33/s =>[signal: VPWR w=1]]', 'b: [connection X33/b =>[signal: VPB w=1]]']]
X_Xclkbuf_0_scan_clk_33 clkbuf_0_scan_clk/X Xclkbuf_0_scan_clk_a_110_47# VPWR VPWR sky130_fd_pr__pfet_01v8_hvt w=1e+06u l=150000u
** [instance X34 of sky130_fd_pr__nfet_01v8, params={'w': '420000u', 'l': '150000u'} connections=['d: [connection X34/d =>[signal: a_110_47# w=1]]', 'g: [connection X34/g =>[signal: A w=1]]', 's: [connection X34/s =>[signal: VGND w=1]]', 'b: [connection X34/b =>[signal: VNB w=1]]']]
X_Xclkbuf_0_scan_clk_34 Xclkbuf_0_scan_clk_a_110_47# scan_clk VGND VGND sky130_fd_pr__nfet_01v8 w=420000u l=150000u
** [instance X35 of sky130_fd_pr__pfet_01v8_hvt, params={'w': '1e+06u', 'l': '150000u'} connections=['d: [connection X35/d =>[signal: VPWR w=1]]', 'g: [connection X35/g =>[signal: a_110_47# w=1]]', 's: [connection X35/s =>[signal: X w=1]]', 'b: [connection X35/b =>[signal: VPB w=1]]']]
X_Xclkbuf_0_scan_clk_35 VPWR Xclkbuf_0_scan_clk_a_110_47# clkbuf_0_scan_clk/X VPWR sky130_fd_pr__pfet_01v8_hvt w=1e+06u l=150000u
** [instance X36 of sky130_fd_pr__nfet_01v8, params={'w': '420000u', 'l': '150000u'} connections=['d: [connection X36/d =>[signal: VGND w=1]]', 'g: [connection X36/g =>[signal: A w=1]]', 's: [connection X36/s =>[signal: a_110_47# w=1]]', 'b: [connection X36/b =>[signal: VNB w=1]]']]
X_Xclkbuf_0_scan_clk_36 VGND scan_clk Xclkbuf_0_scan_clk_a_110_47# VGND sky130_fd_pr__nfet_01v8 w=420000u l=150000u
** [instance X37 of sky130_fd_pr__pfet_01v8_hvt, params={'w': '1e+06u', 'l': '150000u'} connections=['d: [connection X37/d =>[signal: VPWR w=1]]', 'g: [connection X37/g =>[signal: a_110_47# w=1]]', 's: [connection X37/s =>[signal: X w=1]]', 'b: [connection X37/b =>[signal: VPB w=1]]']]
X_Xclkbuf_0_scan_clk_37 VPWR Xclkbuf_0_scan_clk_a_110_47# clkbuf_0_scan_clk/X VPWR sky130_fd_pr__pfet_01v8_hvt w=1e+06u l=150000u
** [instance X38 of sky130_fd_pr__nfet_01v8, params={'w': '420000u', 'l': '150000u'} connections=['d: [connection X38/d =>[signal: VGND w=1]]', 'g: [connection X38/g =>[signal: a_110_47# w=1]]', 's: [connection X38/s =>[signal: X w=1]]', 'b: [connection X38/b =>[signal: VNB w=1]]']]
X_Xclkbuf_0_scan_clk_38 VGND Xclkbuf_0_scan_clk_a_110_47# clkbuf_0_scan_clk/X VGND sky130_fd_pr__nfet_01v8 w=420000u l=150000u
** [instance X39 of sky130_fd_pr__nfet_01v8, params={'w': '420000u', 'l': '150000u'} connections=['d: [connection X39/d =>[signal: VGND w=1]]', 'g: [connection X39/g =>[signal: a_110_47# w=1]]', 's: [connection X39/s =>[signal: X w=1]]', 'b: [connection X39/b =>[signal: VNB w=1]]']]
X_Xclkbuf_0_scan_clk_39 VGND Xclkbuf_0_scan_clk_a_110_47# clkbuf_0_scan_clk/X VGND sky130_fd_pr__nfet_01v8 w=420000u l=150000u

** replacing X_71_ with the contents of sky130_fd_sc_hd__dfxtp_2
** [instance X0 of sky130_fd_pr__pfet_01v8_hvt, params={'w': '420000u', 'l': '150000u'} connections=['d: [connection X0/d =>[signal: a_891_413# w=1]]', 'g: [connection X0/g =>[signal: a_193_47# w=1]]', 's: [connection X0/s =>[signal: a_975_413# w=1]]', 'b: [connection X0/b =>[signal: VPB w=1]]']]
X_X_71__0 X_71__a_891_413# X_71__a_193_47# X_71__a_975_413# VPWR sky130_fd_pr__pfet_01v8_hvt w=420000u l=150000u
** [instance X1 of sky130_fd_pr__nfet_01v8, params={'w': '650000u', 'l': '150000u'} connections=['d: [connection X1/d =>[signal: a_1059_315# w=1]]', 'g: [connection X1/g =>[signal: a_891_413# w=1]]', 's: [connection X1/s =>[signal: VGND w=1]]', 'b: [connection X1/b =>[signal: VNB w=1]]']]
X_X_71__1 X_71__a_1059_315# X_71__a_891_413# VGND VGND sky130_fd_pr__nfet_01v8 w=650000u l=150000u
** [instance X2 of sky130_fd_pr__pfet_01v8_hvt, params={'w': '420000u', 'l': '150000u'} connections=['d: [connection X2/d =>[signal: a_466_413# w=1]]', 'g: [connection X2/g =>[signal: a_27_47# w=1]]', 's: [connection X2/s =>[signal: a_561_413# w=1]]', 'b: [connection X2/b =>[signal: VPB w=1]]']]
X_X_71__2 X_71__a_466_413# X_71__a_27_47# X_71__a_561_413# VPWR sky130_fd_pr__pfet_01v8_hvt w=420000u l=150000u
** [instance X3 of sky130_fd_pr__pfet_01v8_hvt, params={'w': '420000u', 'l': '150000u'} connections=['d: [connection X3/d =>[signal: a_634_159# w=1]]', 'g: [connection X3/g =>[signal: a_27_47# w=1]]', 's: [connection X3/s =>[signal: a_891_413# w=1]]', 'b: [connection X3/b =>[signal: VPB w=1]]']]
X_X_71__3 X_71__a_634_159# X_71__a_27_47# X_71__a_891_413# VPWR sky130_fd_pr__pfet_01v8_hvt w=420000u l=150000u
** [instance X4 of sky130_fd_pr__pfet_01v8_hvt, params={'w': '420000u', 'l': '150000u'} connections=['d: [connection X4/d =>[signal: a_381_47# w=1]]', 'g: [connection X4/g =>[signal: a_193_47# w=1]]', 's: [connection X4/s =>[signal: a_466_413# w=1]]', 'b: [connection X4/b =>[signal: VPB w=1]]']]
X_X_71__4 X_71__a_381_47# X_71__a_193_47# X_71__a_466_413# VPWR sky130_fd_pr__pfet_01v8_hvt w=420000u l=150000u
** [instance X5 of sky130_fd_pr__pfet_01v8_hvt, params={'w': '420000u', 'l': '150000u'} connections=['d: [connection X5/d =>[signal: VPWR w=1]]', 'g: [connection X5/g =>[signal: D w=1]]', 's: [connection X5/s =>[signal: a_381_47# w=1]]', 'b: [connection X5/b =>[signal: VPB w=1]]']]
X_X_71__5 VPWR _71_/D X_71__a_381_47# VPWR sky130_fd_pr__pfet_01v8_hvt w=420000u l=150000u
** [instance X6 of sky130_fd_pr__pfet_01v8_hvt, params={'w': '750000u', 'l': '150000u'} connections=['d: [connection X6/d =>[signal: VPWR w=1]]', 'g: [connection X6/g =>[signal: a_466_413# w=1]]', 's: [connection X6/s =>[signal: a_634_159# w=1]]', 'b: [connection X6/b =>[signal: VPB w=1]]']]
X_X_71__6 VPWR X_71__a_466_413# X_71__a_634_159# VPWR sky130_fd_pr__pfet_01v8_hvt w=750000u l=150000u
** [instance X7 of sky130_fd_pr__nfet_01v8, params={'w': '640000u', 'l': '150000u'} connections=['d: [connection X7/d =>[signal: VGND w=1]]', 'g: [connection X7/g =>[signal: a_466_413# w=1]]', 's: [connection X7/s =>[signal: a_634_159# w=1]]', 'b: [connection X7/b =>[signal: VNB w=1]]']]
X_X_71__7 VGND X_71__a_466_413# X_71__a_634_159# VGND sky130_fd_pr__nfet_01v8 w=640000u l=150000u
** [instance X8 of sky130_fd_pr__nfet_01v8, params={'w': '420000u', 'l': '150000u'} connections=['d: [connection X8/d =>[signal: a_1017_47# w=1]]', 'g: [connection X8/g =>[signal: a_1059_315# w=1]]', 's: [connection X8/s =>[signal: VGND w=1]]', 'b: [connection X8/b =>[signal: VNB w=1]]']]
X_X_71__8 X_71__a_1017_47# X_71__a_1059_315# VGND VGND sky130_fd_pr__nfet_01v8 w=420000u l=150000u
** [instance X9 of sky130_fd_pr__pfet_01v8_hvt, params={'w': '1e+06u', 'l': '150000u'} connections=['d: [connection X9/d =>[signal: a_1059_315# w=1]]', 'g: [connection X9/g =>[signal: a_891_413# w=1]]', 's: [connection X9/s =>[signal: VPWR w=1]]', 'b: [connection X9/b =>[signal: VPB w=1]]']]
X_X_71__9 X_71__a_1059_315# X_71__a_891_413# VPWR VPWR sky130_fd_pr__pfet_01v8_hvt w=1e+06u l=150000u
** [instance X10 of sky130_fd_pr__pfet_01v8_hvt, params={'w': '1e+06u', 'l': '150000u'} connections=['d: [connection X10/d =>[signal: Q w=1]]', 'g: [connection X10/g =>[signal: a_1059_315# w=1]]', 's: [connection X10/s =>[signal: VPWR w=1]]', 'b: [connection X10/b =>[signal: VPB w=1]]']]
X_X_71__10 _71_/Q X_71__a_1059_315# VPWR VPWR sky130_fd_pr__pfet_01v8_hvt w=1e+06u l=150000u
** [instance X11 of sky130_fd_pr__pfet_01v8_hvt, params={'w': '420000u', 'l': '150000u'} connections=['d: [connection X11/d =>[signal: a_561_413# w=1]]', 'g: [connection X11/g =>[signal: a_634_159# w=1]]', 's: [connection X11/s =>[signal: VPWR w=1]]', 'b: [connection X11/b =>[signal: VPB w=1]]']]
X_X_71__11 X_71__a_561_413# X_71__a_634_159# VPWR VPWR sky130_fd_pr__pfet_01v8_hvt w=420000u l=150000u
** [instance X12 of sky130_fd_pr__pfet_01v8_hvt, params={'w': '1e+06u', 'l': '150000u'} connections=['d: [connection X12/d =>[signal: VPWR w=1]]', 'g: [connection X12/g =>[signal: a_1059_315# w=1]]', 's: [connection X12/s =>[signal: Q w=1]]', 'b: [connection X12/b =>[signal: VPB w=1]]']]
X_X_71__12 VPWR X_71__a_1059_315# _71_/Q VPWR sky130_fd_pr__pfet_01v8_hvt w=1e+06u l=150000u
** [instance X13 of sky130_fd_pr__nfet_01v8, params={'w': '360000u', 'l': '150000u'} connections=['d: [connection X13/d =>[signal: a_891_413# w=1]]', 'g: [connection X13/g =>[signal: a_27_47# w=1]]', 's: [connection X13/s =>[signal: a_1017_47# w=1]]', 'b: [connection X13/b =>[signal: VNB w=1]]']]
X_X_71__13 X_71__a_891_413# X_71__a_27_47# X_71__a_1017_47# VGND sky130_fd_pr__nfet_01v8 w=360000u l=150000u
** [instance X14 of sky130_fd_pr__nfet_01v8, params={'w': '360000u', 'l': '150000u'} connections=['d: [connection X14/d =>[signal: a_634_159# w=1]]', 'g: [connection X14/g =>[signal: a_193_47# w=1]]', 's: [connection X14/s =>[signal: a_891_413# w=1]]', 'b: [connection X14/b =>[signal: VNB w=1]]']]
X_X_71__14 X_71__a_634_159# X_71__a_193_47# X_71__a_891_413# VGND sky130_fd_pr__nfet_01v8 w=360000u l=150000u
** [instance X15 of sky130_fd_pr__nfet_01v8, params={'w': '420000u', 'l': '150000u'} connections=['d: [connection X15/d =>[signal: a_592_47# w=1]]', 'g: [connection X15/g =>[signal: a_634_159# w=1]]', 's: [connection X15/s =>[signal: VGND w=1]]', 'b: [connection X15/b =>[signal: VNB w=1]]']]
X_X_71__15 X_71__a_592_47# X_71__a_634_159# VGND VGND sky130_fd_pr__nfet_01v8 w=420000u l=150000u
** [instance X16 of sky130_fd_pr__nfet_01v8, params={'w': '360000u', 'l': '150000u'} connections=['d: [connection X16/d =>[signal: a_466_413# w=1]]', 'g: [connection X16/g =>[signal: a_193_47# w=1]]', 's: [connection X16/s =>[signal: a_592_47# w=1]]', 'b: [connection X16/b =>[signal: VNB w=1]]']]
X_X_71__16 X_71__a_466_413# X_71__a_193_47# X_71__a_592_47# VGND sky130_fd_pr__nfet_01v8 w=360000u l=150000u
** [instance X17 of sky130_fd_pr__nfet_01v8, params={'w': '420000u', 'l': '150000u'} connections=['d: [connection X17/d =>[signal: VGND w=1]]', 'g: [connection X17/g =>[signal: a_27_47# w=1]]', 's: [connection X17/s =>[signal: a_193_47# w=1]]', 'b: [connection X17/b =>[signal: VNB w=1]]']]
X_X_71__17 VGND X_71__a_27_47# X_71__a_193_47# VGND sky130_fd_pr__nfet_01v8 w=420000u l=150000u
** [instance X18 of sky130_fd_pr__nfet_01v8, params={'w': '360000u', 'l': '150000u'} connections=['d: [connection X18/d =>[signal: a_381_47# w=1]]', 'g: [connection X18/g =>[signal: a_27_47# w=1]]', 's: [connection X18/s =>[signal: a_466_413# w=1]]', 'b: [connection X18/b =>[signal: VNB w=1]]']]
X_X_71__18 X_71__a_381_47# X_71__a_27_47# X_71__a_466_413# VGND sky130_fd_pr__nfet_01v8 w=360000u l=150000u
** [instance X19 of sky130_fd_pr__nfet_01v8, params={'w': '420000u', 'l': '150000u'} connections=['d: [connection X19/d =>[signal: a_27_47# w=1]]', 'g: [connection X19/g =>[signal: CLK w=1]]', 's: [connection X19/s =>[signal: VGND w=1]]', 'b: [connection X19/b =>[signal: VNB w=1]]']]
X_X_71__19 X_71__a_27_47# _71_/CLK VGND VGND sky130_fd_pr__nfet_01v8 w=420000u l=150000u
** [instance X20 of sky130_fd_pr__pfet_01v8_hvt, params={'w': '640000u', 'l': '150000u'} connections=['d: [connection X20/d =>[signal: a_27_47# w=1]]', 'g: [connection X20/g =>[signal: CLK w=1]]', 's: [connection X20/s =>[signal: VPWR w=1]]', 'b: [connection X20/b =>[signal: VPB w=1]]']]
X_X_71__20 X_71__a_27_47# _71_/CLK VPWR VPWR sky130_fd_pr__pfet_01v8_hvt w=640000u l=150000u
** [instance X21 of sky130_fd_pr__nfet_01v8, params={'w': '650000u', 'l': '150000u'} connections=['d: [connection X21/d =>[signal: Q w=1]]', 'g: [connection X21/g =>[signal: a_1059_315# w=1]]', 's: [connection X21/s =>[signal: VGND w=1]]', 'b: [connection X21/b =>[signal: VNB w=1]]']]
X_X_71__21 _71_/Q X_71__a_1059_315# VGND VGND sky130_fd_pr__nfet_01v8 w=650000u l=150000u
** [instance X22 of sky130_fd_pr__pfet_01v8_hvt, params={'w': '640000u', 'l': '150000u'} connections=['d: [connection X22/d =>[signal: VPWR w=1]]', 'g: [connection X22/g =>[signal: a_27_47# w=1]]', 's: [connection X22/s =>[signal: a_193_47# w=1]]', 'b: [connection X22/b =>[signal: VPB w=1]]']]
X_X_71__22 VPWR X_71__a_27_47# X_71__a_193_47# VPWR sky130_fd_pr__pfet_01v8_hvt w=640000u l=150000u
** [instance X23 of sky130_fd_pr__nfet_01v8, params={'w': '420000u', 'l': '150000u'} connections=['d: [connection X23/d =>[signal: VGND w=1]]', 'g: [connection X23/g =>[signal: D w=1]]', 's: [connection X23/s =>[signal: a_381_47# w=1]]', 'b: [connection X23/b =>[signal: VNB w=1]]']]
X_X_71__23 VGND _71_/D X_71__a_381_47# VGND sky130_fd_pr__nfet_01v8 w=420000u l=150000u
** [instance X24 of sky130_fd_pr__pfet_01v8_hvt, params={'w': '420000u', 'l': '150000u'} connections=['d: [connection X24/d =>[signal: a_975_413# w=1]]', 'g: [connection X24/g =>[signal: a_1059_315# w=1]]', 's: [connection X24/s =>[signal: VPWR w=1]]', 'b: [connection X24/b =>[signal: VPB w=1]]']]
X_X_71__24 X_71__a_975_413# X_71__a_1059_315# VPWR VPWR sky130_fd_pr__pfet_01v8_hvt w=420000u l=150000u
** [instance X25 of sky130_fd_pr__nfet_01v8, params={'w': '650000u', 'l': '150000u'} connections=['d: [connection X25/d =>[signal: VGND w=1]]', 'g: [connection X25/g =>[signal: a_1059_315# w=1]]', 's: [connection X25/s =>[signal: Q w=1]]', 'b: [connection X25/b =>[signal: VNB w=1]]']]
X_X_71__25 VGND X_71__a_1059_315# _71_/Q VGND sky130_fd_pr__nfet_01v8 w=650000u l=150000u

** replacing X_54_ with the contents of sky130_fd_sc_hd__mux2_1
** [instance X0 of sky130_fd_pr__pfet_01v8_hvt, params={'w': '420000u', 'l': '150000u'} connections=['d: [connection X0/d =>[signal: VPWR w=1]]', 'g: [connection X0/g =>[signal: S w=1]]', 's: [connection X0/s =>[signal: a_218_374# w=1]]', 'b: [connection X0/b =>[signal: VPB w=1]]']]
X_X_54__0 VPWR _58_/S X_54__a_218_374# VPWR sky130_fd_pr__pfet_01v8_hvt w=420000u l=150000u
** [instance X1 of sky130_fd_pr__nfet_01v8, params={'w': '420000u', 'l': '150000u'} connections=['d: [connection X1/d =>[signal: a_76_199# w=1]]', 'g: [connection X1/g =>[signal: A0 w=1]]', 's: [connection X1/s =>[signal: a_439_47# w=1]]', 'b: [connection X1/b =>[signal: VNB w=1]]']]
X_X_54__1 X_54__a_76_199# _54_/A0 X_54__a_439_47# VGND sky130_fd_pr__nfet_01v8 w=420000u l=150000u
** [instance X2 of sky130_fd_pr__pfet_01v8_hvt, params={'w': '420000u', 'l': '150000u'} connections=['d: [connection X2/d =>[signal: a_535_374# w=1]]', 'g: [connection X2/g =>[signal: a_505_21# w=1]]', 's: [connection X2/s =>[signal: VPWR w=1]]', 'b: [connection X2/b =>[signal: VPB w=1]]']]
X_X_54__2 X_54__a_535_374# X_54__a_505_21# VPWR VPWR sky130_fd_pr__pfet_01v8_hvt w=420000u l=150000u
** [instance X3 of sky130_fd_pr__pfet_01v8_hvt, params={'w': '420000u', 'l': '150000u'} connections=['d: [connection X3/d =>[signal: VPWR w=1]]', 'g: [connection X3/g =>[signal: S w=1]]', 's: [connection X3/s =>[signal: a_505_21# w=1]]', 'b: [connection X3/b =>[signal: VPB w=1]]']]
X_X_54__3 VPWR _58_/S X_54__a_505_21# VPWR sky130_fd_pr__pfet_01v8_hvt w=420000u l=150000u
** [instance X4 of sky130_fd_pr__pfet_01v8_hvt, params={'w': '420000u', 'l': '150000u'} connections=['d: [connection X4/d =>[signal: a_76_199# w=1]]', 'g: [connection X4/g =>[signal: A1 w=1]]', 's: [connection X4/s =>[signal: a_535_374# w=1]]', 'b: [connection X4/b =>[signal: VPB w=1]]']]
X_X_54__4 X_54__a_76_199# _55_/A0 X_54__a_535_374# VPWR sky130_fd_pr__pfet_01v8_hvt w=420000u l=150000u
** [instance X5 of sky130_fd_pr__nfet_01v8, params={'w': '420000u', 'l': '150000u'} connections=['d: [connection X5/d =>[signal: a_218_47# w=1]]', 'g: [connection X5/g =>[signal: A1 w=1]]', 's: [connection X5/s =>[signal: a_76_199# w=1]]', 'b: [connection X5/b =>[signal: VNB w=1]]']]
X_X_54__5 X_54__a_218_47# _55_/A0 X_54__a_76_199# VGND sky130_fd_pr__nfet_01v8 w=420000u l=150000u
** [instance X6 of sky130_fd_pr__pfet_01v8_hvt, params={'w': '420000u', 'l': '150000u'} connections=['d: [connection X6/d =>[signal: a_218_374# w=1]]', 'g: [connection X6/g =>[signal: A0 w=1]]', 's: [connection X6/s =>[signal: a_76_199# w=1]]', 'b: [connection X6/b =>[signal: VPB w=1]]']]
X_X_54__6 X_54__a_218_374# _54_/A0 X_54__a_76_199# VPWR sky130_fd_pr__pfet_01v8_hvt w=420000u l=150000u
** [instance X7 of sky130_fd_pr__nfet_01v8, params={'w': '650000u', 'l': '150000u'} connections=['d: [connection X7/d =>[signal: X w=1]]', 'g: [connection X7/g =>[signal: a_76_199# w=1]]', 's: [connection X7/s =>[signal: VGND w=1]]', 'b: [connection X7/b =>[signal: VNB w=1]]']]
X_X_54__7 _72_/D X_54__a_76_199# VGND VGND sky130_fd_pr__nfet_01v8 w=650000u l=150000u
** [instance X8 of sky130_fd_pr__pfet_01v8_hvt, params={'w': '1e+06u', 'l': '150000u'} connections=['d: [connection X8/d =>[signal: X w=1]]', 'g: [connection X8/g =>[signal: a_76_199# w=1]]', 's: [connection X8/s =>[signal: VPWR w=1]]', 'b: [connection X8/b =>[signal: VPB w=1]]']]
X_X_54__8 _72_/D X_54__a_76_199# VPWR VPWR sky130_fd_pr__pfet_01v8_hvt w=1e+06u l=150000u
** [instance X9 of sky130_fd_pr__nfet_01v8, params={'w': '420000u', 'l': '150000u'} connections=['d: [connection X9/d =>[signal: VGND w=1]]', 'g: [connection X9/g =>[signal: S w=1]]', 's: [connection X9/s =>[signal: a_218_47# w=1]]', 'b: [connection X9/b =>[signal: VNB w=1]]']]
X_X_54__9 VGND _58_/S X_54__a_218_47# VGND sky130_fd_pr__nfet_01v8 w=420000u l=150000u
** [instance X10 of sky130_fd_pr__nfet_01v8, params={'w': '420000u', 'l': '150000u'} connections=['d: [connection X10/d =>[signal: VGND w=1]]', 'g: [connection X10/g =>[signal: S w=1]]', 's: [connection X10/s =>[signal: a_505_21# w=1]]', 'b: [connection X10/b =>[signal: VNB w=1]]']]
X_X_54__10 VGND _58_/S X_54__a_505_21# VGND sky130_fd_pr__nfet_01v8 w=420000u l=150000u
** [instance X11 of sky130_fd_pr__nfet_01v8, params={'w': '420000u', 'l': '150000u'} connections=['d: [connection X11/d =>[signal: a_439_47# w=1]]', 'g: [connection X11/g =>[signal: a_505_21# w=1]]', 's: [connection X11/s =>[signal: VGND w=1]]', 'b: [connection X11/b =>[signal: VNB w=1]]']]
X_X_54__11 X_54__a_439_47# X_54__a_505_21# VGND VGND sky130_fd_pr__nfet_01v8 w=420000u l=150000u

** replacing XPHY_EDGE_ROW_2_Left_16 with the contents of sky130_fd_sc_hd__decap_3
** [instance X0 of sky130_fd_pr__pfet_01v8_hvt, params={'w': '870000u', 'l': '590000u'} connections=['d: [connection X0/d =>[signal: VPWR w=1]]', 'g: [connection X0/g =>[signal: VGND w=1]]', 's: [connection X0/s =>[signal: VPWR w=1]]', 'b: [connection X0/b =>[signal: VPB w=1]]']]
X_XPHY_EDGE_ROW_2_Left_16_0 VPWR VGND VPWR VPWR sky130_fd_pr__pfet_01v8_hvt w=870000u l=590000u
** [instance X1 of sky130_fd_pr__nfet_01v8, params={'w': '550000u', 'l': '590000u'} connections=['d: [connection X1/d =>[signal: VGND w=1]]', 'g: [connection X1/g =>[signal: VPWR w=1]]', 's: [connection X1/s =>[signal: VGND w=1]]', 'b: [connection X1/b =>[signal: VNB w=1]]']]
X_XPHY_EDGE_ROW_2_Left_16_1 VGND VPWR VGND VGND sky130_fd_pr__nfet_01v8 w=550000u l=590000u

** replacing X_37_ with the contents of sky130_fd_sc_hd__mux2_1
** [instance X0 of sky130_fd_pr__pfet_01v8_hvt, params={'w': '420000u', 'l': '150000u'} connections=['d: [connection X0/d =>[signal: VPWR w=1]]', 'g: [connection X0/g =>[signal: S w=1]]', 's: [connection X0/s =>[signal: a_218_374# w=1]]', 'b: [connection X0/b =>[signal: VPB w=1]]']]
X_X_37__0 VPWR _37_/S X_37__a_218_374# VPWR sky130_fd_pr__pfet_01v8_hvt w=420000u l=150000u
** [instance X1 of sky130_fd_pr__nfet_01v8, params={'w': '420000u', 'l': '150000u'} connections=['d: [connection X1/d =>[signal: a_76_199# w=1]]', 'g: [connection X1/g =>[signal: A0 w=1]]', 's: [connection X1/s =>[signal: a_439_47# w=1]]', 'b: [connection X1/b =>[signal: VNB w=1]]']]
X_X_37__1 X_37__a_76_199# _35_/X X_37__a_439_47# VGND sky130_fd_pr__nfet_01v8 w=420000u l=150000u
** [instance X2 of sky130_fd_pr__pfet_01v8_hvt, params={'w': '420000u', 'l': '150000u'} connections=['d: [connection X2/d =>[signal: a_535_374# w=1]]', 'g: [connection X2/g =>[signal: a_505_21# w=1]]', 's: [connection X2/s =>[signal: VPWR w=1]]', 'b: [connection X2/b =>[signal: VPB w=1]]']]
X_X_37__2 X_37__a_535_374# X_37__a_505_21# VPWR VPWR sky130_fd_pr__pfet_01v8_hvt w=420000u l=150000u
** [instance X3 of sky130_fd_pr__pfet_01v8_hvt, params={'w': '420000u', 'l': '150000u'} connections=['d: [connection X3/d =>[signal: VPWR w=1]]', 'g: [connection X3/g =>[signal: S w=1]]', 's: [connection X3/s =>[signal: a_505_21# w=1]]', 'b: [connection X3/b =>[signal: VPB w=1]]']]
X_X_37__3 VPWR _37_/S X_37__a_505_21# VPWR sky130_fd_pr__pfet_01v8_hvt w=420000u l=150000u
** [instance X4 of sky130_fd_pr__pfet_01v8_hvt, params={'w': '420000u', 'l': '150000u'} connections=['d: [connection X4/d =>[signal: a_76_199# w=1]]', 'g: [connection X4/g =>[signal: A1 w=1]]', 's: [connection X4/s =>[signal: a_535_374# w=1]]', 'b: [connection X4/b =>[signal: VPB w=1]]']]
X_X_37__4 X_37__a_76_199# _36_/X X_37__a_535_374# VPWR sky130_fd_pr__pfet_01v8_hvt w=420000u l=150000u
** [instance X5 of sky130_fd_pr__nfet_01v8, params={'w': '420000u', 'l': '150000u'} connections=['d: [connection X5/d =>[signal: a_218_47# w=1]]', 'g: [connection X5/g =>[signal: A1 w=1]]', 's: [connection X5/s =>[signal: a_76_199# w=1]]', 'b: [connection X5/b =>[signal: VNB w=1]]']]
X_X_37__5 X_37__a_218_47# _36_/X X_37__a_76_199# VGND sky130_fd_pr__nfet_01v8 w=420000u l=150000u
** [instance X6 of sky130_fd_pr__pfet_01v8_hvt, params={'w': '420000u', 'l': '150000u'} connections=['d: [connection X6/d =>[signal: a_218_374# w=1]]', 'g: [connection X6/g =>[signal: A0 w=1]]', 's: [connection X6/s =>[signal: a_76_199# w=1]]', 'b: [connection X6/b =>[signal: VPB w=1]]']]
X_X_37__6 X_37__a_218_374# _35_/X X_37__a_76_199# VPWR sky130_fd_pr__pfet_01v8_hvt w=420000u l=150000u
** [instance X7 of sky130_fd_pr__nfet_01v8, params={'w': '650000u', 'l': '150000u'} connections=['d: [connection X7/d =>[signal: X w=1]]', 'g: [connection X7/g =>[signal: a_76_199# w=1]]', 's: [connection X7/s =>[signal: VGND w=1]]', 'b: [connection X7/b =>[signal: VNB w=1]]']]
X_X_37__7 _37_/X X_37__a_76_199# VGND VGND sky130_fd_pr__nfet_01v8 w=650000u l=150000u
** [instance X8 of sky130_fd_pr__pfet_01v8_hvt, params={'w': '1e+06u', 'l': '150000u'} connections=['d: [connection X8/d =>[signal: X w=1]]', 'g: [connection X8/g =>[signal: a_76_199# w=1]]', 's: [connection X8/s =>[signal: VPWR w=1]]', 'b: [connection X8/b =>[signal: VPB w=1]]']]
X_X_37__8 _37_/X X_37__a_76_199# VPWR VPWR sky130_fd_pr__pfet_01v8_hvt w=1e+06u l=150000u
** [instance X9 of sky130_fd_pr__nfet_01v8, params={'w': '420000u', 'l': '150000u'} connections=['d: [connection X9/d =>[signal: VGND w=1]]', 'g: [connection X9/g =>[signal: S w=1]]', 's: [connection X9/s =>[signal: a_218_47# w=1]]', 'b: [connection X9/b =>[signal: VNB w=1]]']]
X_X_37__9 VGND _37_/S X_37__a_218_47# VGND sky130_fd_pr__nfet_01v8 w=420000u l=150000u
** [instance X10 of sky130_fd_pr__nfet_01v8, params={'w': '420000u', 'l': '150000u'} connections=['d: [connection X10/d =>[signal: VGND w=1]]', 'g: [connection X10/g =>[signal: S w=1]]', 's: [connection X10/s =>[signal: a_505_21# w=1]]', 'b: [connection X10/b =>[signal: VNB w=1]]']]
X_X_37__10 VGND _37_/S X_37__a_505_21# VGND sky130_fd_pr__nfet_01v8 w=420000u l=150000u
** [instance X11 of sky130_fd_pr__nfet_01v8, params={'w': '420000u', 'l': '150000u'} connections=['d: [connection X11/d =>[signal: a_439_47# w=1]]', 'g: [connection X11/g =>[signal: a_505_21# w=1]]', 's: [connection X11/s =>[signal: VGND w=1]]', 'b: [connection X11/b =>[signal: VNB w=1]]']]
X_X_37__11 X_37__a_439_47# X_37__a_505_21# VGND VGND sky130_fd_pr__nfet_01v8 w=420000u l=150000u

** replacing X_70_ with the contents of sky130_fd_sc_hd__dfxtp_2
** [instance X0 of sky130_fd_pr__pfet_01v8_hvt, params={'w': '420000u', 'l': '150000u'} connections=['d: [connection X0/d =>[signal: a_891_413# w=1]]', 'g: [connection X0/g =>[signal: a_193_47# w=1]]', 's: [connection X0/s =>[signal: a_975_413# w=1]]', 'b: [connection X0/b =>[signal: VPB w=1]]']]
X_X_70__0 X_70__a_891_413# X_70__a_193_47# X_70__a_975_413# VPWR sky130_fd_pr__pfet_01v8_hvt w=420000u l=150000u
** [instance X1 of sky130_fd_pr__nfet_01v8, params={'w': '650000u', 'l': '150000u'} connections=['d: [connection X1/d =>[signal: a_1059_315# w=1]]', 'g: [connection X1/g =>[signal: a_891_413# w=1]]', 's: [connection X1/s =>[signal: VGND w=1]]', 'b: [connection X1/b =>[signal: VNB w=1]]']]
X_X_70__1 X_70__a_1059_315# X_70__a_891_413# VGND VGND sky130_fd_pr__nfet_01v8 w=650000u l=150000u
** [instance X2 of sky130_fd_pr__pfet_01v8_hvt, params={'w': '420000u', 'l': '150000u'} connections=['d: [connection X2/d =>[signal: a_466_413# w=1]]', 'g: [connection X2/g =>[signal: a_27_47# w=1]]', 's: [connection X2/s =>[signal: a_561_413# w=1]]', 'b: [connection X2/b =>[signal: VPB w=1]]']]
X_X_70__2 X_70__a_466_413# X_70__a_27_47# X_70__a_561_413# VPWR sky130_fd_pr__pfet_01v8_hvt w=420000u l=150000u
** [instance X3 of sky130_fd_pr__pfet_01v8_hvt, params={'w': '420000u', 'l': '150000u'} connections=['d: [connection X3/d =>[signal: a_634_159# w=1]]', 'g: [connection X3/g =>[signal: a_27_47# w=1]]', 's: [connection X3/s =>[signal: a_891_413# w=1]]', 'b: [connection X3/b =>[signal: VPB w=1]]']]
X_X_70__3 X_70__a_634_159# X_70__a_27_47# X_70__a_891_413# VPWR sky130_fd_pr__pfet_01v8_hvt w=420000u l=150000u
** [instance X4 of sky130_fd_pr__pfet_01v8_hvt, params={'w': '420000u', 'l': '150000u'} connections=['d: [connection X4/d =>[signal: a_381_47# w=1]]', 'g: [connection X4/g =>[signal: a_193_47# w=1]]', 's: [connection X4/s =>[signal: a_466_413# w=1]]', 'b: [connection X4/b =>[signal: VPB w=1]]']]
X_X_70__4 X_70__a_381_47# X_70__a_193_47# X_70__a_466_413# VPWR sky130_fd_pr__pfet_01v8_hvt w=420000u l=150000u
** [instance X5 of sky130_fd_pr__pfet_01v8_hvt, params={'w': '420000u', 'l': '150000u'} connections=['d: [connection X5/d =>[signal: VPWR w=1]]', 'g: [connection X5/g =>[signal: D w=1]]', 's: [connection X5/s =>[signal: a_381_47# w=1]]', 'b: [connection X5/b =>[signal: VPB w=1]]']]
X_X_70__5 VPWR _70_/D X_70__a_381_47# VPWR sky130_fd_pr__pfet_01v8_hvt w=420000u l=150000u
** [instance X6 of sky130_fd_pr__pfet_01v8_hvt, params={'w': '750000u', 'l': '150000u'} connections=['d: [connection X6/d =>[signal: VPWR w=1]]', 'g: [connection X6/g =>[signal: a_466_413# w=1]]', 's: [connection X6/s =>[signal: a_634_159# w=1]]', 'b: [connection X6/b =>[signal: VPB w=1]]']]
X_X_70__6 VPWR X_70__a_466_413# X_70__a_634_159# VPWR sky130_fd_pr__pfet_01v8_hvt w=750000u l=150000u
** [instance X7 of sky130_fd_pr__nfet_01v8, params={'w': '640000u', 'l': '150000u'} connections=['d: [connection X7/d =>[signal: VGND w=1]]', 'g: [connection X7/g =>[signal: a_466_413# w=1]]', 's: [connection X7/s =>[signal: a_634_159# w=1]]', 'b: [connection X7/b =>[signal: VNB w=1]]']]
X_X_70__7 VGND X_70__a_466_413# X_70__a_634_159# VGND sky130_fd_pr__nfet_01v8 w=640000u l=150000u
** [instance X8 of sky130_fd_pr__nfet_01v8, params={'w': '420000u', 'l': '150000u'} connections=['d: [connection X8/d =>[signal: a_1017_47# w=1]]', 'g: [connection X8/g =>[signal: a_1059_315# w=1]]', 's: [connection X8/s =>[signal: VGND w=1]]', 'b: [connection X8/b =>[signal: VNB w=1]]']]
X_X_70__8 X_70__a_1017_47# X_70__a_1059_315# VGND VGND sky130_fd_pr__nfet_01v8 w=420000u l=150000u
** [instance X9 of sky130_fd_pr__pfet_01v8_hvt, params={'w': '1e+06u', 'l': '150000u'} connections=['d: [connection X9/d =>[signal: a_1059_315# w=1]]', 'g: [connection X9/g =>[signal: a_891_413# w=1]]', 's: [connection X9/s =>[signal: VPWR w=1]]', 'b: [connection X9/b =>[signal: VPB w=1]]']]
X_X_70__9 X_70__a_1059_315# X_70__a_891_413# VPWR VPWR sky130_fd_pr__pfet_01v8_hvt w=1e+06u l=150000u
** [instance X10 of sky130_fd_pr__pfet_01v8_hvt, params={'w': '1e+06u', 'l': '150000u'} connections=['d: [connection X10/d =>[signal: Q w=1]]', 'g: [connection X10/g =>[signal: a_1059_315# w=1]]', 's: [connection X10/s =>[signal: VPWR w=1]]', 'b: [connection X10/b =>[signal: VPB w=1]]']]
X_X_70__10 _70_/Q X_70__a_1059_315# VPWR VPWR sky130_fd_pr__pfet_01v8_hvt w=1e+06u l=150000u
** [instance X11 of sky130_fd_pr__pfet_01v8_hvt, params={'w': '420000u', 'l': '150000u'} connections=['d: [connection X11/d =>[signal: a_561_413# w=1]]', 'g: [connection X11/g =>[signal: a_634_159# w=1]]', 's: [connection X11/s =>[signal: VPWR w=1]]', 'b: [connection X11/b =>[signal: VPB w=1]]']]
X_X_70__11 X_70__a_561_413# X_70__a_634_159# VPWR VPWR sky130_fd_pr__pfet_01v8_hvt w=420000u l=150000u
** [instance X12 of sky130_fd_pr__pfet_01v8_hvt, params={'w': '1e+06u', 'l': '150000u'} connections=['d: [connection X12/d =>[signal: VPWR w=1]]', 'g: [connection X12/g =>[signal: a_1059_315# w=1]]', 's: [connection X12/s =>[signal: Q w=1]]', 'b: [connection X12/b =>[signal: VPB w=1]]']]
X_X_70__12 VPWR X_70__a_1059_315# _70_/Q VPWR sky130_fd_pr__pfet_01v8_hvt w=1e+06u l=150000u
** [instance X13 of sky130_fd_pr__nfet_01v8, params={'w': '360000u', 'l': '150000u'} connections=['d: [connection X13/d =>[signal: a_891_413# w=1]]', 'g: [connection X13/g =>[signal: a_27_47# w=1]]', 's: [connection X13/s =>[signal: a_1017_47# w=1]]', 'b: [connection X13/b =>[signal: VNB w=1]]']]
X_X_70__13 X_70__a_891_413# X_70__a_27_47# X_70__a_1017_47# VGND sky130_fd_pr__nfet_01v8 w=360000u l=150000u
** [instance X14 of sky130_fd_pr__nfet_01v8, params={'w': '360000u', 'l': '150000u'} connections=['d: [connection X14/d =>[signal: a_634_159# w=1]]', 'g: [connection X14/g =>[signal: a_193_47# w=1]]', 's: [connection X14/s =>[signal: a_891_413# w=1]]', 'b: [connection X14/b =>[signal: VNB w=1]]']]
X_X_70__14 X_70__a_634_159# X_70__a_193_47# X_70__a_891_413# VGND sky130_fd_pr__nfet_01v8 w=360000u l=150000u
** [instance X15 of sky130_fd_pr__nfet_01v8, params={'w': '420000u', 'l': '150000u'} connections=['d: [connection X15/d =>[signal: a_592_47# w=1]]', 'g: [connection X15/g =>[signal: a_634_159# w=1]]', 's: [connection X15/s =>[signal: VGND w=1]]', 'b: [connection X15/b =>[signal: VNB w=1]]']]
X_X_70__15 X_70__a_592_47# X_70__a_634_159# VGND VGND sky130_fd_pr__nfet_01v8 w=420000u l=150000u
** [instance X16 of sky130_fd_pr__nfet_01v8, params={'w': '360000u', 'l': '150000u'} connections=['d: [connection X16/d =>[signal: a_466_413# w=1]]', 'g: [connection X16/g =>[signal: a_193_47# w=1]]', 's: [connection X16/s =>[signal: a_592_47# w=1]]', 'b: [connection X16/b =>[signal: VNB w=1]]']]
X_X_70__16 X_70__a_466_413# X_70__a_193_47# X_70__a_592_47# VGND sky130_fd_pr__nfet_01v8 w=360000u l=150000u
** [instance X17 of sky130_fd_pr__nfet_01v8, params={'w': '420000u', 'l': '150000u'} connections=['d: [connection X17/d =>[signal: VGND w=1]]', 'g: [connection X17/g =>[signal: a_27_47# w=1]]', 's: [connection X17/s =>[signal: a_193_47# w=1]]', 'b: [connection X17/b =>[signal: VNB w=1]]']]
X_X_70__17 VGND X_70__a_27_47# X_70__a_193_47# VGND sky130_fd_pr__nfet_01v8 w=420000u l=150000u
** [instance X18 of sky130_fd_pr__nfet_01v8, params={'w': '360000u', 'l': '150000u'} connections=['d: [connection X18/d =>[signal: a_381_47# w=1]]', 'g: [connection X18/g =>[signal: a_27_47# w=1]]', 's: [connection X18/s =>[signal: a_466_413# w=1]]', 'b: [connection X18/b =>[signal: VNB w=1]]']]
X_X_70__18 X_70__a_381_47# X_70__a_27_47# X_70__a_466_413# VGND sky130_fd_pr__nfet_01v8 w=360000u l=150000u
** [instance X19 of sky130_fd_pr__nfet_01v8, params={'w': '420000u', 'l': '150000u'} connections=['d: [connection X19/d =>[signal: a_27_47# w=1]]', 'g: [connection X19/g =>[signal: CLK w=1]]', 's: [connection X19/s =>[signal: VGND w=1]]', 'b: [connection X19/b =>[signal: VNB w=1]]']]
X_X_70__19 X_70__a_27_47# _71_/CLK VGND VGND sky130_fd_pr__nfet_01v8 w=420000u l=150000u
** [instance X20 of sky130_fd_pr__pfet_01v8_hvt, params={'w': '640000u', 'l': '150000u'} connections=['d: [connection X20/d =>[signal: a_27_47# w=1]]', 'g: [connection X20/g =>[signal: CLK w=1]]', 's: [connection X20/s =>[signal: VPWR w=1]]', 'b: [connection X20/b =>[signal: VPB w=1]]']]
X_X_70__20 X_70__a_27_47# _71_/CLK VPWR VPWR sky130_fd_pr__pfet_01v8_hvt w=640000u l=150000u
** [instance X21 of sky130_fd_pr__nfet_01v8, params={'w': '650000u', 'l': '150000u'} connections=['d: [connection X21/d =>[signal: Q w=1]]', 'g: [connection X21/g =>[signal: a_1059_315# w=1]]', 's: [connection X21/s =>[signal: VGND w=1]]', 'b: [connection X21/b =>[signal: VNB w=1]]']]
X_X_70__21 _70_/Q X_70__a_1059_315# VGND VGND sky130_fd_pr__nfet_01v8 w=650000u l=150000u
** [instance X22 of sky130_fd_pr__pfet_01v8_hvt, params={'w': '640000u', 'l': '150000u'} connections=['d: [connection X22/d =>[signal: VPWR w=1]]', 'g: [connection X22/g =>[signal: a_27_47# w=1]]', 's: [connection X22/s =>[signal: a_193_47# w=1]]', 'b: [connection X22/b =>[signal: VPB w=1]]']]
X_X_70__22 VPWR X_70__a_27_47# X_70__a_193_47# VPWR sky130_fd_pr__pfet_01v8_hvt w=640000u l=150000u
** [instance X23 of sky130_fd_pr__nfet_01v8, params={'w': '420000u', 'l': '150000u'} connections=['d: [connection X23/d =>[signal: VGND w=1]]', 'g: [connection X23/g =>[signal: D w=1]]', 's: [connection X23/s =>[signal: a_381_47# w=1]]', 'b: [connection X23/b =>[signal: VNB w=1]]']]
X_X_70__23 VGND _70_/D X_70__a_381_47# VGND sky130_fd_pr__nfet_01v8 w=420000u l=150000u
** [instance X24 of sky130_fd_pr__pfet_01v8_hvt, params={'w': '420000u', 'l': '150000u'} connections=['d: [connection X24/d =>[signal: a_975_413# w=1]]', 'g: [connection X24/g =>[signal: a_1059_315# w=1]]', 's: [connection X24/s =>[signal: VPWR w=1]]', 'b: [connection X24/b =>[signal: VPB w=1]]']]
X_X_70__24 X_70__a_975_413# X_70__a_1059_315# VPWR VPWR sky130_fd_pr__pfet_01v8_hvt w=420000u l=150000u
** [instance X25 of sky130_fd_pr__nfet_01v8, params={'w': '650000u', 'l': '150000u'} connections=['d: [connection X25/d =>[signal: VGND w=1]]', 'g: [connection X25/g =>[signal: a_1059_315# w=1]]', 's: [connection X25/s =>[signal: Q w=1]]', 'b: [connection X25/b =>[signal: VNB w=1]]']]
X_X_70__25 VGND X_70__a_1059_315# _70_/Q VGND sky130_fd_pr__nfet_01v8 w=650000u l=150000u

** replacing XFILLER_5_54 with the contents of sky130_fd_sc_hd__fill_2

** replacing XFILLER_11_31 with the contents of sky130_fd_sc_hd__decap_3
** [instance X0 of sky130_fd_pr__pfet_01v8_hvt, params={'w': '870000u', 'l': '590000u'} connections=['d: [connection X0/d =>[signal: VPWR w=1]]', 'g: [connection X0/g =>[signal: VGND w=1]]', 's: [connection X0/s =>[signal: VPWR w=1]]', 'b: [connection X0/b =>[signal: VPB w=1]]']]
X_XFILLER_11_31_0 VPWR VGND VPWR VPWR sky130_fd_pr__pfet_01v8_hvt w=870000u l=590000u
** [instance X1 of sky130_fd_pr__nfet_01v8, params={'w': '550000u', 'l': '590000u'} connections=['d: [connection X1/d =>[signal: VGND w=1]]', 'g: [connection X1/g =>[signal: VPWR w=1]]', 's: [connection X1/s =>[signal: VGND w=1]]', 'b: [connection X1/b =>[signal: VNB w=1]]']]
X_XFILLER_11_31_1 VGND VPWR VGND VGND sky130_fd_pr__nfet_01v8 w=550000u l=590000u

** replacing X_53_ with the contents of sky130_fd_sc_hd__mux2_1
** [instance X0 of sky130_fd_pr__pfet_01v8_hvt, params={'w': '420000u', 'l': '150000u'} connections=['d: [connection X0/d =>[signal: VPWR w=1]]', 'g: [connection X0/g =>[signal: S w=1]]', 's: [connection X0/s =>[signal: a_218_374# w=1]]', 'b: [connection X0/b =>[signal: VPB w=1]]']]
X_X_53__0 VPWR _53_/S X_53__a_218_374# VPWR sky130_fd_pr__pfet_01v8_hvt w=420000u l=150000u
** [instance X1 of sky130_fd_pr__nfet_01v8, params={'w': '420000u', 'l': '150000u'} connections=['d: [connection X1/d =>[signal: a_76_199# w=1]]', 'g: [connection X1/g =>[signal: A0 w=1]]', 's: [connection X1/s =>[signal: a_439_47# w=1]]', 'b: [connection X1/b =>[signal: VNB w=1]]']]
X_X_53__1 X_53__a_76_199# _53_/A0 X_53__a_439_47# VGND sky130_fd_pr__nfet_01v8 w=420000u l=150000u
** [instance X2 of sky130_fd_pr__pfet_01v8_hvt, params={'w': '420000u', 'l': '150000u'} connections=['d: [connection X2/d =>[signal: a_535_374# w=1]]', 'g: [connection X2/g =>[signal: a_505_21# w=1]]', 's: [connection X2/s =>[signal: VPWR w=1]]', 'b: [connection X2/b =>[signal: VPB w=1]]']]
X_X_53__2 X_53__a_535_374# X_53__a_505_21# VPWR VPWR sky130_fd_pr__pfet_01v8_hvt w=420000u l=150000u
** [instance X3 of sky130_fd_pr__pfet_01v8_hvt, params={'w': '420000u', 'l': '150000u'} connections=['d: [connection X3/d =>[signal: VPWR w=1]]', 'g: [connection X3/g =>[signal: S w=1]]', 's: [connection X3/s =>[signal: a_505_21# w=1]]', 'b: [connection X3/b =>[signal: VPB w=1]]']]
X_X_53__3 VPWR _53_/S X_53__a_505_21# VPWR sky130_fd_pr__pfet_01v8_hvt w=420000u l=150000u
** [instance X4 of sky130_fd_pr__pfet_01v8_hvt, params={'w': '420000u', 'l': '150000u'} connections=['d: [connection X4/d =>[signal: a_76_199# w=1]]', 'g: [connection X4/g =>[signal: A1 w=1]]', 's: [connection X4/s =>[signal: a_535_374# w=1]]', 'b: [connection X4/b =>[signal: VPB w=1]]']]
X_X_53__4 X_53__a_76_199# _54_/A0 X_53__a_535_374# VPWR sky130_fd_pr__pfet_01v8_hvt w=420000u l=150000u
** [instance X5 of sky130_fd_pr__nfet_01v8, params={'w': '420000u', 'l': '150000u'} connections=['d: [connection X5/d =>[signal: a_218_47# w=1]]', 'g: [connection X5/g =>[signal: A1 w=1]]', 's: [connection X5/s =>[signal: a_76_199# w=1]]', 'b: [connection X5/b =>[signal: VNB w=1]]']]
X_X_53__5 X_53__a_218_47# _54_/A0 X_53__a_76_199# VGND sky130_fd_pr__nfet_01v8 w=420000u l=150000u
** [instance X6 of sky130_fd_pr__pfet_01v8_hvt, params={'w': '420000u', 'l': '150000u'} connections=['d: [connection X6/d =>[signal: a_218_374# w=1]]', 'g: [connection X6/g =>[signal: A0 w=1]]', 's: [connection X6/s =>[signal: a_76_199# w=1]]', 'b: [connection X6/b =>[signal: VPB w=1]]']]
X_X_53__6 X_53__a_218_374# _53_/A0 X_53__a_76_199# VPWR sky130_fd_pr__pfet_01v8_hvt w=420000u l=150000u
** [instance X7 of sky130_fd_pr__nfet_01v8, params={'w': '650000u', 'l': '150000u'} connections=['d: [connection X7/d =>[signal: X w=1]]', 'g: [connection X7/g =>[signal: a_76_199# w=1]]', 's: [connection X7/s =>[signal: VGND w=1]]', 'b: [connection X7/b =>[signal: VNB w=1]]']]
X_X_53__7 _71_/D X_53__a_76_199# VGND VGND sky130_fd_pr__nfet_01v8 w=650000u l=150000u
** [instance X8 of sky130_fd_pr__pfet_01v8_hvt, params={'w': '1e+06u', 'l': '150000u'} connections=['d: [connection X8/d =>[signal: X w=1]]', 'g: [connection X8/g =>[signal: a_76_199# w=1]]', 's: [connection X8/s =>[signal: VPWR w=1]]', 'b: [connection X8/b =>[signal: VPB w=1]]']]
X_X_53__8 _71_/D X_53__a_76_199# VPWR VPWR sky130_fd_pr__pfet_01v8_hvt w=1e+06u l=150000u
** [instance X9 of sky130_fd_pr__nfet_01v8, params={'w': '420000u', 'l': '150000u'} connections=['d: [connection X9/d =>[signal: VGND w=1]]', 'g: [connection X9/g =>[signal: S w=1]]', 's: [connection X9/s =>[signal: a_218_47# w=1]]', 'b: [connection X9/b =>[signal: VNB w=1]]']]
X_X_53__9 VGND _53_/S X_53__a_218_47# VGND sky130_fd_pr__nfet_01v8 w=420000u l=150000u
** [instance X10 of sky130_fd_pr__nfet_01v8, params={'w': '420000u', 'l': '150000u'} connections=['d: [connection X10/d =>[signal: VGND w=1]]', 'g: [connection X10/g =>[signal: S w=1]]', 's: [connection X10/s =>[signal: a_505_21# w=1]]', 'b: [connection X10/b =>[signal: VNB w=1]]']]
X_X_53__10 VGND _53_/S X_53__a_505_21# VGND sky130_fd_pr__nfet_01v8 w=420000u l=150000u
** [instance X11 of sky130_fd_pr__nfet_01v8, params={'w': '420000u', 'l': '150000u'} connections=['d: [connection X11/d =>[signal: a_439_47# w=1]]', 'g: [connection X11/g =>[signal: a_505_21# w=1]]', 's: [connection X11/s =>[signal: VGND w=1]]', 'b: [connection X11/b =>[signal: VNB w=1]]']]
X_X_53__11 X_53__a_439_47# X_53__a_505_21# VGND VGND sky130_fd_pr__nfet_01v8 w=420000u l=150000u

** replacing X_36_ with the contents of sky130_fd_sc_hd__mux4_2
** [instance X0 of sky130_fd_pr__pfet_01v8_hvt, params={'w': '640000u', 'l': '150000u'} connections=['d: [connection X0/d =>[signal: VPWR w=1]]', 'g: [connection X0/g =>[signal: A1 w=1]]', 's: [connection X0/s =>[signal: a_1060_369# w=1]]', 'b: [connection X0/b =>[signal: VPB w=1]]']]
X_X_36__0 VPWR _69_/Q X_36__a_1060_369# VPWR sky130_fd_pr__pfet_01v8_hvt w=640000u l=150000u
** [instance X1 of sky130_fd_pr__nfet_01v8, params={'w': '360000u', 'l': '150000u'} connections=['d: [connection X1/d =>[signal: a_193_47# w=1]]', 'g: [connection X1/g =>[signal: a_27_47# w=1]]', 's: [connection X1/s =>[signal: a_288_47# w=1]]', 'b: [connection X1/b =>[signal: VNB w=1]]']]
X_X_36__1 X_36__a_193_47# X_36__a_27_47# X_36__a_288_47# VGND sky130_fd_pr__nfet_01v8 w=360000u l=150000u
** [instance X2 of sky130_fd_pr__pfet_01v8_hvt, params={'w': '1e+06u', 'l': '150000u'} connections=['d: [connection X2/d =>[signal: VPWR w=1]]', 'g: [connection X2/g =>[signal: a_788_316# w=1]]', 's: [connection X2/s =>[signal: X w=1]]', 'b: [connection X2/b =>[signal: VPB w=1]]']]
X_X_36__2 VPWR X_36__a_788_316# _36_/X VPWR sky130_fd_pr__pfet_01v8_hvt w=1e+06u l=150000u
** [instance X3 of sky130_fd_pr__pfet_01v8_hvt, params={'w': '640000u', 'l': '150000u'} connections=['d: [connection X3/d =>[signal: a_1279_413# w=1]]', 'g: [connection X3/g =>[signal: A0 w=1]]', 's: [connection X3/s =>[signal: VPWR w=1]]', 'b: [connection X3/b =>[signal: VPB w=1]]']]
X_X_36__3 X_36__a_1279_413# _70_/Q VPWR VPWR sky130_fd_pr__pfet_01v8_hvt w=640000u l=150000u
** [instance X4 of sky130_fd_pr__nfet_01v8, params={'w': '650000u', 'l': '150000u'} connections=['d: [connection X4/d =>[signal: VGND w=1]]', 'g: [connection X4/g =>[signal: a_788_316# w=1]]', 's: [connection X4/s =>[signal: X w=1]]', 'b: [connection X4/b =>[signal: VNB w=1]]']]
X_X_36__4 VGND X_36__a_788_316# _36_/X VGND sky130_fd_pr__nfet_01v8 w=650000u l=150000u
** [instance X5 of sky130_fd_pr__pfet_01v8_hvt, params={'w': '1e+06u', 'l': '150000u'} connections=['d: [connection X5/d =>[signal: X w=1]]', 'g: [connection X5/g =>[signal: a_788_316# w=1]]', 's: [connection X5/s =>[signal: VPWR w=1]]', 'b: [connection X5/b =>[signal: VPB w=1]]']]
X_X_36__5 _36_/X X_36__a_788_316# VPWR VPWR sky130_fd_pr__pfet_01v8_hvt w=1e+06u l=150000u
** [instance X6 of sky130_fd_pr__nfet_01v8, params={'w': '420000u', 'l': '150000u'} connections=['d: [connection X6/d =>[signal: a_288_47# w=1]]', 'g: [connection X6/g =>[signal: S1 w=1]]', 's: [connection X6/s =>[signal: a_788_316# w=1]]', 'b: [connection X6/b =>[signal: VNB w=1]]']]
X_X_36__6 X_36__a_288_47# _36_/S1 X_36__a_788_316# VGND sky130_fd_pr__nfet_01v8 w=420000u l=150000u
** [instance X7 of sky130_fd_pr__pfet_01v8_hvt, params={'w': '420000u', 'l': '150000u'} connections=['d: [connection X7/d =>[signal: a_193_369# w=1]]', 'g: [connection X7/g =>[signal: S0 w=1]]', 's: [connection X7/s =>[signal: a_288_47# w=1]]', 'b: [connection X7/b =>[signal: VPB w=1]]']]
X_X_36__7 X_36__a_193_369# _36_/S0 X_36__a_288_47# VPWR sky130_fd_pr__pfet_01v8_hvt w=420000u l=150000u
** [instance X8 of sky130_fd_pr__pfet_01v8_hvt, params={'w': '640000u', 'l': '150000u'} connections=['d: [connection X8/d =>[signal: a_372_413# w=1]]', 'g: [connection X8/g =>[signal: A3 w=1]]', 's: [connection X8/s =>[signal: VPWR w=1]]', 'b: [connection X8/b =>[signal: VPB w=1]]']]
X_X_36__8 X_36__a_372_413# _67_/Q VPWR VPWR sky130_fd_pr__pfet_01v8_hvt w=640000u l=150000u
** [instance X9 of sky130_fd_pr__nfet_01v8, params={'w': '360000u', 'l': '150000u'} connections=['d: [connection X9/d =>[signal: a_872_316# w=1]]', 'g: [connection X9/g =>[signal: a_27_47# w=1]]', 's: [connection X9/s =>[signal: a_1281_47# w=1]]', 'b: [connection X9/b =>[signal: VNB w=1]]']]
X_X_36__9 X_36__a_872_316# X_36__a_27_47# X_36__a_1281_47# VGND sky130_fd_pr__nfet_01v8 w=360000u l=150000u
** [instance X10 of sky130_fd_pr__pfet_01v8_hvt, params={'w': '420000u', 'l': '150000u'} connections=['d: [connection X10/d =>[signal: a_288_47# w=1]]', 'g: [connection X10/g =>[signal: a_27_47# w=1]]', 's: [connection X10/s =>[signal: a_372_413# w=1]]', 'b: [connection X10/b =>[signal: VPB w=1]]']]
X_X_36__10 X_36__a_288_47# X_36__a_27_47# X_36__a_372_413# VPWR sky130_fd_pr__pfet_01v8_hvt w=420000u l=150000u
** [instance X11 of sky130_fd_pr__nfet_01v8, params={'w': '420000u', 'l': '150000u'} connections=['d: [connection X11/d =>[signal: VGND w=1]]', 'g: [connection X11/g =>[signal: A1 w=1]]', 's: [connection X11/s =>[signal: a_1064_47# w=1]]', 'b: [connection X11/b =>[signal: VNB w=1]]']]
X_X_36__11 VGND _69_/Q X_36__a_1064_47# VGND sky130_fd_pr__nfet_01v8 w=420000u l=150000u
** [instance X12 of sky130_fd_pr__pfet_01v8_hvt, params={'w': '640000u', 'l': '150000u'} connections=['d: [connection X12/d =>[signal: VPWR w=1]]', 'g: [connection X12/g =>[signal: S1 w=1]]', 's: [connection X12/s =>[signal: a_600_345# w=1]]', 'b: [connection X12/b =>[signal: VPB w=1]]']]
X_X_36__12 VPWR _36_/S1 X_36__a_600_345# VPWR sky130_fd_pr__pfet_01v8_hvt w=640000u l=150000u
** [instance X13 of sky130_fd_pr__pfet_01v8_hvt, params={'w': '420000u', 'l': '150000u'} connections=['d: [connection X13/d =>[signal: a_872_316# w=1]]', 'g: [connection X13/g =>[signal: S0 w=1]]', 's: [connection X13/s =>[signal: a_1279_413# w=1]]', 'b: [connection X13/b =>[signal: VPB w=1]]']]
X_X_36__13 X_36__a_872_316# _36_/S0 X_36__a_1279_413# VPWR sky130_fd_pr__pfet_01v8_hvt w=420000u l=150000u
** [instance X14 of sky130_fd_pr__pfet_01v8_hvt, params={'w': '640000u', 'l': '150000u'} connections=['d: [connection X14/d =>[signal: a_27_47# w=1]]', 'g: [connection X14/g =>[signal: S0 w=1]]', 's: [connection X14/s =>[signal: VPWR w=1]]', 'b: [connection X14/b =>[signal: VPB w=1]]']]
X_X_36__14 X_36__a_27_47# _36_/S0 VPWR VPWR sky130_fd_pr__pfet_01v8_hvt w=640000u l=150000u
** [instance X15 of sky130_fd_pr__pfet_01v8_hvt, params={'w': '640000u', 'l': '150000u'} connections=['d: [connection X15/d =>[signal: VPWR w=1]]', 'g: [connection X15/g =>[signal: A2 w=1]]', 's: [connection X15/s =>[signal: a_193_369# w=1]]', 'b: [connection X15/b =>[signal: VPB w=1]]']]
X_X_36__15 VPWR _68_/Q X_36__a_193_369# VPWR sky130_fd_pr__pfet_01v8_hvt w=640000u l=150000u
** [instance X16 of sky130_fd_pr__nfet_01v8, params={'w': '420000u', 'l': '150000u'} connections=['d: [connection X16/d =>[signal: VGND w=1]]', 'g: [connection X16/g =>[signal: A2 w=1]]', 's: [connection X16/s =>[signal: a_193_47# w=1]]', 'b: [connection X16/b =>[signal: VNB w=1]]']]
X_X_36__16 VGND _68_/Q X_36__a_193_47# VGND sky130_fd_pr__nfet_01v8 w=420000u l=150000u
** [instance X17 of sky130_fd_pr__pfet_01v8_hvt, params={'w': '540000u', 'l': '150000u'} connections=['d: [connection X17/d =>[signal: a_288_47# w=1]]', 'g: [connection X17/g =>[signal: a_600_345# w=1]]', 's: [connection X17/s =>[signal: a_788_316# w=1]]', 'b: [connection X17/b =>[signal: VPB w=1]]']]
X_X_36__17 X_36__a_288_47# X_36__a_600_345# X_36__a_788_316# VPWR sky130_fd_pr__pfet_01v8_hvt w=540000u l=150000u
** [instance X18 of sky130_fd_pr__nfet_01v8, params={'w': '420000u', 'l': '150000u'} connections=['d: [connection X18/d =>[signal: a_397_47# w=1]]', 'g: [connection X18/g =>[signal: A3 w=1]]', 's: [connection X18/s =>[signal: VGND w=1]]', 'b: [connection X18/b =>[signal: VNB w=1]]']]
X_X_36__18 X_36__a_397_47# _67_/Q VGND VGND sky130_fd_pr__nfet_01v8 w=420000u l=150000u
** [instance X19 of sky130_fd_pr__nfet_01v8, params={'w': '420000u', 'l': '150000u'} connections=['d: [connection X19/d =>[signal: a_27_47# w=1]]', 'g: [connection X19/g =>[signal: S0 w=1]]', 's: [connection X19/s =>[signal: VGND w=1]]', 'b: [connection X19/b =>[signal: VNB w=1]]']]
X_X_36__19 X_36__a_27_47# _36_/S0 VGND VGND sky130_fd_pr__nfet_01v8 w=420000u l=150000u
** [instance X20 of sky130_fd_pr__pfet_01v8_hvt, params={'w': '420000u', 'l': '150000u'} connections=['d: [connection X20/d =>[signal: a_1060_369# w=1]]', 'g: [connection X20/g =>[signal: a_27_47# w=1]]', 's: [connection X20/s =>[signal: a_872_316# w=1]]', 'b: [connection X20/b =>[signal: VPB w=1]]']]
X_X_36__20 X_36__a_1060_369# X_36__a_27_47# X_36__a_872_316# VPWR sky130_fd_pr__pfet_01v8_hvt w=420000u l=150000u
** [instance X21 of sky130_fd_pr__nfet_01v8, params={'w': '420000u', 'l': '150000u'} connections=['d: [connection X21/d =>[signal: VGND w=1]]', 'g: [connection X21/g =>[signal: S1 w=1]]', 's: [connection X21/s =>[signal: a_600_345# w=1]]', 'b: [connection X21/b =>[signal: VNB w=1]]']]
X_X_36__21 VGND _36_/S1 X_36__a_600_345# VGND sky130_fd_pr__nfet_01v8 w=420000u l=150000u
** [instance X22 of sky130_fd_pr__nfet_01v8, params={'w': '420000u', 'l': '150000u'} connections=['d: [connection X22/d =>[signal: a_1281_47# w=1]]', 'g: [connection X22/g =>[signal: A0 w=1]]', 's: [connection X22/s =>[signal: VGND w=1]]', 'b: [connection X22/b =>[signal: VNB w=1]]']]
X_X_36__22 X_36__a_1281_47# _70_/Q VGND VGND sky130_fd_pr__nfet_01v8 w=420000u l=150000u
** [instance X23 of sky130_fd_pr__nfet_01v8, params={'w': '650000u', 'l': '150000u'} connections=['d: [connection X23/d =>[signal: X w=1]]', 'g: [connection X23/g =>[signal: a_788_316# w=1]]', 's: [connection X23/s =>[signal: VGND w=1]]', 'b: [connection X23/b =>[signal: VNB w=1]]']]
X_X_36__23 _36_/X X_36__a_788_316# VGND VGND sky130_fd_pr__nfet_01v8 w=650000u l=150000u
** [instance X24 of sky130_fd_pr__nfet_01v8, params={'w': '360000u', 'l': '150000u'} connections=['d: [connection X24/d =>[signal: a_288_47# w=1]]', 'g: [connection X24/g =>[signal: S0 w=1]]', 's: [connection X24/s =>[signal: a_397_47# w=1]]', 'b: [connection X24/b =>[signal: VNB w=1]]']]
X_X_36__24 X_36__a_288_47# _36_/S0 X_36__a_397_47# VGND sky130_fd_pr__nfet_01v8 w=360000u l=150000u
** [instance X25 of sky130_fd_pr__pfet_01v8_hvt, params={'w': '540000u', 'l': '150000u'} connections=['d: [connection X25/d =>[signal: a_788_316# w=1]]', 'g: [connection X25/g =>[signal: S1 w=1]]', 's: [connection X25/s =>[signal: a_872_316# w=1]]', 'b: [connection X25/b =>[signal: VPB w=1]]']]
X_X_36__25 X_36__a_788_316# _36_/S1 X_36__a_872_316# VPWR sky130_fd_pr__pfet_01v8_hvt w=540000u l=150000u
** [instance X26 of sky130_fd_pr__nfet_01v8, params={'w': '420000u', 'l': '150000u'} connections=['d: [connection X26/d =>[signal: a_788_316# w=1]]', 'g: [connection X26/g =>[signal: a_600_345# w=1]]', 's: [connection X26/s =>[signal: a_872_316# w=1]]', 'b: [connection X26/b =>[signal: VNB w=1]]']]
X_X_36__26 X_36__a_788_316# X_36__a_600_345# X_36__a_872_316# VGND sky130_fd_pr__nfet_01v8 w=420000u l=150000u
** [instance X27 of sky130_fd_pr__nfet_01v8, params={'w': '360000u', 'l': '150000u'} connections=['d: [connection X27/d =>[signal: a_1064_47# w=1]]', 'g: [connection X27/g =>[signal: S0 w=1]]', 's: [connection X27/s =>[signal: a_872_316# w=1]]', 'b: [connection X27/b =>[signal: VNB w=1]]']]
X_X_36__27 X_36__a_1064_47# _36_/S0 X_36__a_872_316# VGND sky130_fd_pr__nfet_01v8 w=360000u l=150000u

** replacing XFILLER_10_3 with the contents of sky130_fd_sc_hd__decap_3
** [instance X0 of sky130_fd_pr__pfet_01v8_hvt, params={'w': '870000u', 'l': '590000u'} connections=['d: [connection X0/d =>[signal: VPWR w=1]]', 'g: [connection X0/g =>[signal: VGND w=1]]', 's: [connection X0/s =>[signal: VPWR w=1]]', 'b: [connection X0/b =>[signal: VPB w=1]]']]
X_XFILLER_10_3_0 VPWR VGND VPWR VPWR sky130_fd_pr__pfet_01v8_hvt w=870000u l=590000u
** [instance X1 of sky130_fd_pr__nfet_01v8, params={'w': '550000u', 'l': '590000u'} connections=['d: [connection X1/d =>[signal: VGND w=1]]', 'g: [connection X1/g =>[signal: VPWR w=1]]', 's: [connection X1/s =>[signal: VGND w=1]]', 'b: [connection X1/b =>[signal: VNB w=1]]']]
X_XFILLER_10_3_1 VGND VPWR VGND VGND sky130_fd_pr__nfet_01v8 w=550000u l=590000u

** replacing XTAP_TAPCELL_ROW_4_33 with the contents of sky130_fd_sc_hd__tapvpwrvgnd_1

** replacing XFILLER_5_77 with the contents of sky130_fd_sc_hd__decap_3
** [instance X0 of sky130_fd_pr__pfet_01v8_hvt, params={'w': '870000u', 'l': '590000u'} connections=['d: [connection X0/d =>[signal: VPWR w=1]]', 'g: [connection X0/g =>[signal: VGND w=1]]', 's: [connection X0/s =>[signal: VPWR w=1]]', 'b: [connection X0/b =>[signal: VPB w=1]]']]
X_XFILLER_5_77_0 VPWR VGND VPWR VPWR sky130_fd_pr__pfet_01v8_hvt w=870000u l=590000u
** [instance X1 of sky130_fd_pr__nfet_01v8, params={'w': '550000u', 'l': '590000u'} connections=['d: [connection X1/d =>[signal: VGND w=1]]', 'g: [connection X1/g =>[signal: VPWR w=1]]', 's: [connection X1/s =>[signal: VGND w=1]]', 'b: [connection X1/b =>[signal: VNB w=1]]']]
X_XFILLER_5_77_1 VGND VPWR VGND VGND sky130_fd_pr__nfet_01v8 w=550000u l=590000u

** replacing X_52_ with the contents of sky130_fd_sc_hd__mux2_1
** [instance X0 of sky130_fd_pr__pfet_01v8_hvt, params={'w': '420000u', 'l': '150000u'} connections=['d: [connection X0/d =>[signal: VPWR w=1]]', 'g: [connection X0/g =>[signal: S w=1]]', 's: [connection X0/s =>[signal: a_218_374# w=1]]', 'b: [connection X0/b =>[signal: VPB w=1]]']]
X_X_52__0 VPWR _53_/S X_52__a_218_374# VPWR sky130_fd_pr__pfet_01v8_hvt w=420000u l=150000u
** [instance X1 of sky130_fd_pr__nfet_01v8, params={'w': '420000u', 'l': '150000u'} connections=['d: [connection X1/d =>[signal: a_76_199# w=1]]', 'g: [connection X1/g =>[signal: A0 w=1]]', 's: [connection X1/s =>[signal: a_439_47# w=1]]', 'b: [connection X1/b =>[signal: VNB w=1]]']]
X_X_52__1 X_52__a_76_199# _52_/A0 X_52__a_439_47# VGND sky130_fd_pr__nfet_01v8 w=420000u l=150000u
** [instance X2 of sky130_fd_pr__pfet_01v8_hvt, params={'w': '420000u', 'l': '150000u'} connections=['d: [connection X2/d =>[signal: a_535_374# w=1]]', 'g: [connection X2/g =>[signal: a_505_21# w=1]]', 's: [connection X2/s =>[signal: VPWR w=1]]', 'b: [connection X2/b =>[signal: VPB w=1]]']]
X_X_52__2 X_52__a_535_374# X_52__a_505_21# VPWR VPWR sky130_fd_pr__pfet_01v8_hvt w=420000u l=150000u
** [instance X3 of sky130_fd_pr__pfet_01v8_hvt, params={'w': '420000u', 'l': '150000u'} connections=['d: [connection X3/d =>[signal: VPWR w=1]]', 'g: [connection X3/g =>[signal: S w=1]]', 's: [connection X3/s =>[signal: a_505_21# w=1]]', 'b: [connection X3/b =>[signal: VPB w=1]]']]
X_X_52__3 VPWR _53_/S X_52__a_505_21# VPWR sky130_fd_pr__pfet_01v8_hvt w=420000u l=150000u
** [instance X4 of sky130_fd_pr__pfet_01v8_hvt, params={'w': '420000u', 'l': '150000u'} connections=['d: [connection X4/d =>[signal: a_76_199# w=1]]', 'g: [connection X4/g =>[signal: A1 w=1]]', 's: [connection X4/s =>[signal: a_535_374# w=1]]', 'b: [connection X4/b =>[signal: VPB w=1]]']]
X_X_52__4 X_52__a_76_199# _71_/Q X_52__a_535_374# VPWR sky130_fd_pr__pfet_01v8_hvt w=420000u l=150000u
** [instance X5 of sky130_fd_pr__nfet_01v8, params={'w': '420000u', 'l': '150000u'} connections=['d: [connection X5/d =>[signal: a_218_47# w=1]]', 'g: [connection X5/g =>[signal: A1 w=1]]', 's: [connection X5/s =>[signal: a_76_199# w=1]]', 'b: [connection X5/b =>[signal: VNB w=1]]']]
X_X_52__5 X_52__a_218_47# _71_/Q X_52__a_76_199# VGND sky130_fd_pr__nfet_01v8 w=420000u l=150000u
** [instance X6 of sky130_fd_pr__pfet_01v8_hvt, params={'w': '420000u', 'l': '150000u'} connections=['d: [connection X6/d =>[signal: a_218_374# w=1]]', 'g: [connection X6/g =>[signal: A0 w=1]]', 's: [connection X6/s =>[signal: a_76_199# w=1]]', 'b: [connection X6/b =>[signal: VPB w=1]]']]
X_X_52__6 X_52__a_218_374# _52_/A0 X_52__a_76_199# VPWR sky130_fd_pr__pfet_01v8_hvt w=420000u l=150000u
** [instance X7 of sky130_fd_pr__nfet_01v8, params={'w': '650000u', 'l': '150000u'} connections=['d: [connection X7/d =>[signal: X w=1]]', 'g: [connection X7/g =>[signal: a_76_199# w=1]]', 's: [connection X7/s =>[signal: VGND w=1]]', 'b: [connection X7/b =>[signal: VNB w=1]]']]
X_X_52__7 _52_/X X_52__a_76_199# VGND VGND sky130_fd_pr__nfet_01v8 w=650000u l=150000u
** [instance X8 of sky130_fd_pr__pfet_01v8_hvt, params={'w': '1e+06u', 'l': '150000u'} connections=['d: [connection X8/d =>[signal: X w=1]]', 'g: [connection X8/g =>[signal: a_76_199# w=1]]', 's: [connection X8/s =>[signal: VPWR w=1]]', 'b: [connection X8/b =>[signal: VPB w=1]]']]
X_X_52__8 _52_/X X_52__a_76_199# VPWR VPWR sky130_fd_pr__pfet_01v8_hvt w=1e+06u l=150000u
** [instance X9 of sky130_fd_pr__nfet_01v8, params={'w': '420000u', 'l': '150000u'} connections=['d: [connection X9/d =>[signal: VGND w=1]]', 'g: [connection X9/g =>[signal: S w=1]]', 's: [connection X9/s =>[signal: a_218_47# w=1]]', 'b: [connection X9/b =>[signal: VNB w=1]]']]
X_X_52__9 VGND _53_/S X_52__a_218_47# VGND sky130_fd_pr__nfet_01v8 w=420000u l=150000u
** [instance X10 of sky130_fd_pr__nfet_01v8, params={'w': '420000u', 'l': '150000u'} connections=['d: [connection X10/d =>[signal: VGND w=1]]', 'g: [connection X10/g =>[signal: S w=1]]', 's: [connection X10/s =>[signal: a_505_21# w=1]]', 'b: [connection X10/b =>[signal: VNB w=1]]']]
X_X_52__10 VGND _53_/S X_52__a_505_21# VGND sky130_fd_pr__nfet_01v8 w=420000u l=150000u
** [instance X11 of sky130_fd_pr__nfet_01v8, params={'w': '420000u', 'l': '150000u'} connections=['d: [connection X11/d =>[signal: a_439_47# w=1]]', 'g: [connection X11/g =>[signal: a_505_21# w=1]]', 's: [connection X11/s =>[signal: VGND w=1]]', 'b: [connection X11/b =>[signal: VNB w=1]]']]
X_X_52__11 X_52__a_439_47# X_52__a_505_21# VGND VGND sky130_fd_pr__nfet_01v8 w=420000u l=150000u

** replacing XFILLER_11_65 with the contents of sky130_fd_sc_hd__fill_2

** replacing XFILLER_11_43 with the contents of sky130_fd_sc_hd__decap_3
** [instance X0 of sky130_fd_pr__pfet_01v8_hvt, params={'w': '870000u', 'l': '590000u'} connections=['d: [connection X0/d =>[signal: VPWR w=1]]', 'g: [connection X0/g =>[signal: VGND w=1]]', 's: [connection X0/s =>[signal: VPWR w=1]]', 'b: [connection X0/b =>[signal: VPB w=1]]']]
X_XFILLER_11_43_0 VPWR VGND VPWR VPWR sky130_fd_pr__pfet_01v8_hvt w=870000u l=590000u
** [instance X1 of sky130_fd_pr__nfet_01v8, params={'w': '550000u', 'l': '590000u'} connections=['d: [connection X1/d =>[signal: VGND w=1]]', 'g: [connection X1/g =>[signal: VPWR w=1]]', 's: [connection X1/s =>[signal: VGND w=1]]', 'b: [connection X1/b =>[signal: VNB w=1]]']]
X_XFILLER_11_43_1 VGND VPWR VGND VGND sky130_fd_pr__nfet_01v8 w=550000u l=590000u

** replacing X_35_ with the contents of sky130_fd_sc_hd__mux4_2
** [instance X0 of sky130_fd_pr__pfet_01v8_hvt, params={'w': '640000u', 'l': '150000u'} connections=['d: [connection X0/d =>[signal: VPWR w=1]]', 'g: [connection X0/g =>[signal: A1 w=1]]', 's: [connection X0/s =>[signal: a_1060_369# w=1]]', 'b: [connection X0/b =>[signal: VPB w=1]]']]
X_X_35__0 VPWR _73_/Q X_35__a_1060_369# VPWR sky130_fd_pr__pfet_01v8_hvt w=640000u l=150000u
** [instance X1 of sky130_fd_pr__nfet_01v8, params={'w': '360000u', 'l': '150000u'} connections=['d: [connection X1/d =>[signal: a_193_47# w=1]]', 'g: [connection X1/g =>[signal: a_27_47# w=1]]', 's: [connection X1/s =>[signal: a_288_47# w=1]]', 'b: [connection X1/b =>[signal: VNB w=1]]']]
X_X_35__1 X_35__a_193_47# X_35__a_27_47# X_35__a_288_47# VGND sky130_fd_pr__nfet_01v8 w=360000u l=150000u
** [instance X2 of sky130_fd_pr__pfet_01v8_hvt, params={'w': '1e+06u', 'l': '150000u'} connections=['d: [connection X2/d =>[signal: VPWR w=1]]', 'g: [connection X2/g =>[signal: a_788_316# w=1]]', 's: [connection X2/s =>[signal: X w=1]]', 'b: [connection X2/b =>[signal: VPB w=1]]']]
X_X_35__2 VPWR X_35__a_788_316# _35_/X VPWR sky130_fd_pr__pfet_01v8_hvt w=1e+06u l=150000u
** [instance X3 of sky130_fd_pr__pfet_01v8_hvt, params={'w': '640000u', 'l': '150000u'} connections=['d: [connection X3/d =>[signal: a_1279_413# w=1]]', 'g: [connection X3/g =>[signal: A0 w=1]]', 's: [connection X3/s =>[signal: VPWR w=1]]', 'b: [connection X3/b =>[signal: VPB w=1]]']]
X_X_35__3 X_35__a_1279_413# _75_/Q VPWR VPWR sky130_fd_pr__pfet_01v8_hvt w=640000u l=150000u
** [instance X4 of sky130_fd_pr__nfet_01v8, params={'w': '650000u', 'l': '150000u'} connections=['d: [connection X4/d =>[signal: VGND w=1]]', 'g: [connection X4/g =>[signal: a_788_316# w=1]]', 's: [connection X4/s =>[signal: X w=1]]', 'b: [connection X4/b =>[signal: VNB w=1]]']]
X_X_35__4 VGND X_35__a_788_316# _35_/X VGND sky130_fd_pr__nfet_01v8 w=650000u l=150000u
** [instance X5 of sky130_fd_pr__pfet_01v8_hvt, params={'w': '1e+06u', 'l': '150000u'} connections=['d: [connection X5/d =>[signal: X w=1]]', 'g: [connection X5/g =>[signal: a_788_316# w=1]]', 's: [connection X5/s =>[signal: VPWR w=1]]', 'b: [connection X5/b =>[signal: VPB w=1]]']]
X_X_35__5 _35_/X X_35__a_788_316# VPWR VPWR sky130_fd_pr__pfet_01v8_hvt w=1e+06u l=150000u
** [instance X6 of sky130_fd_pr__nfet_01v8, params={'w': '420000u', 'l': '150000u'} connections=['d: [connection X6/d =>[signal: a_288_47# w=1]]', 'g: [connection X6/g =>[signal: S1 w=1]]', 's: [connection X6/s =>[signal: a_788_316# w=1]]', 'b: [connection X6/b =>[signal: VNB w=1]]']]
X_X_35__6 X_35__a_288_47# _36_/S1 X_35__a_788_316# VGND sky130_fd_pr__nfet_01v8 w=420000u l=150000u
** [instance X7 of sky130_fd_pr__pfet_01v8_hvt, params={'w': '420000u', 'l': '150000u'} connections=['d: [connection X7/d =>[signal: a_193_369# w=1]]', 'g: [connection X7/g =>[signal: S0 w=1]]', 's: [connection X7/s =>[signal: a_288_47# w=1]]', 'b: [connection X7/b =>[signal: VPB w=1]]']]
X_X_35__7 X_35__a_193_369# _36_/S0 X_35__a_288_47# VPWR sky130_fd_pr__pfet_01v8_hvt w=420000u l=150000u
** [instance X8 of sky130_fd_pr__pfet_01v8_hvt, params={'w': '640000u', 'l': '150000u'} connections=['d: [connection X8/d =>[signal: a_372_413# w=1]]', 'g: [connection X8/g =>[signal: A3 w=1]]', 's: [connection X8/s =>[signal: VPWR w=1]]', 'b: [connection X8/b =>[signal: VPB w=1]]']]
X_X_35__8 X_35__a_372_413# _71_/Q VPWR VPWR sky130_fd_pr__pfet_01v8_hvt w=640000u l=150000u
** [instance X9 of sky130_fd_pr__nfet_01v8, params={'w': '360000u', 'l': '150000u'} connections=['d: [connection X9/d =>[signal: a_872_316# w=1]]', 'g: [connection X9/g =>[signal: a_27_47# w=1]]', 's: [connection X9/s =>[signal: a_1281_47# w=1]]', 'b: [connection X9/b =>[signal: VNB w=1]]']]
X_X_35__9 X_35__a_872_316# X_35__a_27_47# X_35__a_1281_47# VGND sky130_fd_pr__nfet_01v8 w=360000u l=150000u
** [instance X10 of sky130_fd_pr__pfet_01v8_hvt, params={'w': '420000u', 'l': '150000u'} connections=['d: [connection X10/d =>[signal: a_288_47# w=1]]', 'g: [connection X10/g =>[signal: a_27_47# w=1]]', 's: [connection X10/s =>[signal: a_372_413# w=1]]', 'b: [connection X10/b =>[signal: VPB w=1]]']]
X_X_35__10 X_35__a_288_47# X_35__a_27_47# X_35__a_372_413# VPWR sky130_fd_pr__pfet_01v8_hvt w=420000u l=150000u
** [instance X11 of sky130_fd_pr__nfet_01v8, params={'w': '420000u', 'l': '150000u'} connections=['d: [connection X11/d =>[signal: VGND w=1]]', 'g: [connection X11/g =>[signal: A1 w=1]]', 's: [connection X11/s =>[signal: a_1064_47# w=1]]', 'b: [connection X11/b =>[signal: VNB w=1]]']]
X_X_35__11 VGND _73_/Q X_35__a_1064_47# VGND sky130_fd_pr__nfet_01v8 w=420000u l=150000u
** [instance X12 of sky130_fd_pr__pfet_01v8_hvt, params={'w': '640000u', 'l': '150000u'} connections=['d: [connection X12/d =>[signal: VPWR w=1]]', 'g: [connection X12/g =>[signal: S1 w=1]]', 's: [connection X12/s =>[signal: a_600_345# w=1]]', 'b: [connection X12/b =>[signal: VPB w=1]]']]
X_X_35__12 VPWR _36_/S1 X_35__a_600_345# VPWR sky130_fd_pr__pfet_01v8_hvt w=640000u l=150000u
** [instance X13 of sky130_fd_pr__pfet_01v8_hvt, params={'w': '420000u', 'l': '150000u'} connections=['d: [connection X13/d =>[signal: a_872_316# w=1]]', 'g: [connection X13/g =>[signal: S0 w=1]]', 's: [connection X13/s =>[signal: a_1279_413# w=1]]', 'b: [connection X13/b =>[signal: VPB w=1]]']]
X_X_35__13 X_35__a_872_316# _36_/S0 X_35__a_1279_413# VPWR sky130_fd_pr__pfet_01v8_hvt w=420000u l=150000u
** [instance X14 of sky130_fd_pr__pfet_01v8_hvt, params={'w': '640000u', 'l': '150000u'} connections=['d: [connection X14/d =>[signal: a_27_47# w=1]]', 'g: [connection X14/g =>[signal: S0 w=1]]', 's: [connection X14/s =>[signal: VPWR w=1]]', 'b: [connection X14/b =>[signal: VPB w=1]]']]
X_X_35__14 X_35__a_27_47# _36_/S0 VPWR VPWR sky130_fd_pr__pfet_01v8_hvt w=640000u l=150000u
** [instance X15 of sky130_fd_pr__pfet_01v8_hvt, params={'w': '640000u', 'l': '150000u'} connections=['d: [connection X15/d =>[signal: VPWR w=1]]', 'g: [connection X15/g =>[signal: A2 w=1]]', 's: [connection X15/s =>[signal: a_193_369# w=1]]', 'b: [connection X15/b =>[signal: VPB w=1]]']]
X_X_35__15 VPWR _72_/Q X_35__a_193_369# VPWR sky130_fd_pr__pfet_01v8_hvt w=640000u l=150000u
** [instance X16 of sky130_fd_pr__nfet_01v8, params={'w': '420000u', 'l': '150000u'} connections=['d: [connection X16/d =>[signal: VGND w=1]]', 'g: [connection X16/g =>[signal: A2 w=1]]', 's: [connection X16/s =>[signal: a_193_47# w=1]]', 'b: [connection X16/b =>[signal: VNB w=1]]']]
X_X_35__16 VGND _72_/Q X_35__a_193_47# VGND sky130_fd_pr__nfet_01v8 w=420000u l=150000u
** [instance X17 of sky130_fd_pr__pfet_01v8_hvt, params={'w': '540000u', 'l': '150000u'} connections=['d: [connection X17/d =>[signal: a_288_47# w=1]]', 'g: [connection X17/g =>[signal: a_600_345# w=1]]', 's: [connection X17/s =>[signal: a_788_316# w=1]]', 'b: [connection X17/b =>[signal: VPB w=1]]']]
X_X_35__17 X_35__a_288_47# X_35__a_600_345# X_35__a_788_316# VPWR sky130_fd_pr__pfet_01v8_hvt w=540000u l=150000u
** [instance X18 of sky130_fd_pr__nfet_01v8, params={'w': '420000u', 'l': '150000u'} connections=['d: [connection X18/d =>[signal: a_397_47# w=1]]', 'g: [connection X18/g =>[signal: A3 w=1]]', 's: [connection X18/s =>[signal: VGND w=1]]', 'b: [connection X18/b =>[signal: VNB w=1]]']]
X_X_35__18 X_35__a_397_47# _71_/Q VGND VGND sky130_fd_pr__nfet_01v8 w=420000u l=150000u
** [instance X19 of sky130_fd_pr__nfet_01v8, params={'w': '420000u', 'l': '150000u'} connections=['d: [connection X19/d =>[signal: a_27_47# w=1]]', 'g: [connection X19/g =>[signal: S0 w=1]]', 's: [connection X19/s =>[signal: VGND w=1]]', 'b: [connection X19/b =>[signal: VNB w=1]]']]
X_X_35__19 X_35__a_27_47# _36_/S0 VGND VGND sky130_fd_pr__nfet_01v8 w=420000u l=150000u
** [instance X20 of sky130_fd_pr__pfet_01v8_hvt, params={'w': '420000u', 'l': '150000u'} connections=['d: [connection X20/d =>[signal: a_1060_369# w=1]]', 'g: [connection X20/g =>[signal: a_27_47# w=1]]', 's: [connection X20/s =>[signal: a_872_316# w=1]]', 'b: [connection X20/b =>[signal: VPB w=1]]']]
X_X_35__20 X_35__a_1060_369# X_35__a_27_47# X_35__a_872_316# VPWR sky130_fd_pr__pfet_01v8_hvt w=420000u l=150000u
** [instance X21 of sky130_fd_pr__nfet_01v8, params={'w': '420000u', 'l': '150000u'} connections=['d: [connection X21/d =>[signal: VGND w=1]]', 'g: [connection X21/g =>[signal: S1 w=1]]', 's: [connection X21/s =>[signal: a_600_345# w=1]]', 'b: [connection X21/b =>[signal: VNB w=1]]']]
X_X_35__21 VGND _36_/S1 X_35__a_600_345# VGND sky130_fd_pr__nfet_01v8 w=420000u l=150000u
** [instance X22 of sky130_fd_pr__nfet_01v8, params={'w': '420000u', 'l': '150000u'} connections=['d: [connection X22/d =>[signal: a_1281_47# w=1]]', 'g: [connection X22/g =>[signal: A0 w=1]]', 's: [connection X22/s =>[signal: VGND w=1]]', 'b: [connection X22/b =>[signal: VNB w=1]]']]
X_X_35__22 X_35__a_1281_47# _75_/Q VGND VGND sky130_fd_pr__nfet_01v8 w=420000u l=150000u
** [instance X23 of sky130_fd_pr__nfet_01v8, params={'w': '650000u', 'l': '150000u'} connections=['d: [connection X23/d =>[signal: X w=1]]', 'g: [connection X23/g =>[signal: a_788_316# w=1]]', 's: [connection X23/s =>[signal: VGND w=1]]', 'b: [connection X23/b =>[signal: VNB w=1]]']]
X_X_35__23 _35_/X X_35__a_788_316# VGND VGND sky130_fd_pr__nfet_01v8 w=650000u l=150000u
** [instance X24 of sky130_fd_pr__nfet_01v8, params={'w': '360000u', 'l': '150000u'} connections=['d: [connection X24/d =>[signal: a_288_47# w=1]]', 'g: [connection X24/g =>[signal: S0 w=1]]', 's: [connection X24/s =>[signal: a_397_47# w=1]]', 'b: [connection X24/b =>[signal: VNB w=1]]']]
X_X_35__24 X_35__a_288_47# _36_/S0 X_35__a_397_47# VGND sky130_fd_pr__nfet_01v8 w=360000u l=150000u
** [instance X25 of sky130_fd_pr__pfet_01v8_hvt, params={'w': '540000u', 'l': '150000u'} connections=['d: [connection X25/d =>[signal: a_788_316# w=1]]', 'g: [connection X25/g =>[signal: S1 w=1]]', 's: [connection X25/s =>[signal: a_872_316# w=1]]', 'b: [connection X25/b =>[signal: VPB w=1]]']]
X_X_35__25 X_35__a_788_316# _36_/S1 X_35__a_872_316# VPWR sky130_fd_pr__pfet_01v8_hvt w=540000u l=150000u
** [instance X26 of sky130_fd_pr__nfet_01v8, params={'w': '420000u', 'l': '150000u'} connections=['d: [connection X26/d =>[signal: a_788_316# w=1]]', 'g: [connection X26/g =>[signal: a_600_345# w=1]]', 's: [connection X26/s =>[signal: a_872_316# w=1]]', 'b: [connection X26/b =>[signal: VNB w=1]]']]
X_X_35__26 X_35__a_788_316# X_35__a_600_345# X_35__a_872_316# VGND sky130_fd_pr__nfet_01v8 w=420000u l=150000u
** [instance X27 of sky130_fd_pr__nfet_01v8, params={'w': '360000u', 'l': '150000u'} connections=['d: [connection X27/d =>[signal: a_1064_47# w=1]]', 'g: [connection X27/g =>[signal: S0 w=1]]', 's: [connection X27/s =>[signal: a_872_316# w=1]]', 'b: [connection X27/b =>[signal: VNB w=1]]']]
X_X_35__27 X_35__a_1064_47# _36_/S0 X_35__a_872_316# VGND sky130_fd_pr__nfet_01v8 w=360000u l=150000u

** replacing XFILLER_8_55 with the contents of sky130_fd_sc_hd__fill_1

** replacing XFILLER_11_55 with the contents of sky130_fd_sc_hd__fill_1

** replacing XFILLER_11_22 with the contents of sky130_fd_sc_hd__fill_1

** replacing X_51_ with the contents of sky130_fd_sc_hd__mux2_1
** [instance X0 of sky130_fd_pr__pfet_01v8_hvt, params={'w': '420000u', 'l': '150000u'} connections=['d: [connection X0/d =>[signal: VPWR w=1]]', 'g: [connection X0/g =>[signal: S w=1]]', 's: [connection X0/s =>[signal: a_218_374# w=1]]', 'b: [connection X0/b =>[signal: VPB w=1]]']]
X_X_51__0 VPWR _53_/S X_51__a_218_374# VPWR sky130_fd_pr__pfet_01v8_hvt w=420000u l=150000u
** [instance X1 of sky130_fd_pr__nfet_01v8, params={'w': '420000u', 'l': '150000u'} connections=['d: [connection X1/d =>[signal: a_76_199# w=1]]', 'g: [connection X1/g =>[signal: A0 w=1]]', 's: [connection X1/s =>[signal: a_439_47# w=1]]', 'b: [connection X1/b =>[signal: VNB w=1]]']]
X_X_51__1 X_51__a_76_199# _51_/A0 X_51__a_439_47# VGND sky130_fd_pr__nfet_01v8 w=420000u l=150000u
** [instance X2 of sky130_fd_pr__pfet_01v8_hvt, params={'w': '420000u', 'l': '150000u'} connections=['d: [connection X2/d =>[signal: a_535_374# w=1]]', 'g: [connection X2/g =>[signal: a_505_21# w=1]]', 's: [connection X2/s =>[signal: VPWR w=1]]', 'b: [connection X2/b =>[signal: VPB w=1]]']]
X_X_51__2 X_51__a_535_374# X_51__a_505_21# VPWR VPWR sky130_fd_pr__pfet_01v8_hvt w=420000u l=150000u
** [instance X3 of sky130_fd_pr__pfet_01v8_hvt, params={'w': '420000u', 'l': '150000u'} connections=['d: [connection X3/d =>[signal: VPWR w=1]]', 'g: [connection X3/g =>[signal: S w=1]]', 's: [connection X3/s =>[signal: a_505_21# w=1]]', 'b: [connection X3/b =>[signal: VPB w=1]]']]
X_X_51__3 VPWR _53_/S X_51__a_505_21# VPWR sky130_fd_pr__pfet_01v8_hvt w=420000u l=150000u
** [instance X4 of sky130_fd_pr__pfet_01v8_hvt, params={'w': '420000u', 'l': '150000u'} connections=['d: [connection X4/d =>[signal: a_76_199# w=1]]', 'g: [connection X4/g =>[signal: A1 w=1]]', 's: [connection X4/s =>[signal: a_535_374# w=1]]', 'b: [connection X4/b =>[signal: VPB w=1]]']]
X_X_51__4 X_51__a_76_199# _52_/A0 X_51__a_535_374# VPWR sky130_fd_pr__pfet_01v8_hvt w=420000u l=150000u
** [instance X5 of sky130_fd_pr__nfet_01v8, params={'w': '420000u', 'l': '150000u'} connections=['d: [connection X5/d =>[signal: a_218_47# w=1]]', 'g: [connection X5/g =>[signal: A1 w=1]]', 's: [connection X5/s =>[signal: a_76_199# w=1]]', 'b: [connection X5/b =>[signal: VNB w=1]]']]
X_X_51__5 X_51__a_218_47# _52_/A0 X_51__a_76_199# VGND sky130_fd_pr__nfet_01v8 w=420000u l=150000u
** [instance X6 of sky130_fd_pr__pfet_01v8_hvt, params={'w': '420000u', 'l': '150000u'} connections=['d: [connection X6/d =>[signal: a_218_374# w=1]]', 'g: [connection X6/g =>[signal: A0 w=1]]', 's: [connection X6/s =>[signal: a_76_199# w=1]]', 'b: [connection X6/b =>[signal: VPB w=1]]']]
X_X_51__6 X_51__a_218_374# _51_/A0 X_51__a_76_199# VPWR sky130_fd_pr__pfet_01v8_hvt w=420000u l=150000u
** [instance X7 of sky130_fd_pr__nfet_01v8, params={'w': '650000u', 'l': '150000u'} connections=['d: [connection X7/d =>[signal: X w=1]]', 'g: [connection X7/g =>[signal: a_76_199# w=1]]', 's: [connection X7/s =>[signal: VGND w=1]]', 'b: [connection X7/b =>[signal: VNB w=1]]']]
X_X_51__7 _69_/D X_51__a_76_199# VGND VGND sky130_fd_pr__nfet_01v8 w=650000u l=150000u
** [instance X8 of sky130_fd_pr__pfet_01v8_hvt, params={'w': '1e+06u', 'l': '150000u'} connections=['d: [connection X8/d =>[signal: X w=1]]', 'g: [connection X8/g =>[signal: a_76_199# w=1]]', 's: [connection X8/s =>[signal: VPWR w=1]]', 'b: [connection X8/b =>[signal: VPB w=1]]']]
X_X_51__8 _69_/D X_51__a_76_199# VPWR VPWR sky130_fd_pr__pfet_01v8_hvt w=1e+06u l=150000u
** [instance X9 of sky130_fd_pr__nfet_01v8, params={'w': '420000u', 'l': '150000u'} connections=['d: [connection X9/d =>[signal: VGND w=1]]', 'g: [connection X9/g =>[signal: S w=1]]', 's: [connection X9/s =>[signal: a_218_47# w=1]]', 'b: [connection X9/b =>[signal: VNB w=1]]']]
X_X_51__9 VGND _53_/S X_51__a_218_47# VGND sky130_fd_pr__nfet_01v8 w=420000u l=150000u
** [instance X10 of sky130_fd_pr__nfet_01v8, params={'w': '420000u', 'l': '150000u'} connections=['d: [connection X10/d =>[signal: VGND w=1]]', 'g: [connection X10/g =>[signal: S w=1]]', 's: [connection X10/s =>[signal: a_505_21# w=1]]', 'b: [connection X10/b =>[signal: VNB w=1]]']]
X_X_51__10 VGND _53_/S X_51__a_505_21# VGND sky130_fd_pr__nfet_01v8 w=420000u l=150000u
** [instance X11 of sky130_fd_pr__nfet_01v8, params={'w': '420000u', 'l': '150000u'} connections=['d: [connection X11/d =>[signal: a_439_47# w=1]]', 'g: [connection X11/g =>[signal: a_505_21# w=1]]', 's: [connection X11/s =>[signal: VGND w=1]]', 'b: [connection X11/b =>[signal: VNB w=1]]']]
X_X_51__11 X_51__a_439_47# X_51__a_505_21# VGND VGND sky130_fd_pr__nfet_01v8 w=420000u l=150000u

** replacing X_34_ with the contents of sky130_fd_sc_hd__o21a_2
** [instance X0 of sky130_fd_pr__nfet_01v8, params={'w': '650000u', 'l': '150000u'} connections=['d: [connection X0/d =>[signal: a_384_47# w=1]]', 'g: [connection X0/g =>[signal: A2 w=1]]', 's: [connection X0/s =>[signal: VGND w=1]]', 'b: [connection X0/b =>[signal: VNB w=1]]']]
X_X_34__0 X_34__a_384_47# _33_/X VGND VGND sky130_fd_pr__nfet_01v8 w=650000u l=150000u
** [instance X1 of sky130_fd_pr__nfet_01v8, params={'w': '650000u', 'l': '150000u'} connections=['d: [connection X1/d =>[signal: X w=1]]', 'g: [connection X1/g =>[signal: a_79_21# w=1]]', 's: [connection X1/s =>[signal: VGND w=1]]', 'b: [connection X1/b =>[signal: VNB w=1]]']]
X_X_34__1 _34_/X X_34__a_79_21# VGND VGND sky130_fd_pr__nfet_01v8 w=650000u l=150000u
** [instance X2 of sky130_fd_pr__pfet_01v8_hvt, params={'w': '1e+06u', 'l': '150000u'} connections=['d: [connection X2/d =>[signal: a_470_297# w=1]]', 'g: [connection X2/g =>[signal: A1 w=1]]', 's: [connection X2/s =>[signal: VPWR w=1]]', 'b: [connection X2/b =>[signal: VPB w=1]]']]
X_X_34__2 X_34__a_470_297# _29_/Y VPWR VPWR sky130_fd_pr__pfet_01v8_hvt w=1e+06u l=150000u
** [instance X3 of sky130_fd_pr__pfet_01v8_hvt, params={'w': '1e+06u', 'l': '150000u'} connections=['d: [connection X3/d =>[signal: VPWR w=1]]', 'g: [connection X3/g =>[signal: B1 w=1]]', 's: [connection X3/s =>[signal: a_79_21# w=1]]', 'b: [connection X3/b =>[signal: VPB w=1]]']]
X_X_34__3 VPWR _30_/A X_34__a_79_21# VPWR sky130_fd_pr__pfet_01v8_hvt w=1e+06u l=150000u
** [instance X4 of sky130_fd_pr__nfet_01v8, params={'w': '650000u', 'l': '150000u'} connections=['d: [connection X4/d =>[signal: VGND w=1]]', 'g: [connection X4/g =>[signal: A1 w=1]]', 's: [connection X4/s =>[signal: a_384_47# w=1]]', 'b: [connection X4/b =>[signal: VNB w=1]]']]
X_X_34__4 VGND _29_/Y X_34__a_384_47# VGND sky130_fd_pr__nfet_01v8 w=650000u l=150000u
** [instance X5 of sky130_fd_pr__nfet_01v8, params={'w': '650000u', 'l': '150000u'} connections=['d: [connection X5/d =>[signal: VGND w=1]]', 'g: [connection X5/g =>[signal: a_79_21# w=1]]', 's: [connection X5/s =>[signal: X w=1]]', 'b: [connection X5/b =>[signal: VNB w=1]]']]
X_X_34__5 VGND X_34__a_79_21# _34_/X VGND sky130_fd_pr__nfet_01v8 w=650000u l=150000u
** [instance X6 of sky130_fd_pr__pfet_01v8_hvt, params={'w': '1e+06u', 'l': '150000u'} connections=['d: [connection X6/d =>[signal: VPWR w=1]]', 'g: [connection X6/g =>[signal: a_79_21# w=1]]', 's: [connection X6/s =>[signal: X w=1]]', 'b: [connection X6/b =>[signal: VPB w=1]]']]
X_X_34__6 VPWR X_34__a_79_21# _34_/X VPWR sky130_fd_pr__pfet_01v8_hvt w=1e+06u l=150000u
** [instance X7 of sky130_fd_pr__pfet_01v8_hvt, params={'w': '1e+06u', 'l': '150000u'} connections=['d: [connection X7/d =>[signal: a_79_21# w=1]]', 'g: [connection X7/g =>[signal: A2 w=1]]', 's: [connection X7/s =>[signal: a_470_297# w=1]]', 'b: [connection X7/b =>[signal: VPB w=1]]']]
X_X_34__7 X_34__a_79_21# _33_/X X_34__a_470_297# VPWR sky130_fd_pr__pfet_01v8_hvt w=1e+06u l=150000u
** [instance X8 of sky130_fd_pr__pfet_01v8_hvt, params={'w': '1e+06u', 'l': '150000u'} connections=['d: [connection X8/d =>[signal: X w=1]]', 'g: [connection X8/g =>[signal: a_79_21# w=1]]', 's: [connection X8/s =>[signal: VPWR w=1]]', 'b: [connection X8/b =>[signal: VPB w=1]]']]
X_X_34__8 _34_/X X_34__a_79_21# VPWR VPWR sky130_fd_pr__pfet_01v8_hvt w=1e+06u l=150000u
** [instance X9 of sky130_fd_pr__nfet_01v8, params={'w': '650000u', 'l': '150000u'} connections=['d: [connection X9/d =>[signal: a_79_21# w=1]]', 'g: [connection X9/g =>[signal: B1 w=1]]', 's: [connection X9/s =>[signal: a_384_47# w=1]]', 'b: [connection X9/b =>[signal: VNB w=1]]']]
X_X_34__9 X_34__a_79_21# _30_/A X_34__a_384_47# VGND sky130_fd_pr__nfet_01v8 w=650000u l=150000u

** replacing XPHY_EDGE_ROW_9_Left_23 with the contents of sky130_fd_sc_hd__decap_3
** [instance X0 of sky130_fd_pr__pfet_01v8_hvt, params={'w': '870000u', 'l': '590000u'} connections=['d: [connection X0/d =>[signal: VPWR w=1]]', 'g: [connection X0/g =>[signal: VGND w=1]]', 's: [connection X0/s =>[signal: VPWR w=1]]', 'b: [connection X0/b =>[signal: VPB w=1]]']]
X_XPHY_EDGE_ROW_9_Left_23_0 VPWR VGND VPWR VPWR sky130_fd_pr__pfet_01v8_hvt w=870000u l=590000u
** [instance X1 of sky130_fd_pr__nfet_01v8, params={'w': '550000u', 'l': '590000u'} connections=['d: [connection X1/d =>[signal: VGND w=1]]', 'g: [connection X1/g =>[signal: VPWR w=1]]', 's: [connection X1/s =>[signal: VGND w=1]]', 'b: [connection X1/b =>[signal: VNB w=1]]']]
X_XPHY_EDGE_ROW_9_Left_23_1 VGND VPWR VGND VGND sky130_fd_pr__nfet_01v8 w=550000u l=590000u

** replacing XFILLER_11_34 with the contents of sky130_fd_sc_hd__fill_1

** replacing X_33_ with the contents of sky130_fd_sc_hd__mux4_2
** [instance X0 of sky130_fd_pr__pfet_01v8_hvt, params={'w': '640000u', 'l': '150000u'} connections=['d: [connection X0/d =>[signal: VPWR w=1]]', 'g: [connection X0/g =>[signal: A1 w=1]]', 's: [connection X0/s =>[signal: a_1060_369# w=1]]', 'b: [connection X0/b =>[signal: VPB w=1]]']]
X_X_33__0 VPWR _61_/Q X_33__a_1060_369# VPWR sky130_fd_pr__pfet_01v8_hvt w=640000u l=150000u
** [instance X1 of sky130_fd_pr__nfet_01v8, params={'w': '360000u', 'l': '150000u'} connections=['d: [connection X1/d =>[signal: a_193_47# w=1]]', 'g: [connection X1/g =>[signal: a_27_47# w=1]]', 's: [connection X1/s =>[signal: a_288_47# w=1]]', 'b: [connection X1/b =>[signal: VNB w=1]]']]
X_X_33__1 X_33__a_193_47# X_33__a_27_47# X_33__a_288_47# VGND sky130_fd_pr__nfet_01v8 w=360000u l=150000u
** [instance X2 of sky130_fd_pr__pfet_01v8_hvt, params={'w': '1e+06u', 'l': '150000u'} connections=['d: [connection X2/d =>[signal: VPWR w=1]]', 'g: [connection X2/g =>[signal: a_788_316# w=1]]', 's: [connection X2/s =>[signal: X w=1]]', 'b: [connection X2/b =>[signal: VPB w=1]]']]
X_X_33__2 VPWR X_33__a_788_316# _33_/X VPWR sky130_fd_pr__pfet_01v8_hvt w=1e+06u l=150000u
** [instance X3 of sky130_fd_pr__pfet_01v8_hvt, params={'w': '640000u', 'l': '150000u'} connections=['d: [connection X3/d =>[signal: a_1279_413# w=1]]', 'g: [connection X3/g =>[signal: A0 w=1]]', 's: [connection X3/s =>[signal: VPWR w=1]]', 'b: [connection X3/b =>[signal: VPB w=1]]']]
X_X_33__3 X_33__a_1279_413# _62_/Q VPWR VPWR sky130_fd_pr__pfet_01v8_hvt w=640000u l=150000u
** [instance X4 of sky130_fd_pr__nfet_01v8, params={'w': '650000u', 'l': '150000u'} connections=['d: [connection X4/d =>[signal: VGND w=1]]', 'g: [connection X4/g =>[signal: a_788_316# w=1]]', 's: [connection X4/s =>[signal: X w=1]]', 'b: [connection X4/b =>[signal: VNB w=1]]']]
X_X_33__4 VGND X_33__a_788_316# _33_/X VGND sky130_fd_pr__nfet_01v8 w=650000u l=150000u
** [instance X5 of sky130_fd_pr__pfet_01v8_hvt, params={'w': '1e+06u', 'l': '150000u'} connections=['d: [connection X5/d =>[signal: X w=1]]', 'g: [connection X5/g =>[signal: a_788_316# w=1]]', 's: [connection X5/s =>[signal: VPWR w=1]]', 'b: [connection X5/b =>[signal: VPB w=1]]']]
X_X_33__5 _33_/X X_33__a_788_316# VPWR VPWR sky130_fd_pr__pfet_01v8_hvt w=1e+06u l=150000u
** [instance X6 of sky130_fd_pr__nfet_01v8, params={'w': '420000u', 'l': '150000u'} connections=['d: [connection X6/d =>[signal: a_288_47# w=1]]', 'g: [connection X6/g =>[signal: S1 w=1]]', 's: [connection X6/s =>[signal: a_788_316# w=1]]', 'b: [connection X6/b =>[signal: VNB w=1]]']]
X_X_33__6 X_33__a_288_47# _36_/S1 X_33__a_788_316# VGND sky130_fd_pr__nfet_01v8 w=420000u l=150000u
** [instance X7 of sky130_fd_pr__pfet_01v8_hvt, params={'w': '420000u', 'l': '150000u'} connections=['d: [connection X7/d =>[signal: a_193_369# w=1]]', 'g: [connection X7/g =>[signal: S0 w=1]]', 's: [connection X7/s =>[signal: a_288_47# w=1]]', 'b: [connection X7/b =>[signal: VPB w=1]]']]
X_X_33__7 X_33__a_193_369# _36_/S0 X_33__a_288_47# VPWR sky130_fd_pr__pfet_01v8_hvt w=420000u l=150000u
** [instance X8 of sky130_fd_pr__pfet_01v8_hvt, params={'w': '640000u', 'l': '150000u'} connections=['d: [connection X8/d =>[signal: a_372_413# w=1]]', 'g: [connection X8/g =>[signal: A3 w=1]]', 's: [connection X8/s =>[signal: VPWR w=1]]', 'b: [connection X8/b =>[signal: VPB w=1]]']]
X_X_33__8 X_33__a_372_413# _59_/Q VPWR VPWR sky130_fd_pr__pfet_01v8_hvt w=640000u l=150000u
** [instance X9 of sky130_fd_pr__nfet_01v8, params={'w': '360000u', 'l': '150000u'} connections=['d: [connection X9/d =>[signal: a_872_316# w=1]]', 'g: [connection X9/g =>[signal: a_27_47# w=1]]', 's: [connection X9/s =>[signal: a_1281_47# w=1]]', 'b: [connection X9/b =>[signal: VNB w=1]]']]
X_X_33__9 X_33__a_872_316# X_33__a_27_47# X_33__a_1281_47# VGND sky130_fd_pr__nfet_01v8 w=360000u l=150000u
** [instance X10 of sky130_fd_pr__pfet_01v8_hvt, params={'w': '420000u', 'l': '150000u'} connections=['d: [connection X10/d =>[signal: a_288_47# w=1]]', 'g: [connection X10/g =>[signal: a_27_47# w=1]]', 's: [connection X10/s =>[signal: a_372_413# w=1]]', 'b: [connection X10/b =>[signal: VPB w=1]]']]
X_X_33__10 X_33__a_288_47# X_33__a_27_47# X_33__a_372_413# VPWR sky130_fd_pr__pfet_01v8_hvt w=420000u l=150000u
** [instance X11 of sky130_fd_pr__nfet_01v8, params={'w': '420000u', 'l': '150000u'} connections=['d: [connection X11/d =>[signal: VGND w=1]]', 'g: [connection X11/g =>[signal: A1 w=1]]', 's: [connection X11/s =>[signal: a_1064_47# w=1]]', 'b: [connection X11/b =>[signal: VNB w=1]]']]
X_X_33__11 VGND _61_/Q X_33__a_1064_47# VGND sky130_fd_pr__nfet_01v8 w=420000u l=150000u
** [instance X12 of sky130_fd_pr__pfet_01v8_hvt, params={'w': '640000u', 'l': '150000u'} connections=['d: [connection X12/d =>[signal: VPWR w=1]]', 'g: [connection X12/g =>[signal: S1 w=1]]', 's: [connection X12/s =>[signal: a_600_345# w=1]]', 'b: [connection X12/b =>[signal: VPB w=1]]']]
X_X_33__12 VPWR _36_/S1 X_33__a_600_345# VPWR sky130_fd_pr__pfet_01v8_hvt w=640000u l=150000u
** [instance X13 of sky130_fd_pr__pfet_01v8_hvt, params={'w': '420000u', 'l': '150000u'} connections=['d: [connection X13/d =>[signal: a_872_316# w=1]]', 'g: [connection X13/g =>[signal: S0 w=1]]', 's: [connection X13/s =>[signal: a_1279_413# w=1]]', 'b: [connection X13/b =>[signal: VPB w=1]]']]
X_X_33__13 X_33__a_872_316# _36_/S0 X_33__a_1279_413# VPWR sky130_fd_pr__pfet_01v8_hvt w=420000u l=150000u
** [instance X14 of sky130_fd_pr__pfet_01v8_hvt, params={'w': '640000u', 'l': '150000u'} connections=['d: [connection X14/d =>[signal: a_27_47# w=1]]', 'g: [connection X14/g =>[signal: S0 w=1]]', 's: [connection X14/s =>[signal: VPWR w=1]]', 'b: [connection X14/b =>[signal: VPB w=1]]']]
X_X_33__14 X_33__a_27_47# _36_/S0 VPWR VPWR sky130_fd_pr__pfet_01v8_hvt w=640000u l=150000u
** [instance X15 of sky130_fd_pr__pfet_01v8_hvt, params={'w': '640000u', 'l': '150000u'} connections=['d: [connection X15/d =>[signal: VPWR w=1]]', 'g: [connection X15/g =>[signal: A2 w=1]]', 's: [connection X15/s =>[signal: a_193_369# w=1]]', 'b: [connection X15/b =>[signal: VPB w=1]]']]
X_X_33__15 VPWR _60_/Q X_33__a_193_369# VPWR sky130_fd_pr__pfet_01v8_hvt w=640000u l=150000u
** [instance X16 of sky130_fd_pr__nfet_01v8, params={'w': '420000u', 'l': '150000u'} connections=['d: [connection X16/d =>[signal: VGND w=1]]', 'g: [connection X16/g =>[signal: A2 w=1]]', 's: [connection X16/s =>[signal: a_193_47# w=1]]', 'b: [connection X16/b =>[signal: VNB w=1]]']]
X_X_33__16 VGND _60_/Q X_33__a_193_47# VGND sky130_fd_pr__nfet_01v8 w=420000u l=150000u
** [instance X17 of sky130_fd_pr__pfet_01v8_hvt, params={'w': '540000u', 'l': '150000u'} connections=['d: [connection X17/d =>[signal: a_288_47# w=1]]', 'g: [connection X17/g =>[signal: a_600_345# w=1]]', 's: [connection X17/s =>[signal: a_788_316# w=1]]', 'b: [connection X17/b =>[signal: VPB w=1]]']]
X_X_33__17 X_33__a_288_47# X_33__a_600_345# X_33__a_788_316# VPWR sky130_fd_pr__pfet_01v8_hvt w=540000u l=150000u
** [instance X18 of sky130_fd_pr__nfet_01v8, params={'w': '420000u', 'l': '150000u'} connections=['d: [connection X18/d =>[signal: a_397_47# w=1]]', 'g: [connection X18/g =>[signal: A3 w=1]]', 's: [connection X18/s =>[signal: VGND w=1]]', 'b: [connection X18/b =>[signal: VNB w=1]]']]
X_X_33__18 X_33__a_397_47# _59_/Q VGND VGND sky130_fd_pr__nfet_01v8 w=420000u l=150000u
** [instance X19 of sky130_fd_pr__nfet_01v8, params={'w': '420000u', 'l': '150000u'} connections=['d: [connection X19/d =>[signal: a_27_47# w=1]]', 'g: [connection X19/g =>[signal: S0 w=1]]', 's: [connection X19/s =>[signal: VGND w=1]]', 'b: [connection X19/b =>[signal: VNB w=1]]']]
X_X_33__19 X_33__a_27_47# _36_/S0 VGND VGND sky130_fd_pr__nfet_01v8 w=420000u l=150000u
** [instance X20 of sky130_fd_pr__pfet_01v8_hvt, params={'w': '420000u', 'l': '150000u'} connections=['d: [connection X20/d =>[signal: a_1060_369# w=1]]', 'g: [connection X20/g =>[signal: a_27_47# w=1]]', 's: [connection X20/s =>[signal: a_872_316# w=1]]', 'b: [connection X20/b =>[signal: VPB w=1]]']]
X_X_33__20 X_33__a_1060_369# X_33__a_27_47# X_33__a_872_316# VPWR sky130_fd_pr__pfet_01v8_hvt w=420000u l=150000u
** [instance X21 of sky130_fd_pr__nfet_01v8, params={'w': '420000u', 'l': '150000u'} connections=['d: [connection X21/d =>[signal: VGND w=1]]', 'g: [connection X21/g =>[signal: S1 w=1]]', 's: [connection X21/s =>[signal: a_600_345# w=1]]', 'b: [connection X21/b =>[signal: VNB w=1]]']]
X_X_33__21 VGND _36_/S1 X_33__a_600_345# VGND sky130_fd_pr__nfet_01v8 w=420000u l=150000u
** [instance X22 of sky130_fd_pr__nfet_01v8, params={'w': '420000u', 'l': '150000u'} connections=['d: [connection X22/d =>[signal: a_1281_47# w=1]]', 'g: [connection X22/g =>[signal: A0 w=1]]', 's: [connection X22/s =>[signal: VGND w=1]]', 'b: [connection X22/b =>[signal: VNB w=1]]']]
X_X_33__22 X_33__a_1281_47# _62_/Q VGND VGND sky130_fd_pr__nfet_01v8 w=420000u l=150000u
** [instance X23 of sky130_fd_pr__nfet_01v8, params={'w': '650000u', 'l': '150000u'} connections=['d: [connection X23/d =>[signal: X w=1]]', 'g: [connection X23/g =>[signal: a_788_316# w=1]]', 's: [connection X23/s =>[signal: VGND w=1]]', 'b: [connection X23/b =>[signal: VNB w=1]]']]
X_X_33__23 _33_/X X_33__a_788_316# VGND VGND sky130_fd_pr__nfet_01v8 w=650000u l=150000u
** [instance X24 of sky130_fd_pr__nfet_01v8, params={'w': '360000u', 'l': '150000u'} connections=['d: [connection X24/d =>[signal: a_288_47# w=1]]', 'g: [connection X24/g =>[signal: S0 w=1]]', 's: [connection X24/s =>[signal: a_397_47# w=1]]', 'b: [connection X24/b =>[signal: VNB w=1]]']]
X_X_33__24 X_33__a_288_47# _36_/S0 X_33__a_397_47# VGND sky130_fd_pr__nfet_01v8 w=360000u l=150000u
** [instance X25 of sky130_fd_pr__pfet_01v8_hvt, params={'w': '540000u', 'l': '150000u'} connections=['d: [connection X25/d =>[signal: a_788_316# w=1]]', 'g: [connection X25/g =>[signal: S1 w=1]]', 's: [connection X25/s =>[signal: a_872_316# w=1]]', 'b: [connection X25/b =>[signal: VPB w=1]]']]
X_X_33__25 X_33__a_788_316# _36_/S1 X_33__a_872_316# VPWR sky130_fd_pr__pfet_01v8_hvt w=540000u l=150000u
** [instance X26 of sky130_fd_pr__nfet_01v8, params={'w': '420000u', 'l': '150000u'} connections=['d: [connection X26/d =>[signal: a_788_316# w=1]]', 'g: [connection X26/g =>[signal: a_600_345# w=1]]', 's: [connection X26/s =>[signal: a_872_316# w=1]]', 'b: [connection X26/b =>[signal: VNB w=1]]']]
X_X_33__26 X_33__a_788_316# X_33__a_600_345# X_33__a_872_316# VGND sky130_fd_pr__nfet_01v8 w=420000u l=150000u
** [instance X27 of sky130_fd_pr__nfet_01v8, params={'w': '360000u', 'l': '150000u'} connections=['d: [connection X27/d =>[signal: a_1064_47# w=1]]', 'g: [connection X27/g =>[signal: S0 w=1]]', 's: [connection X27/s =>[signal: a_872_316# w=1]]', 'b: [connection X27/b =>[signal: VNB w=1]]']]
X_X_33__27 X_33__a_1064_47# _36_/S0 X_33__a_872_316# VGND sky130_fd_pr__nfet_01v8 w=360000u l=150000u

** replacing X_50_ with the contents of sky130_fd_sc_hd__mux2_1
** [instance X0 of sky130_fd_pr__pfet_01v8_hvt, params={'w': '420000u', 'l': '150000u'} connections=['d: [connection X0/d =>[signal: VPWR w=1]]', 'g: [connection X0/g =>[signal: S w=1]]', 's: [connection X0/s =>[signal: a_218_374# w=1]]', 'b: [connection X0/b =>[signal: VPB w=1]]']]
X_X_50__0 VPWR _53_/S X_50__a_218_374# VPWR sky130_fd_pr__pfet_01v8_hvt w=420000u l=150000u
** [instance X1 of sky130_fd_pr__nfet_01v8, params={'w': '420000u', 'l': '150000u'} connections=['d: [connection X1/d =>[signal: a_76_199# w=1]]', 'g: [connection X1/g =>[signal: A0 w=1]]', 's: [connection X1/s =>[signal: a_439_47# w=1]]', 'b: [connection X1/b =>[signal: VNB w=1]]']]
X_X_50__1 X_50__a_76_199# _50_/A0 X_50__a_439_47# VGND sky130_fd_pr__nfet_01v8 w=420000u l=150000u
** [instance X2 of sky130_fd_pr__pfet_01v8_hvt, params={'w': '420000u', 'l': '150000u'} connections=['d: [connection X2/d =>[signal: a_535_374# w=1]]', 'g: [connection X2/g =>[signal: a_505_21# w=1]]', 's: [connection X2/s =>[signal: VPWR w=1]]', 'b: [connection X2/b =>[signal: VPB w=1]]']]
X_X_50__2 X_50__a_535_374# X_50__a_505_21# VPWR VPWR sky130_fd_pr__pfet_01v8_hvt w=420000u l=150000u
** [instance X3 of sky130_fd_pr__pfet_01v8_hvt, params={'w': '420000u', 'l': '150000u'} connections=['d: [connection X3/d =>[signal: VPWR w=1]]', 'g: [connection X3/g =>[signal: S w=1]]', 's: [connection X3/s =>[signal: a_505_21# w=1]]', 'b: [connection X3/b =>[signal: VPB w=1]]']]
X_X_50__3 VPWR _53_/S X_50__a_505_21# VPWR sky130_fd_pr__pfet_01v8_hvt w=420000u l=150000u
** [instance X4 of sky130_fd_pr__pfet_01v8_hvt, params={'w': '420000u', 'l': '150000u'} connections=['d: [connection X4/d =>[signal: a_76_199# w=1]]', 'g: [connection X4/g =>[signal: A1 w=1]]', 's: [connection X4/s =>[signal: a_535_374# w=1]]', 'b: [connection X4/b =>[signal: VPB w=1]]']]
X_X_50__4 X_50__a_76_199# _51_/A0 X_50__a_535_374# VPWR sky130_fd_pr__pfet_01v8_hvt w=420000u l=150000u
** [instance X5 of sky130_fd_pr__nfet_01v8, params={'w': '420000u', 'l': '150000u'} connections=['d: [connection X5/d =>[signal: a_218_47# w=1]]', 'g: [connection X5/g =>[signal: A1 w=1]]', 's: [connection X5/s =>[signal: a_76_199# w=1]]', 'b: [connection X5/b =>[signal: VNB w=1]]']]
X_X_50__5 X_50__a_218_47# _51_/A0 X_50__a_76_199# VGND sky130_fd_pr__nfet_01v8 w=420000u l=150000u
** [instance X6 of sky130_fd_pr__pfet_01v8_hvt, params={'w': '420000u', 'l': '150000u'} connections=['d: [connection X6/d =>[signal: a_218_374# w=1]]', 'g: [connection X6/g =>[signal: A0 w=1]]', 's: [connection X6/s =>[signal: a_76_199# w=1]]', 'b: [connection X6/b =>[signal: VPB w=1]]']]
X_X_50__6 X_50__a_218_374# _50_/A0 X_50__a_76_199# VPWR sky130_fd_pr__pfet_01v8_hvt w=420000u l=150000u
** [instance X7 of sky130_fd_pr__nfet_01v8, params={'w': '650000u', 'l': '150000u'} connections=['d: [connection X7/d =>[signal: X w=1]]', 'g: [connection X7/g =>[signal: a_76_199# w=1]]', 's: [connection X7/s =>[signal: VGND w=1]]', 'b: [connection X7/b =>[signal: VNB w=1]]']]
X_X_50__7 _68_/D X_50__a_76_199# VGND VGND sky130_fd_pr__nfet_01v8 w=650000u l=150000u
** [instance X8 of sky130_fd_pr__pfet_01v8_hvt, params={'w': '1e+06u', 'l': '150000u'} connections=['d: [connection X8/d =>[signal: X w=1]]', 'g: [connection X8/g =>[signal: a_76_199# w=1]]', 's: [connection X8/s =>[signal: VPWR w=1]]', 'b: [connection X8/b =>[signal: VPB w=1]]']]
X_X_50__8 _68_/D X_50__a_76_199# VPWR VPWR sky130_fd_pr__pfet_01v8_hvt w=1e+06u l=150000u
** [instance X9 of sky130_fd_pr__nfet_01v8, params={'w': '420000u', 'l': '150000u'} connections=['d: [connection X9/d =>[signal: VGND w=1]]', 'g: [connection X9/g =>[signal: S w=1]]', 's: [connection X9/s =>[signal: a_218_47# w=1]]', 'b: [connection X9/b =>[signal: VNB w=1]]']]
X_X_50__9 VGND _53_/S X_50__a_218_47# VGND sky130_fd_pr__nfet_01v8 w=420000u l=150000u
** [instance X10 of sky130_fd_pr__nfet_01v8, params={'w': '420000u', 'l': '150000u'} connections=['d: [connection X10/d =>[signal: VGND w=1]]', 'g: [connection X10/g =>[signal: S w=1]]', 's: [connection X10/s =>[signal: a_505_21# w=1]]', 'b: [connection X10/b =>[signal: VNB w=1]]']]
X_X_50__10 VGND _53_/S X_50__a_505_21# VGND sky130_fd_pr__nfet_01v8 w=420000u l=150000u
** [instance X11 of sky130_fd_pr__nfet_01v8, params={'w': '420000u', 'l': '150000u'} connections=['d: [connection X11/d =>[signal: a_439_47# w=1]]', 'g: [connection X11/g =>[signal: a_505_21# w=1]]', 's: [connection X11/s =>[signal: VGND w=1]]', 'b: [connection X11/b =>[signal: VNB w=1]]']]
X_X_50__11 X_50__a_439_47# X_50__a_505_21# VGND VGND sky130_fd_pr__nfet_01v8 w=420000u l=150000u

** replacing XPHY_EDGE_ROW_3_Right_3 with the contents of sky130_fd_sc_hd__decap_3
** [instance X0 of sky130_fd_pr__pfet_01v8_hvt, params={'w': '870000u', 'l': '590000u'} connections=['d: [connection X0/d =>[signal: VPWR w=1]]', 'g: [connection X0/g =>[signal: VGND w=1]]', 's: [connection X0/s =>[signal: VPWR w=1]]', 'b: [connection X0/b =>[signal: VPB w=1]]']]
X_XPHY_EDGE_ROW_3_Right_3_0 VPWR VGND VPWR VPWR sky130_fd_pr__pfet_01v8_hvt w=870000u l=590000u
** [instance X1 of sky130_fd_pr__nfet_01v8, params={'w': '550000u', 'l': '590000u'} connections=['d: [connection X1/d =>[signal: VGND w=1]]', 'g: [connection X1/g =>[signal: VPWR w=1]]', 's: [connection X1/s =>[signal: VGND w=1]]', 'b: [connection X1/b =>[signal: VNB w=1]]']]
X_XPHY_EDGE_ROW_3_Right_3_1 VGND VPWR VGND VGND sky130_fd_pr__nfet_01v8 w=550000u l=590000u

** replacing XFILLER_11_46 with the contents of sky130_fd_sc_hd__fill_1

** replacing X_32_ with the contents of sky130_fd_sc_hd__or2_2
** [instance X0 of sky130_fd_pr__pfet_01v8_hvt, params={'w': '420000u', 'l': '150000u'} connections=['d: [connection X0/d =>[signal: a_39_297# w=1]]', 'g: [connection X0/g =>[signal: B w=1]]', 's: [connection X0/s =>[signal: a_121_297# w=1]]', 'b: [connection X0/b =>[signal: VPB w=1]]']]
X_X_32__0 X_32__a_39_297# _32_/B X_32__a_121_297# VPWR sky130_fd_pr__pfet_01v8_hvt w=420000u l=150000u
** [instance X1 of sky130_fd_pr__pfet_01v8_hvt, params={'w': '1e+06u', 'l': '150000u'} connections=['d: [connection X1/d =>[signal: X w=1]]', 'g: [connection X1/g =>[signal: a_39_297# w=1]]', 's: [connection X1/s =>[signal: VPWR w=1]]', 'b: [connection X1/b =>[signal: VPB w=1]]']]
X_X_32__1 _32_/X X_32__a_39_297# VPWR VPWR sky130_fd_pr__pfet_01v8_hvt w=1e+06u l=150000u
** [instance X2 of sky130_fd_pr__nfet_01v8, params={'w': '650000u', 'l': '150000u'} connections=['d: [connection X2/d =>[signal: VGND w=1]]', 'g: [connection X2/g =>[signal: a_39_297# w=1]]', 's: [connection X2/s =>[signal: X w=1]]', 'b: [connection X2/b =>[signal: VNB w=1]]']]
X_X_32__2 VGND X_32__a_39_297# _32_/X VGND sky130_fd_pr__nfet_01v8 w=650000u l=150000u
** [instance X3 of sky130_fd_pr__pfet_01v8_hvt, params={'w': '1e+06u', 'l': '150000u'} connections=['d: [connection X3/d =>[signal: VPWR w=1]]', 'g: [connection X3/g =>[signal: a_39_297# w=1]]', 's: [connection X3/s =>[signal: X w=1]]', 'b: [connection X3/b =>[signal: VPB w=1]]']]
X_X_32__3 VPWR X_32__a_39_297# _32_/X VPWR sky130_fd_pr__pfet_01v8_hvt w=1e+06u l=150000u
** [instance X4 of sky130_fd_pr__nfet_01v8, params={'w': '420000u', 'l': '150000u'} connections=['d: [connection X4/d =>[signal: a_39_297# w=1]]', 'g: [connection X4/g =>[signal: A w=1]]', 's: [connection X4/s =>[signal: VGND w=1]]', 'b: [connection X4/b =>[signal: VNB w=1]]']]
X_X_32__4 X_32__a_39_297# _37_/S VGND VGND sky130_fd_pr__nfet_01v8 w=420000u l=150000u
** [instance X5 of sky130_fd_pr__nfet_01v8, params={'w': '420000u', 'l': '150000u'} connections=['d: [connection X5/d =>[signal: VGND w=1]]', 'g: [connection X5/g =>[signal: B w=1]]', 's: [connection X5/s =>[signal: a_39_297# w=1]]', 'b: [connection X5/b =>[signal: VNB w=1]]']]
X_X_32__5 VGND _32_/B X_32__a_39_297# VGND sky130_fd_pr__nfet_01v8 w=420000u l=150000u
** [instance X6 of sky130_fd_pr__pfet_01v8_hvt, params={'w': '420000u', 'l': '150000u'} connections=['d: [connection X6/d =>[signal: a_121_297# w=1]]', 'g: [connection X6/g =>[signal: A w=1]]', 's: [connection X6/s =>[signal: VPWR w=1]]', 'b: [connection X6/b =>[signal: VPB w=1]]']]
X_X_32__6 X_32__a_121_297# _37_/S VPWR VPWR sky130_fd_pr__pfet_01v8_hvt w=420000u l=150000u
** [instance X7 of sky130_fd_pr__nfet_01v8, params={'w': '650000u', 'l': '150000u'} connections=['d: [connection X7/d =>[signal: X w=1]]', 'g: [connection X7/g =>[signal: a_39_297# w=1]]', 's: [connection X7/s =>[signal: VGND w=1]]', 'b: [connection X7/b =>[signal: VNB w=1]]']]
X_X_32__7 _32_/X X_32__a_39_297# VGND VGND sky130_fd_pr__nfet_01v8 w=650000u l=150000u

** replacing XTAP_TAPCELL_ROW_7_36 with the contents of sky130_fd_sc_hd__tapvpwrvgnd_1

** replacing XPHY_EDGE_ROW_13_Right_13 with the contents of sky130_fd_sc_hd__decap_3
** [instance X0 of sky130_fd_pr__pfet_01v8_hvt, params={'w': '870000u', 'l': '590000u'} connections=['d: [connection X0/d =>[signal: VPWR w=1]]', 'g: [connection X0/g =>[signal: VGND w=1]]', 's: [connection X0/s =>[signal: VPWR w=1]]', 'b: [connection X0/b =>[signal: VPB w=1]]']]
X_XPHY_EDGE_ROW_13_Right_13_0 VPWR VGND VPWR VPWR sky130_fd_pr__pfet_01v8_hvt w=870000u l=590000u
** [instance X1 of sky130_fd_pr__nfet_01v8, params={'w': '550000u', 'l': '590000u'} connections=['d: [connection X1/d =>[signal: VGND w=1]]', 'g: [connection X1/g =>[signal: VPWR w=1]]', 's: [connection X1/s =>[signal: VGND w=1]]', 'b: [connection X1/b =>[signal: VNB w=1]]']]
X_XPHY_EDGE_ROW_13_Right_13_1 VGND VPWR VGND VGND sky130_fd_pr__nfet_01v8 w=550000u l=590000u

** replacing X_31_ with the contents of sky130_fd_sc_hd__mux4_2
** [instance X0 of sky130_fd_pr__pfet_01v8_hvt, params={'w': '640000u', 'l': '150000u'} connections=['d: [connection X0/d =>[signal: VPWR w=1]]', 'g: [connection X0/g =>[signal: A1 w=1]]', 's: [connection X0/s =>[signal: a_1060_369# w=1]]', 'b: [connection X0/b =>[signal: VPB w=1]]']]
X_X_31__0 VPWR _65_/Q X_31__a_1060_369# VPWR sky130_fd_pr__pfet_01v8_hvt w=640000u l=150000u
** [instance X1 of sky130_fd_pr__nfet_01v8, params={'w': '360000u', 'l': '150000u'} connections=['d: [connection X1/d =>[signal: a_193_47# w=1]]', 'g: [connection X1/g =>[signal: a_27_47# w=1]]', 's: [connection X1/s =>[signal: a_288_47# w=1]]', 'b: [connection X1/b =>[signal: VNB w=1]]']]
X_X_31__1 X_31__a_193_47# X_31__a_27_47# X_31__a_288_47# VGND sky130_fd_pr__nfet_01v8 w=360000u l=150000u
** [instance X2 of sky130_fd_pr__pfet_01v8_hvt, params={'w': '1e+06u', 'l': '150000u'} connections=['d: [connection X2/d =>[signal: VPWR w=1]]', 'g: [connection X2/g =>[signal: a_788_316# w=1]]', 's: [connection X2/s =>[signal: X w=1]]', 'b: [connection X2/b =>[signal: VPB w=1]]']]
X_X_31__2 VPWR X_31__a_788_316# _32_/B VPWR sky130_fd_pr__pfet_01v8_hvt w=1e+06u l=150000u
** [instance X3 of sky130_fd_pr__pfet_01v8_hvt, params={'w': '640000u', 'l': '150000u'} connections=['d: [connection X3/d =>[signal: a_1279_413# w=1]]', 'g: [connection X3/g =>[signal: A0 w=1]]', 's: [connection X3/s =>[signal: VPWR w=1]]', 'b: [connection X3/b =>[signal: VPB w=1]]']]
X_X_31__3 X_31__a_1279_413# _66_/Q VPWR VPWR sky130_fd_pr__pfet_01v8_hvt w=640000u l=150000u
** [instance X4 of sky130_fd_pr__nfet_01v8, params={'w': '650000u', 'l': '150000u'} connections=['d: [connection X4/d =>[signal: VGND w=1]]', 'g: [connection X4/g =>[signal: a_788_316# w=1]]', 's: [connection X4/s =>[signal: X w=1]]', 'b: [connection X4/b =>[signal: VNB w=1]]']]
X_X_31__4 VGND X_31__a_788_316# _32_/B VGND sky130_fd_pr__nfet_01v8 w=650000u l=150000u
** [instance X5 of sky130_fd_pr__pfet_01v8_hvt, params={'w': '1e+06u', 'l': '150000u'} connections=['d: [connection X5/d =>[signal: X w=1]]', 'g: [connection X5/g =>[signal: a_788_316# w=1]]', 's: [connection X5/s =>[signal: VPWR w=1]]', 'b: [connection X5/b =>[signal: VPB w=1]]']]
X_X_31__5 _32_/B X_31__a_788_316# VPWR VPWR sky130_fd_pr__pfet_01v8_hvt w=1e+06u l=150000u
** [instance X6 of sky130_fd_pr__nfet_01v8, params={'w': '420000u', 'l': '150000u'} connections=['d: [connection X6/d =>[signal: a_288_47# w=1]]', 'g: [connection X6/g =>[signal: S1 w=1]]', 's: [connection X6/s =>[signal: a_788_316# w=1]]', 'b: [connection X6/b =>[signal: VNB w=1]]']]
X_X_31__6 X_31__a_288_47# _36_/S1 X_31__a_788_316# VGND sky130_fd_pr__nfet_01v8 w=420000u l=150000u
** [instance X7 of sky130_fd_pr__pfet_01v8_hvt, params={'w': '420000u', 'l': '150000u'} connections=['d: [connection X7/d =>[signal: a_193_369# w=1]]', 'g: [connection X7/g =>[signal: S0 w=1]]', 's: [connection X7/s =>[signal: a_288_47# w=1]]', 'b: [connection X7/b =>[signal: VPB w=1]]']]
X_X_31__7 X_31__a_193_369# _36_/S0 X_31__a_288_47# VPWR sky130_fd_pr__pfet_01v8_hvt w=420000u l=150000u
** [instance X8 of sky130_fd_pr__pfet_01v8_hvt, params={'w': '640000u', 'l': '150000u'} connections=['d: [connection X8/d =>[signal: a_372_413# w=1]]', 'g: [connection X8/g =>[signal: A3 w=1]]', 's: [connection X8/s =>[signal: VPWR w=1]]', 'b: [connection X8/b =>[signal: VPB w=1]]']]
X_X_31__8 X_31__a_372_413# _63_/Q VPWR VPWR sky130_fd_pr__pfet_01v8_hvt w=640000u l=150000u
** [instance X9 of sky130_fd_pr__nfet_01v8, params={'w': '360000u', 'l': '150000u'} connections=['d: [connection X9/d =>[signal: a_872_316# w=1]]', 'g: [connection X9/g =>[signal: a_27_47# w=1]]', 's: [connection X9/s =>[signal: a_1281_47# w=1]]', 'b: [connection X9/b =>[signal: VNB w=1]]']]
X_X_31__9 X_31__a_872_316# X_31__a_27_47# X_31__a_1281_47# VGND sky130_fd_pr__nfet_01v8 w=360000u l=150000u
** [instance X10 of sky130_fd_pr__pfet_01v8_hvt, params={'w': '420000u', 'l': '150000u'} connections=['d: [connection X10/d =>[signal: a_288_47# w=1]]', 'g: [connection X10/g =>[signal: a_27_47# w=1]]', 's: [connection X10/s =>[signal: a_372_413# w=1]]', 'b: [connection X10/b =>[signal: VPB w=1]]']]
X_X_31__10 X_31__a_288_47# X_31__a_27_47# X_31__a_372_413# VPWR sky130_fd_pr__pfet_01v8_hvt w=420000u l=150000u
** [instance X11 of sky130_fd_pr__nfet_01v8, params={'w': '420000u', 'l': '150000u'} connections=['d: [connection X11/d =>[signal: VGND w=1]]', 'g: [connection X11/g =>[signal: A1 w=1]]', 's: [connection X11/s =>[signal: a_1064_47# w=1]]', 'b: [connection X11/b =>[signal: VNB w=1]]']]
X_X_31__11 VGND _65_/Q X_31__a_1064_47# VGND sky130_fd_pr__nfet_01v8 w=420000u l=150000u
** [instance X12 of sky130_fd_pr__pfet_01v8_hvt, params={'w': '640000u', 'l': '150000u'} connections=['d: [connection X12/d =>[signal: VPWR w=1]]', 'g: [connection X12/g =>[signal: S1 w=1]]', 's: [connection X12/s =>[signal: a_600_345# w=1]]', 'b: [connection X12/b =>[signal: VPB w=1]]']]
X_X_31__12 VPWR _36_/S1 X_31__a_600_345# VPWR sky130_fd_pr__pfet_01v8_hvt w=640000u l=150000u
** [instance X13 of sky130_fd_pr__pfet_01v8_hvt, params={'w': '420000u', 'l': '150000u'} connections=['d: [connection X13/d =>[signal: a_872_316# w=1]]', 'g: [connection X13/g =>[signal: S0 w=1]]', 's: [connection X13/s =>[signal: a_1279_413# w=1]]', 'b: [connection X13/b =>[signal: VPB w=1]]']]
X_X_31__13 X_31__a_872_316# _36_/S0 X_31__a_1279_413# VPWR sky130_fd_pr__pfet_01v8_hvt w=420000u l=150000u
** [instance X14 of sky130_fd_pr__pfet_01v8_hvt, params={'w': '640000u', 'l': '150000u'} connections=['d: [connection X14/d =>[signal: a_27_47# w=1]]', 'g: [connection X14/g =>[signal: S0 w=1]]', 's: [connection X14/s =>[signal: VPWR w=1]]', 'b: [connection X14/b =>[signal: VPB w=1]]']]
X_X_31__14 X_31__a_27_47# _36_/S0 VPWR VPWR sky130_fd_pr__pfet_01v8_hvt w=640000u l=150000u
** [instance X15 of sky130_fd_pr__pfet_01v8_hvt, params={'w': '640000u', 'l': '150000u'} connections=['d: [connection X15/d =>[signal: VPWR w=1]]', 'g: [connection X15/g =>[signal: A2 w=1]]', 's: [connection X15/s =>[signal: a_193_369# w=1]]', 'b: [connection X15/b =>[signal: VPB w=1]]']]
X_X_31__15 VPWR _64_/Q X_31__a_193_369# VPWR sky130_fd_pr__pfet_01v8_hvt w=640000u l=150000u
** [instance X16 of sky130_fd_pr__nfet_01v8, params={'w': '420000u', 'l': '150000u'} connections=['d: [connection X16/d =>[signal: VGND w=1]]', 'g: [connection X16/g =>[signal: A2 w=1]]', 's: [connection X16/s =>[signal: a_193_47# w=1]]', 'b: [connection X16/b =>[signal: VNB w=1]]']]
X_X_31__16 VGND _64_/Q X_31__a_193_47# VGND sky130_fd_pr__nfet_01v8 w=420000u l=150000u
** [instance X17 of sky130_fd_pr__pfet_01v8_hvt, params={'w': '540000u', 'l': '150000u'} connections=['d: [connection X17/d =>[signal: a_288_47# w=1]]', 'g: [connection X17/g =>[signal: a_600_345# w=1]]', 's: [connection X17/s =>[signal: a_788_316# w=1]]', 'b: [connection X17/b =>[signal: VPB w=1]]']]
X_X_31__17 X_31__a_288_47# X_31__a_600_345# X_31__a_788_316# VPWR sky130_fd_pr__pfet_01v8_hvt w=540000u l=150000u
** [instance X18 of sky130_fd_pr__nfet_01v8, params={'w': '420000u', 'l': '150000u'} connections=['d: [connection X18/d =>[signal: a_397_47# w=1]]', 'g: [connection X18/g =>[signal: A3 w=1]]', 's: [connection X18/s =>[signal: VGND w=1]]', 'b: [connection X18/b =>[signal: VNB w=1]]']]
X_X_31__18 X_31__a_397_47# _63_/Q VGND VGND sky130_fd_pr__nfet_01v8 w=420000u l=150000u
** [instance X19 of sky130_fd_pr__nfet_01v8, params={'w': '420000u', 'l': '150000u'} connections=['d: [connection X19/d =>[signal: a_27_47# w=1]]', 'g: [connection X19/g =>[signal: S0 w=1]]', 's: [connection X19/s =>[signal: VGND w=1]]', 'b: [connection X19/b =>[signal: VNB w=1]]']]
X_X_31__19 X_31__a_27_47# _36_/S0 VGND VGND sky130_fd_pr__nfet_01v8 w=420000u l=150000u
** [instance X20 of sky130_fd_pr__pfet_01v8_hvt, params={'w': '420000u', 'l': '150000u'} connections=['d: [connection X20/d =>[signal: a_1060_369# w=1]]', 'g: [connection X20/g =>[signal: a_27_47# w=1]]', 's: [connection X20/s =>[signal: a_872_316# w=1]]', 'b: [connection X20/b =>[signal: VPB w=1]]']]
X_X_31__20 X_31__a_1060_369# X_31__a_27_47# X_31__a_872_316# VPWR sky130_fd_pr__pfet_01v8_hvt w=420000u l=150000u
** [instance X21 of sky130_fd_pr__nfet_01v8, params={'w': '420000u', 'l': '150000u'} connections=['d: [connection X21/d =>[signal: VGND w=1]]', 'g: [connection X21/g =>[signal: S1 w=1]]', 's: [connection X21/s =>[signal: a_600_345# w=1]]', 'b: [connection X21/b =>[signal: VNB w=1]]']]
X_X_31__21 VGND _36_/S1 X_31__a_600_345# VGND sky130_fd_pr__nfet_01v8 w=420000u l=150000u
** [instance X22 of sky130_fd_pr__nfet_01v8, params={'w': '420000u', 'l': '150000u'} connections=['d: [connection X22/d =>[signal: a_1281_47# w=1]]', 'g: [connection X22/g =>[signal: A0 w=1]]', 's: [connection X22/s =>[signal: VGND w=1]]', 'b: [connection X22/b =>[signal: VNB w=1]]']]
X_X_31__22 X_31__a_1281_47# _66_/Q VGND VGND sky130_fd_pr__nfet_01v8 w=420000u l=150000u
** [instance X23 of sky130_fd_pr__nfet_01v8, params={'w': '650000u', 'l': '150000u'} connections=['d: [connection X23/d =>[signal: X w=1]]', 'g: [connection X23/g =>[signal: a_788_316# w=1]]', 's: [connection X23/s =>[signal: VGND w=1]]', 'b: [connection X23/b =>[signal: VNB w=1]]']]
X_X_31__23 _32_/B X_31__a_788_316# VGND VGND sky130_fd_pr__nfet_01v8 w=650000u l=150000u
** [instance X24 of sky130_fd_pr__nfet_01v8, params={'w': '360000u', 'l': '150000u'} connections=['d: [connection X24/d =>[signal: a_288_47# w=1]]', 'g: [connection X24/g =>[signal: S0 w=1]]', 's: [connection X24/s =>[signal: a_397_47# w=1]]', 'b: [connection X24/b =>[signal: VNB w=1]]']]
X_X_31__24 X_31__a_288_47# _36_/S0 X_31__a_397_47# VGND sky130_fd_pr__nfet_01v8 w=360000u l=150000u
** [instance X25 of sky130_fd_pr__pfet_01v8_hvt, params={'w': '540000u', 'l': '150000u'} connections=['d: [connection X25/d =>[signal: a_788_316# w=1]]', 'g: [connection X25/g =>[signal: S1 w=1]]', 's: [connection X25/s =>[signal: a_872_316# w=1]]', 'b: [connection X25/b =>[signal: VPB w=1]]']]
X_X_31__25 X_31__a_788_316# _36_/S1 X_31__a_872_316# VPWR sky130_fd_pr__pfet_01v8_hvt w=540000u l=150000u
** [instance X26 of sky130_fd_pr__nfet_01v8, params={'w': '420000u', 'l': '150000u'} connections=['d: [connection X26/d =>[signal: a_788_316# w=1]]', 'g: [connection X26/g =>[signal: a_600_345# w=1]]', 's: [connection X26/s =>[signal: a_872_316# w=1]]', 'b: [connection X26/b =>[signal: VNB w=1]]']]
X_X_31__26 X_31__a_788_316# X_31__a_600_345# X_31__a_872_316# VGND sky130_fd_pr__nfet_01v8 w=420000u l=150000u
** [instance X27 of sky130_fd_pr__nfet_01v8, params={'w': '360000u', 'l': '150000u'} connections=['d: [connection X27/d =>[signal: a_1064_47# w=1]]', 'g: [connection X27/g =>[signal: S0 w=1]]', 's: [connection X27/s =>[signal: a_872_316# w=1]]', 'b: [connection X27/b =>[signal: VNB w=1]]']]
X_X_31__27 X_31__a_1064_47# _36_/S0 X_31__a_872_316# VGND sky130_fd_pr__nfet_01v8 w=360000u l=150000u

** replacing Xclkbuf_1_1__f_scan_clk with the contents of sky130_fd_sc_hd__clkbuf_16
** [instance X0 of sky130_fd_pr__pfet_01v8_hvt, params={'w': '1e+06u', 'l': '150000u'} connections=['d: [connection X0/d =>[signal: VPWR w=1]]', 'g: [connection X0/g =>[signal: a_110_47# w=1]]', 's: [connection X0/s =>[signal: X w=1]]', 'b: [connection X0/b =>[signal: VPB w=1]]']]
X_Xclkbuf_1_1__f_scan_clk_0 VPWR Xclkbuf_1_1__f_scan_clk_a_110_47# _76_/CLK VPWR sky130_fd_pr__pfet_01v8_hvt w=1e+06u l=150000u
** [instance X1 of sky130_fd_pr__nfet_01v8, params={'w': '420000u', 'l': '150000u'} connections=['d: [connection X1/d =>[signal: X w=1]]', 'g: [connection X1/g =>[signal: a_110_47# w=1]]', 's: [connection X1/s =>[signal: VGND w=1]]', 'b: [connection X1/b =>[signal: VNB w=1]]']]
X_Xclkbuf_1_1__f_scan_clk_1 _76_/CLK Xclkbuf_1_1__f_scan_clk_a_110_47# VGND VGND sky130_fd_pr__nfet_01v8 w=420000u l=150000u
** [instance X2 of sky130_fd_pr__nfet_01v8, params={'w': '420000u', 'l': '150000u'} connections=['d: [connection X2/d =>[signal: X w=1]]', 'g: [connection X2/g =>[signal: a_110_47# w=1]]', 's: [connection X2/s =>[signal: VGND w=1]]', 'b: [connection X2/b =>[signal: VNB w=1]]']]
X_Xclkbuf_1_1__f_scan_clk_2 _76_/CLK Xclkbuf_1_1__f_scan_clk_a_110_47# VGND VGND sky130_fd_pr__nfet_01v8 w=420000u l=150000u
** [instance X3 of sky130_fd_pr__pfet_01v8_hvt, params={'w': '1e+06u', 'l': '150000u'} connections=['d: [connection X3/d =>[signal: a_110_47# w=1]]', 'g: [connection X3/g =>[signal: A w=1]]', 's: [connection X3/s =>[signal: VPWR w=1]]', 'b: [connection X3/b =>[signal: VPB w=1]]']]
X_Xclkbuf_1_1__f_scan_clk_3 Xclkbuf_1_1__f_scan_clk_a_110_47# clkbuf_0_scan_clk/X VPWR VPWR sky130_fd_pr__pfet_01v8_hvt w=1e+06u l=150000u
** [instance X4 of sky130_fd_pr__pfet_01v8_hvt, params={'w': '1e+06u', 'l': '150000u'} connections=['d: [connection X4/d =>[signal: VPWR w=1]]', 'g: [connection X4/g =>[signal: a_110_47# w=1]]', 's: [connection X4/s =>[signal: X w=1]]', 'b: [connection X4/b =>[signal: VPB w=1]]']]
X_Xclkbuf_1_1__f_scan_clk_4 VPWR Xclkbuf_1_1__f_scan_clk_a_110_47# _76_/CLK VPWR sky130_fd_pr__pfet_01v8_hvt w=1e+06u l=150000u
** [instance X5 of sky130_fd_pr__pfet_01v8_hvt, params={'w': '1e+06u', 'l': '150000u'} connections=['d: [connection X5/d =>[signal: X w=1]]', 'g: [connection X5/g =>[signal: a_110_47# w=1]]', 's: [connection X5/s =>[signal: VPWR w=1]]', 'b: [connection X5/b =>[signal: VPB w=1]]']]
X_Xclkbuf_1_1__f_scan_clk_5 _76_/CLK Xclkbuf_1_1__f_scan_clk_a_110_47# VPWR VPWR sky130_fd_pr__pfet_01v8_hvt w=1e+06u l=150000u
** [instance X6 of sky130_fd_pr__nfet_01v8, params={'w': '420000u', 'l': '150000u'} connections=['d: [connection X6/d =>[signal: a_110_47# w=1]]', 'g: [connection X6/g =>[signal: A w=1]]', 's: [connection X6/s =>[signal: VGND w=1]]', 'b: [connection X6/b =>[signal: VNB w=1]]']]
X_Xclkbuf_1_1__f_scan_clk_6 Xclkbuf_1_1__f_scan_clk_a_110_47# clkbuf_0_scan_clk/X VGND VGND sky130_fd_pr__nfet_01v8 w=420000u l=150000u
** [instance X7 of sky130_fd_pr__pfet_01v8_hvt, params={'w': '1e+06u', 'l': '150000u'} connections=['d: [connection X7/d =>[signal: VPWR w=1]]', 'g: [connection X7/g =>[signal: A w=1]]', 's: [connection X7/s =>[signal: a_110_47# w=1]]', 'b: [connection X7/b =>[signal: VPB w=1]]']]
X_Xclkbuf_1_1__f_scan_clk_7 VPWR clkbuf_0_scan_clk/X Xclkbuf_1_1__f_scan_clk_a_110_47# VPWR sky130_fd_pr__pfet_01v8_hvt w=1e+06u l=150000u
** [instance X8 of sky130_fd_pr__nfet_01v8, params={'w': '420000u', 'l': '150000u'} connections=['d: [connection X8/d =>[signal: VGND w=1]]', 'g: [connection X8/g =>[signal: a_110_47# w=1]]', 's: [connection X8/s =>[signal: X w=1]]', 'b: [connection X8/b =>[signal: VNB w=1]]']]
X_Xclkbuf_1_1__f_scan_clk_8 VGND Xclkbuf_1_1__f_scan_clk_a_110_47# _76_/CLK VGND sky130_fd_pr__nfet_01v8 w=420000u l=150000u
** [instance X9 of sky130_fd_pr__nfet_01v8, params={'w': '420000u', 'l': '150000u'} connections=['d: [connection X9/d =>[signal: VGND w=1]]', 'g: [connection X9/g =>[signal: A w=1]]', 's: [connection X9/s =>[signal: a_110_47# w=1]]', 'b: [connection X9/b =>[signal: VNB w=1]]']]
X_Xclkbuf_1_1__f_scan_clk_9 VGND clkbuf_0_scan_clk/X Xclkbuf_1_1__f_scan_clk_a_110_47# VGND sky130_fd_pr__nfet_01v8 w=420000u l=150000u
** [instance X10 of sky130_fd_pr__nfet_01v8, params={'w': '420000u', 'l': '150000u'} connections=['d: [connection X10/d =>[signal: X w=1]]', 'g: [connection X10/g =>[signal: a_110_47# w=1]]', 's: [connection X10/s =>[signal: VGND w=1]]', 'b: [connection X10/b =>[signal: VNB w=1]]']]
X_Xclkbuf_1_1__f_scan_clk_10 _76_/CLK Xclkbuf_1_1__f_scan_clk_a_110_47# VGND VGND sky130_fd_pr__nfet_01v8 w=420000u l=150000u
** [instance X11 of sky130_fd_pr__nfet_01v8, params={'w': '420000u', 'l': '150000u'} connections=['d: [connection X11/d =>[signal: X w=1]]', 'g: [connection X11/g =>[signal: a_110_47# w=1]]', 's: [connection X11/s =>[signal: VGND w=1]]', 'b: [connection X11/b =>[signal: VNB w=1]]']]
X_Xclkbuf_1_1__f_scan_clk_11 _76_/CLK Xclkbuf_1_1__f_scan_clk_a_110_47# VGND VGND sky130_fd_pr__nfet_01v8 w=420000u l=150000u
** [instance X12 of sky130_fd_pr__pfet_01v8_hvt, params={'w': '1e+06u', 'l': '150000u'} connections=['d: [connection X12/d =>[signal: a_110_47# w=1]]', 'g: [connection X12/g =>[signal: A w=1]]', 's: [connection X12/s =>[signal: VPWR w=1]]', 'b: [connection X12/b =>[signal: VPB w=1]]']]
X_Xclkbuf_1_1__f_scan_clk_12 Xclkbuf_1_1__f_scan_clk_a_110_47# clkbuf_0_scan_clk/X VPWR VPWR sky130_fd_pr__pfet_01v8_hvt w=1e+06u l=150000u
** [instance X13 of sky130_fd_pr__pfet_01v8_hvt, params={'w': '1e+06u', 'l': '150000u'} connections=['d: [connection X13/d =>[signal: VPWR w=1]]', 'g: [connection X13/g =>[signal: a_110_47# w=1]]', 's: [connection X13/s =>[signal: X w=1]]', 'b: [connection X13/b =>[signal: VPB w=1]]']]
X_Xclkbuf_1_1__f_scan_clk_13 VPWR Xclkbuf_1_1__f_scan_clk_a_110_47# _76_/CLK VPWR sky130_fd_pr__pfet_01v8_hvt w=1e+06u l=150000u
** [instance X14 of sky130_fd_pr__nfet_01v8, params={'w': '420000u', 'l': '150000u'} connections=['d: [connection X14/d =>[signal: X w=1]]', 'g: [connection X14/g =>[signal: a_110_47# w=1]]', 's: [connection X14/s =>[signal: VGND w=1]]', 'b: [connection X14/b =>[signal: VNB w=1]]']]
X_Xclkbuf_1_1__f_scan_clk_14 _76_/CLK Xclkbuf_1_1__f_scan_clk_a_110_47# VGND VGND sky130_fd_pr__nfet_01v8 w=420000u l=150000u
** [instance X15 of sky130_fd_pr__pfet_01v8_hvt, params={'w': '1e+06u', 'l': '150000u'} connections=['d: [connection X15/d =>[signal: VPWR w=1]]', 'g: [connection X15/g =>[signal: A w=1]]', 's: [connection X15/s =>[signal: a_110_47# w=1]]', 'b: [connection X15/b =>[signal: VPB w=1]]']]
X_Xclkbuf_1_1__f_scan_clk_15 VPWR clkbuf_0_scan_clk/X Xclkbuf_1_1__f_scan_clk_a_110_47# VPWR sky130_fd_pr__pfet_01v8_hvt w=1e+06u l=150000u
** [instance X16 of sky130_fd_pr__nfet_01v8, params={'w': '420000u', 'l': '150000u'} connections=['d: [connection X16/d =>[signal: VGND w=1]]', 'g: [connection X16/g =>[signal: a_110_47# w=1]]', 's: [connection X16/s =>[signal: X w=1]]', 'b: [connection X16/b =>[signal: VNB w=1]]']]
X_Xclkbuf_1_1__f_scan_clk_16 VGND Xclkbuf_1_1__f_scan_clk_a_110_47# _76_/CLK VGND sky130_fd_pr__nfet_01v8 w=420000u l=150000u
** [instance X17 of sky130_fd_pr__nfet_01v8, params={'w': '420000u', 'l': '150000u'} connections=['d: [connection X17/d =>[signal: X w=1]]', 'g: [connection X17/g =>[signal: a_110_47# w=1]]', 's: [connection X17/s =>[signal: VGND w=1]]', 'b: [connection X17/b =>[signal: VNB w=1]]']]
X_Xclkbuf_1_1__f_scan_clk_17 _76_/CLK Xclkbuf_1_1__f_scan_clk_a_110_47# VGND VGND sky130_fd_pr__nfet_01v8 w=420000u l=150000u
** [instance X18 of sky130_fd_pr__nfet_01v8, params={'w': '420000u', 'l': '150000u'} connections=['d: [connection X18/d =>[signal: VGND w=1]]', 'g: [connection X18/g =>[signal: a_110_47# w=1]]', 's: [connection X18/s =>[signal: X w=1]]', 'b: [connection X18/b =>[signal: VNB w=1]]']]
X_Xclkbuf_1_1__f_scan_clk_18 VGND Xclkbuf_1_1__f_scan_clk_a_110_47# _76_/CLK VGND sky130_fd_pr__nfet_01v8 w=420000u l=150000u
** [instance X19 of sky130_fd_pr__nfet_01v8, params={'w': '420000u', 'l': '150000u'} connections=['d: [connection X19/d =>[signal: VGND w=1]]', 'g: [connection X19/g =>[signal: a_110_47# w=1]]', 's: [connection X19/s =>[signal: X w=1]]', 'b: [connection X19/b =>[signal: VNB w=1]]']]
X_Xclkbuf_1_1__f_scan_clk_19 VGND Xclkbuf_1_1__f_scan_clk_a_110_47# _76_/CLK VGND sky130_fd_pr__nfet_01v8 w=420000u l=150000u
** [instance X20 of sky130_fd_pr__pfet_01v8_hvt, params={'w': '1e+06u', 'l': '150000u'} connections=['d: [connection X20/d =>[signal: X w=1]]', 'g: [connection X20/g =>[signal: a_110_47# w=1]]', 's: [connection X20/s =>[signal: VPWR w=1]]', 'b: [connection X20/b =>[signal: VPB w=1]]']]
X_Xclkbuf_1_1__f_scan_clk_20 _76_/CLK Xclkbuf_1_1__f_scan_clk_a_110_47# VPWR VPWR sky130_fd_pr__pfet_01v8_hvt w=1e+06u l=150000u
** [instance X21 of sky130_fd_pr__pfet_01v8_hvt, params={'w': '1e+06u', 'l': '150000u'} connections=['d: [connection X21/d =>[signal: X w=1]]', 'g: [connection X21/g =>[signal: a_110_47# w=1]]', 's: [connection X21/s =>[signal: VPWR w=1]]', 'b: [connection X21/b =>[signal: VPB w=1]]']]
X_Xclkbuf_1_1__f_scan_clk_21 _76_/CLK Xclkbuf_1_1__f_scan_clk_a_110_47# VPWR VPWR sky130_fd_pr__pfet_01v8_hvt w=1e+06u l=150000u
** [instance X22 of sky130_fd_pr__pfet_01v8_hvt, params={'w': '1e+06u', 'l': '150000u'} connections=['d: [connection X22/d =>[signal: X w=1]]', 'g: [connection X22/g =>[signal: a_110_47# w=1]]', 's: [connection X22/s =>[signal: VPWR w=1]]', 'b: [connection X22/b =>[signal: VPB w=1]]']]
X_Xclkbuf_1_1__f_scan_clk_22 _76_/CLK Xclkbuf_1_1__f_scan_clk_a_110_47# VPWR VPWR sky130_fd_pr__pfet_01v8_hvt w=1e+06u l=150000u
** [instance X23 of sky130_fd_pr__pfet_01v8_hvt, params={'w': '1e+06u', 'l': '150000u'} connections=['d: [connection X23/d =>[signal: VPWR w=1]]', 'g: [connection X23/g =>[signal: a_110_47# w=1]]', 's: [connection X23/s =>[signal: X w=1]]', 'b: [connection X23/b =>[signal: VPB w=1]]']]
X_Xclkbuf_1_1__f_scan_clk_23 VPWR Xclkbuf_1_1__f_scan_clk_a_110_47# _76_/CLK VPWR sky130_fd_pr__pfet_01v8_hvt w=1e+06u l=150000u
** [instance X24 of sky130_fd_pr__pfet_01v8_hvt, params={'w': '1e+06u', 'l': '150000u'} connections=['d: [connection X24/d =>[signal: VPWR w=1]]', 'g: [connection X24/g =>[signal: a_110_47# w=1]]', 's: [connection X24/s =>[signal: X w=1]]', 'b: [connection X24/b =>[signal: VPB w=1]]']]
X_Xclkbuf_1_1__f_scan_clk_24 VPWR Xclkbuf_1_1__f_scan_clk_a_110_47# _76_/CLK VPWR sky130_fd_pr__pfet_01v8_hvt w=1e+06u l=150000u
** [instance X25 of sky130_fd_pr__nfet_01v8, params={'w': '420000u', 'l': '150000u'} connections=['d: [connection X25/d =>[signal: VGND w=1]]', 'g: [connection X25/g =>[signal: a_110_47# w=1]]', 's: [connection X25/s =>[signal: X w=1]]', 'b: [connection X25/b =>[signal: VNB w=1]]']]
X_Xclkbuf_1_1__f_scan_clk_25 VGND Xclkbuf_1_1__f_scan_clk_a_110_47# _76_/CLK VGND sky130_fd_pr__nfet_01v8 w=420000u l=150000u
** [instance X26 of sky130_fd_pr__pfet_01v8_hvt, params={'w': '1e+06u', 'l': '150000u'} connections=['d: [connection X26/d =>[signal: X w=1]]', 'g: [connection X26/g =>[signal: a_110_47# w=1]]', 's: [connection X26/s =>[signal: VPWR w=1]]', 'b: [connection X26/b =>[signal: VPB w=1]]']]
X_Xclkbuf_1_1__f_scan_clk_26 _76_/CLK Xclkbuf_1_1__f_scan_clk_a_110_47# VPWR VPWR sky130_fd_pr__pfet_01v8_hvt w=1e+06u l=150000u
** [instance X27 of sky130_fd_pr__nfet_01v8, params={'w': '420000u', 'l': '150000u'} connections=['d: [connection X27/d =>[signal: X w=1]]', 'g: [connection X27/g =>[signal: a_110_47# w=1]]', 's: [connection X27/s =>[signal: VGND w=1]]', 'b: [connection X27/b =>[signal: VNB w=1]]']]
X_Xclkbuf_1_1__f_scan_clk_27 _76_/CLK Xclkbuf_1_1__f_scan_clk_a_110_47# VGND VGND sky130_fd_pr__nfet_01v8 w=420000u l=150000u
** [instance X28 of sky130_fd_pr__pfet_01v8_hvt, params={'w': '1e+06u', 'l': '150000u'} connections=['d: [connection X28/d =>[signal: VPWR w=1]]', 'g: [connection X28/g =>[signal: a_110_47# w=1]]', 's: [connection X28/s =>[signal: X w=1]]', 'b: [connection X28/b =>[signal: VPB w=1]]']]
X_Xclkbuf_1_1__f_scan_clk_28 VPWR Xclkbuf_1_1__f_scan_clk_a_110_47# _76_/CLK VPWR sky130_fd_pr__pfet_01v8_hvt w=1e+06u l=150000u
** [instance X29 of sky130_fd_pr__nfet_01v8, params={'w': '420000u', 'l': '150000u'} connections=['d: [connection X29/d =>[signal: VGND w=1]]', 'g: [connection X29/g =>[signal: a_110_47# w=1]]', 's: [connection X29/s =>[signal: X w=1]]', 'b: [connection X29/b =>[signal: VNB w=1]]']]
X_Xclkbuf_1_1__f_scan_clk_29 VGND Xclkbuf_1_1__f_scan_clk_a_110_47# _76_/CLK VGND sky130_fd_pr__nfet_01v8 w=420000u l=150000u
** [instance X30 of sky130_fd_pr__nfet_01v8, params={'w': '420000u', 'l': '150000u'} connections=['d: [connection X30/d =>[signal: X w=1]]', 'g: [connection X30/g =>[signal: a_110_47# w=1]]', 's: [connection X30/s =>[signal: VGND w=1]]', 'b: [connection X30/b =>[signal: VNB w=1]]']]
X_Xclkbuf_1_1__f_scan_clk_30 _76_/CLK Xclkbuf_1_1__f_scan_clk_a_110_47# VGND VGND sky130_fd_pr__nfet_01v8 w=420000u l=150000u
** [instance X31 of sky130_fd_pr__pfet_01v8_hvt, params={'w': '1e+06u', 'l': '150000u'} connections=['d: [connection X31/d =>[signal: X w=1]]', 'g: [connection X31/g =>[signal: a_110_47# w=1]]', 's: [connection X31/s =>[signal: VPWR w=1]]', 'b: [connection X31/b =>[signal: VPB w=1]]']]
X_Xclkbuf_1_1__f_scan_clk_31 _76_/CLK Xclkbuf_1_1__f_scan_clk_a_110_47# VPWR VPWR sky130_fd_pr__pfet_01v8_hvt w=1e+06u l=150000u
** [instance X32 of sky130_fd_pr__pfet_01v8_hvt, params={'w': '1e+06u', 'l': '150000u'} connections=['d: [connection X32/d =>[signal: X w=1]]', 'g: [connection X32/g =>[signal: a_110_47# w=1]]', 's: [connection X32/s =>[signal: VPWR w=1]]', 'b: [connection X32/b =>[signal: VPB w=1]]']]
X_Xclkbuf_1_1__f_scan_clk_32 _76_/CLK Xclkbuf_1_1__f_scan_clk_a_110_47# VPWR VPWR sky130_fd_pr__pfet_01v8_hvt w=1e+06u l=150000u
** [instance X33 of sky130_fd_pr__pfet_01v8_hvt, params={'w': '1e+06u', 'l': '150000u'} connections=['d: [connection X33/d =>[signal: X w=1]]', 'g: [connection X33/g =>[signal: a_110_47# w=1]]', 's: [connection X33/s =>[signal: VPWR w=1]]', 'b: [connection X33/b =>[signal: VPB w=1]]']]
X_Xclkbuf_1_1__f_scan_clk_33 _76_/CLK Xclkbuf_1_1__f_scan_clk_a_110_47# VPWR VPWR sky130_fd_pr__pfet_01v8_hvt w=1e+06u l=150000u
** [instance X34 of sky130_fd_pr__nfet_01v8, params={'w': '420000u', 'l': '150000u'} connections=['d: [connection X34/d =>[signal: a_110_47# w=1]]', 'g: [connection X34/g =>[signal: A w=1]]', 's: [connection X34/s =>[signal: VGND w=1]]', 'b: [connection X34/b =>[signal: VNB w=1]]']]
X_Xclkbuf_1_1__f_scan_clk_34 Xclkbuf_1_1__f_scan_clk_a_110_47# clkbuf_0_scan_clk/X VGND VGND sky130_fd_pr__nfet_01v8 w=420000u l=150000u
** [instance X35 of sky130_fd_pr__pfet_01v8_hvt, params={'w': '1e+06u', 'l': '150000u'} connections=['d: [connection X35/d =>[signal: VPWR w=1]]', 'g: [connection X35/g =>[signal: a_110_47# w=1]]', 's: [connection X35/s =>[signal: X w=1]]', 'b: [connection X35/b =>[signal: VPB w=1]]']]
X_Xclkbuf_1_1__f_scan_clk_35 VPWR Xclkbuf_1_1__f_scan_clk_a_110_47# _76_/CLK VPWR sky130_fd_pr__pfet_01v8_hvt w=1e+06u l=150000u
** [instance X36 of sky130_fd_pr__nfet_01v8, params={'w': '420000u', 'l': '150000u'} connections=['d: [connection X36/d =>[signal: VGND w=1]]', 'g: [connection X36/g =>[signal: A w=1]]', 's: [connection X36/s =>[signal: a_110_47# w=1]]', 'b: [connection X36/b =>[signal: VNB w=1]]']]
X_Xclkbuf_1_1__f_scan_clk_36 VGND clkbuf_0_scan_clk/X Xclkbuf_1_1__f_scan_clk_a_110_47# VGND sky130_fd_pr__nfet_01v8 w=420000u l=150000u
** [instance X37 of sky130_fd_pr__pfet_01v8_hvt, params={'w': '1e+06u', 'l': '150000u'} connections=['d: [connection X37/d =>[signal: VPWR w=1]]', 'g: [connection X37/g =>[signal: a_110_47# w=1]]', 's: [connection X37/s =>[signal: X w=1]]', 'b: [connection X37/b =>[signal: VPB w=1]]']]
X_Xclkbuf_1_1__f_scan_clk_37 VPWR Xclkbuf_1_1__f_scan_clk_a_110_47# _76_/CLK VPWR sky130_fd_pr__pfet_01v8_hvt w=1e+06u l=150000u
** [instance X38 of sky130_fd_pr__nfet_01v8, params={'w': '420000u', 'l': '150000u'} connections=['d: [connection X38/d =>[signal: VGND w=1]]', 'g: [connection X38/g =>[signal: a_110_47# w=1]]', 's: [connection X38/s =>[signal: X w=1]]', 'b: [connection X38/b =>[signal: VNB w=1]]']]
X_Xclkbuf_1_1__f_scan_clk_38 VGND Xclkbuf_1_1__f_scan_clk_a_110_47# _76_/CLK VGND sky130_fd_pr__nfet_01v8 w=420000u l=150000u
** [instance X39 of sky130_fd_pr__nfet_01v8, params={'w': '420000u', 'l': '150000u'} connections=['d: [connection X39/d =>[signal: VGND w=1]]', 'g: [connection X39/g =>[signal: a_110_47# w=1]]', 's: [connection X39/s =>[signal: X w=1]]', 'b: [connection X39/b =>[signal: VNB w=1]]']]
X_Xclkbuf_1_1__f_scan_clk_39 VGND Xclkbuf_1_1__f_scan_clk_a_110_47# _76_/CLK VGND sky130_fd_pr__nfet_01v8 w=420000u l=150000u

** replacing XFILLER_6_81 with the contents of sky130_fd_sc_hd__fill_2

** replacing XFILLER_3_82 with the contents of sky130_fd_sc_hd__fill_1

** replacing Xclkbuf_1_0__f_scan_clk with the contents of sky130_fd_sc_hd__clkbuf_16
** [instance X0 of sky130_fd_pr__pfet_01v8_hvt, params={'w': '1e+06u', 'l': '150000u'} connections=['d: [connection X0/d =>[signal: VPWR w=1]]', 'g: [connection X0/g =>[signal: a_110_47# w=1]]', 's: [connection X0/s =>[signal: X w=1]]', 'b: [connection X0/b =>[signal: VPB w=1]]']]
X_Xclkbuf_1_0__f_scan_clk_0 VPWR Xclkbuf_1_0__f_scan_clk_a_110_47# _71_/CLK VPWR sky130_fd_pr__pfet_01v8_hvt w=1e+06u l=150000u
** [instance X1 of sky130_fd_pr__nfet_01v8, params={'w': '420000u', 'l': '150000u'} connections=['d: [connection X1/d =>[signal: X w=1]]', 'g: [connection X1/g =>[signal: a_110_47# w=1]]', 's: [connection X1/s =>[signal: VGND w=1]]', 'b: [connection X1/b =>[signal: VNB w=1]]']]
X_Xclkbuf_1_0__f_scan_clk_1 _71_/CLK Xclkbuf_1_0__f_scan_clk_a_110_47# VGND VGND sky130_fd_pr__nfet_01v8 w=420000u l=150000u
** [instance X2 of sky130_fd_pr__nfet_01v8, params={'w': '420000u', 'l': '150000u'} connections=['d: [connection X2/d =>[signal: X w=1]]', 'g: [connection X2/g =>[signal: a_110_47# w=1]]', 's: [connection X2/s =>[signal: VGND w=1]]', 'b: [connection X2/b =>[signal: VNB w=1]]']]
X_Xclkbuf_1_0__f_scan_clk_2 _71_/CLK Xclkbuf_1_0__f_scan_clk_a_110_47# VGND VGND sky130_fd_pr__nfet_01v8 w=420000u l=150000u
** [instance X3 of sky130_fd_pr__pfet_01v8_hvt, params={'w': '1e+06u', 'l': '150000u'} connections=['d: [connection X3/d =>[signal: a_110_47# w=1]]', 'g: [connection X3/g =>[signal: A w=1]]', 's: [connection X3/s =>[signal: VPWR w=1]]', 'b: [connection X3/b =>[signal: VPB w=1]]']]
X_Xclkbuf_1_0__f_scan_clk_3 Xclkbuf_1_0__f_scan_clk_a_110_47# clkbuf_0_scan_clk/X VPWR VPWR sky130_fd_pr__pfet_01v8_hvt w=1e+06u l=150000u
** [instance X4 of sky130_fd_pr__pfet_01v8_hvt, params={'w': '1e+06u', 'l': '150000u'} connections=['d: [connection X4/d =>[signal: VPWR w=1]]', 'g: [connection X4/g =>[signal: a_110_47# w=1]]', 's: [connection X4/s =>[signal: X w=1]]', 'b: [connection X4/b =>[signal: VPB w=1]]']]
X_Xclkbuf_1_0__f_scan_clk_4 VPWR Xclkbuf_1_0__f_scan_clk_a_110_47# _71_/CLK VPWR sky130_fd_pr__pfet_01v8_hvt w=1e+06u l=150000u
** [instance X5 of sky130_fd_pr__pfet_01v8_hvt, params={'w': '1e+06u', 'l': '150000u'} connections=['d: [connection X5/d =>[signal: X w=1]]', 'g: [connection X5/g =>[signal: a_110_47# w=1]]', 's: [connection X5/s =>[signal: VPWR w=1]]', 'b: [connection X5/b =>[signal: VPB w=1]]']]
X_Xclkbuf_1_0__f_scan_clk_5 _71_/CLK Xclkbuf_1_0__f_scan_clk_a_110_47# VPWR VPWR sky130_fd_pr__pfet_01v8_hvt w=1e+06u l=150000u
** [instance X6 of sky130_fd_pr__nfet_01v8, params={'w': '420000u', 'l': '150000u'} connections=['d: [connection X6/d =>[signal: a_110_47# w=1]]', 'g: [connection X6/g =>[signal: A w=1]]', 's: [connection X6/s =>[signal: VGND w=1]]', 'b: [connection X6/b =>[signal: VNB w=1]]']]
X_Xclkbuf_1_0__f_scan_clk_6 Xclkbuf_1_0__f_scan_clk_a_110_47# clkbuf_0_scan_clk/X VGND VGND sky130_fd_pr__nfet_01v8 w=420000u l=150000u
** [instance X7 of sky130_fd_pr__pfet_01v8_hvt, params={'w': '1e+06u', 'l': '150000u'} connections=['d: [connection X7/d =>[signal: VPWR w=1]]', 'g: [connection X7/g =>[signal: A w=1]]', 's: [connection X7/s =>[signal: a_110_47# w=1]]', 'b: [connection X7/b =>[signal: VPB w=1]]']]
X_Xclkbuf_1_0__f_scan_clk_7 VPWR clkbuf_0_scan_clk/X Xclkbuf_1_0__f_scan_clk_a_110_47# VPWR sky130_fd_pr__pfet_01v8_hvt w=1e+06u l=150000u
** [instance X8 of sky130_fd_pr__nfet_01v8, params={'w': '420000u', 'l': '150000u'} connections=['d: [connection X8/d =>[signal: VGND w=1]]', 'g: [connection X8/g =>[signal: a_110_47# w=1]]', 's: [connection X8/s =>[signal: X w=1]]', 'b: [connection X8/b =>[signal: VNB w=1]]']]
X_Xclkbuf_1_0__f_scan_clk_8 VGND Xclkbuf_1_0__f_scan_clk_a_110_47# _71_/CLK VGND sky130_fd_pr__nfet_01v8 w=420000u l=150000u
** [instance X9 of sky130_fd_pr__nfet_01v8, params={'w': '420000u', 'l': '150000u'} connections=['d: [connection X9/d =>[signal: VGND w=1]]', 'g: [connection X9/g =>[signal: A w=1]]', 's: [connection X9/s =>[signal: a_110_47# w=1]]', 'b: [connection X9/b =>[signal: VNB w=1]]']]
X_Xclkbuf_1_0__f_scan_clk_9 VGND clkbuf_0_scan_clk/X Xclkbuf_1_0__f_scan_clk_a_110_47# VGND sky130_fd_pr__nfet_01v8 w=420000u l=150000u
** [instance X10 of sky130_fd_pr__nfet_01v8, params={'w': '420000u', 'l': '150000u'} connections=['d: [connection X10/d =>[signal: X w=1]]', 'g: [connection X10/g =>[signal: a_110_47# w=1]]', 's: [connection X10/s =>[signal: VGND w=1]]', 'b: [connection X10/b =>[signal: VNB w=1]]']]
X_Xclkbuf_1_0__f_scan_clk_10 _71_/CLK Xclkbuf_1_0__f_scan_clk_a_110_47# VGND VGND sky130_fd_pr__nfet_01v8 w=420000u l=150000u
** [instance X11 of sky130_fd_pr__nfet_01v8, params={'w': '420000u', 'l': '150000u'} connections=['d: [connection X11/d =>[signal: X w=1]]', 'g: [connection X11/g =>[signal: a_110_47# w=1]]', 's: [connection X11/s =>[signal: VGND w=1]]', 'b: [connection X11/b =>[signal: VNB w=1]]']]
X_Xclkbuf_1_0__f_scan_clk_11 _71_/CLK Xclkbuf_1_0__f_scan_clk_a_110_47# VGND VGND sky130_fd_pr__nfet_01v8 w=420000u l=150000u
** [instance X12 of sky130_fd_pr__pfet_01v8_hvt, params={'w': '1e+06u', 'l': '150000u'} connections=['d: [connection X12/d =>[signal: a_110_47# w=1]]', 'g: [connection X12/g =>[signal: A w=1]]', 's: [connection X12/s =>[signal: VPWR w=1]]', 'b: [connection X12/b =>[signal: VPB w=1]]']]
X_Xclkbuf_1_0__f_scan_clk_12 Xclkbuf_1_0__f_scan_clk_a_110_47# clkbuf_0_scan_clk/X VPWR VPWR sky130_fd_pr__pfet_01v8_hvt w=1e+06u l=150000u
** [instance X13 of sky130_fd_pr__pfet_01v8_hvt, params={'w': '1e+06u', 'l': '150000u'} connections=['d: [connection X13/d =>[signal: VPWR w=1]]', 'g: [connection X13/g =>[signal: a_110_47# w=1]]', 's: [connection X13/s =>[signal: X w=1]]', 'b: [connection X13/b =>[signal: VPB w=1]]']]
X_Xclkbuf_1_0__f_scan_clk_13 VPWR Xclkbuf_1_0__f_scan_clk_a_110_47# _71_/CLK VPWR sky130_fd_pr__pfet_01v8_hvt w=1e+06u l=150000u
** [instance X14 of sky130_fd_pr__nfet_01v8, params={'w': '420000u', 'l': '150000u'} connections=['d: [connection X14/d =>[signal: X w=1]]', 'g: [connection X14/g =>[signal: a_110_47# w=1]]', 's: [connection X14/s =>[signal: VGND w=1]]', 'b: [connection X14/b =>[signal: VNB w=1]]']]
X_Xclkbuf_1_0__f_scan_clk_14 _71_/CLK Xclkbuf_1_0__f_scan_clk_a_110_47# VGND VGND sky130_fd_pr__nfet_01v8 w=420000u l=150000u
** [instance X15 of sky130_fd_pr__pfet_01v8_hvt, params={'w': '1e+06u', 'l': '150000u'} connections=['d: [connection X15/d =>[signal: VPWR w=1]]', 'g: [connection X15/g =>[signal: A w=1]]', 's: [connection X15/s =>[signal: a_110_47# w=1]]', 'b: [connection X15/b =>[signal: VPB w=1]]']]
X_Xclkbuf_1_0__f_scan_clk_15 VPWR clkbuf_0_scan_clk/X Xclkbuf_1_0__f_scan_clk_a_110_47# VPWR sky130_fd_pr__pfet_01v8_hvt w=1e+06u l=150000u
** [instance X16 of sky130_fd_pr__nfet_01v8, params={'w': '420000u', 'l': '150000u'} connections=['d: [connection X16/d =>[signal: VGND w=1]]', 'g: [connection X16/g =>[signal: a_110_47# w=1]]', 's: [connection X16/s =>[signal: X w=1]]', 'b: [connection X16/b =>[signal: VNB w=1]]']]
X_Xclkbuf_1_0__f_scan_clk_16 VGND Xclkbuf_1_0__f_scan_clk_a_110_47# _71_/CLK VGND sky130_fd_pr__nfet_01v8 w=420000u l=150000u
** [instance X17 of sky130_fd_pr__nfet_01v8, params={'w': '420000u', 'l': '150000u'} connections=['d: [connection X17/d =>[signal: X w=1]]', 'g: [connection X17/g =>[signal: a_110_47# w=1]]', 's: [connection X17/s =>[signal: VGND w=1]]', 'b: [connection X17/b =>[signal: VNB w=1]]']]
X_Xclkbuf_1_0__f_scan_clk_17 _71_/CLK Xclkbuf_1_0__f_scan_clk_a_110_47# VGND VGND sky130_fd_pr__nfet_01v8 w=420000u l=150000u
** [instance X18 of sky130_fd_pr__nfet_01v8, params={'w': '420000u', 'l': '150000u'} connections=['d: [connection X18/d =>[signal: VGND w=1]]', 'g: [connection X18/g =>[signal: a_110_47# w=1]]', 's: [connection X18/s =>[signal: X w=1]]', 'b: [connection X18/b =>[signal: VNB w=1]]']]
X_Xclkbuf_1_0__f_scan_clk_18 VGND Xclkbuf_1_0__f_scan_clk_a_110_47# _71_/CLK VGND sky130_fd_pr__nfet_01v8 w=420000u l=150000u
** [instance X19 of sky130_fd_pr__nfet_01v8, params={'w': '420000u', 'l': '150000u'} connections=['d: [connection X19/d =>[signal: VGND w=1]]', 'g: [connection X19/g =>[signal: a_110_47# w=1]]', 's: [connection X19/s =>[signal: X w=1]]', 'b: [connection X19/b =>[signal: VNB w=1]]']]
X_Xclkbuf_1_0__f_scan_clk_19 VGND Xclkbuf_1_0__f_scan_clk_a_110_47# _71_/CLK VGND sky130_fd_pr__nfet_01v8 w=420000u l=150000u
** [instance X20 of sky130_fd_pr__pfet_01v8_hvt, params={'w': '1e+06u', 'l': '150000u'} connections=['d: [connection X20/d =>[signal: X w=1]]', 'g: [connection X20/g =>[signal: a_110_47# w=1]]', 's: [connection X20/s =>[signal: VPWR w=1]]', 'b: [connection X20/b =>[signal: VPB w=1]]']]
X_Xclkbuf_1_0__f_scan_clk_20 _71_/CLK Xclkbuf_1_0__f_scan_clk_a_110_47# VPWR VPWR sky130_fd_pr__pfet_01v8_hvt w=1e+06u l=150000u
** [instance X21 of sky130_fd_pr__pfet_01v8_hvt, params={'w': '1e+06u', 'l': '150000u'} connections=['d: [connection X21/d =>[signal: X w=1]]', 'g: [connection X21/g =>[signal: a_110_47# w=1]]', 's: [connection X21/s =>[signal: VPWR w=1]]', 'b: [connection X21/b =>[signal: VPB w=1]]']]
X_Xclkbuf_1_0__f_scan_clk_21 _71_/CLK Xclkbuf_1_0__f_scan_clk_a_110_47# VPWR VPWR sky130_fd_pr__pfet_01v8_hvt w=1e+06u l=150000u
** [instance X22 of sky130_fd_pr__pfet_01v8_hvt, params={'w': '1e+06u', 'l': '150000u'} connections=['d: [connection X22/d =>[signal: X w=1]]', 'g: [connection X22/g =>[signal: a_110_47# w=1]]', 's: [connection X22/s =>[signal: VPWR w=1]]', 'b: [connection X22/b =>[signal: VPB w=1]]']]
X_Xclkbuf_1_0__f_scan_clk_22 _71_/CLK Xclkbuf_1_0__f_scan_clk_a_110_47# VPWR VPWR sky130_fd_pr__pfet_01v8_hvt w=1e+06u l=150000u
** [instance X23 of sky130_fd_pr__pfet_01v8_hvt, params={'w': '1e+06u', 'l': '150000u'} connections=['d: [connection X23/d =>[signal: VPWR w=1]]', 'g: [connection X23/g =>[signal: a_110_47# w=1]]', 's: [connection X23/s =>[signal: X w=1]]', 'b: [connection X23/b =>[signal: VPB w=1]]']]
X_Xclkbuf_1_0__f_scan_clk_23 VPWR Xclkbuf_1_0__f_scan_clk_a_110_47# _71_/CLK VPWR sky130_fd_pr__pfet_01v8_hvt w=1e+06u l=150000u
** [instance X24 of sky130_fd_pr__pfet_01v8_hvt, params={'w': '1e+06u', 'l': '150000u'} connections=['d: [connection X24/d =>[signal: VPWR w=1]]', 'g: [connection X24/g =>[signal: a_110_47# w=1]]', 's: [connection X24/s =>[signal: X w=1]]', 'b: [connection X24/b =>[signal: VPB w=1]]']]
X_Xclkbuf_1_0__f_scan_clk_24 VPWR Xclkbuf_1_0__f_scan_clk_a_110_47# _71_/CLK VPWR sky130_fd_pr__pfet_01v8_hvt w=1e+06u l=150000u
** [instance X25 of sky130_fd_pr__nfet_01v8, params={'w': '420000u', 'l': '150000u'} connections=['d: [connection X25/d =>[signal: VGND w=1]]', 'g: [connection X25/g =>[signal: a_110_47# w=1]]', 's: [connection X25/s =>[signal: X w=1]]', 'b: [connection X25/b =>[signal: VNB w=1]]']]
X_Xclkbuf_1_0__f_scan_clk_25 VGND Xclkbuf_1_0__f_scan_clk_a_110_47# _71_/CLK VGND sky130_fd_pr__nfet_01v8 w=420000u l=150000u
** [instance X26 of sky130_fd_pr__pfet_01v8_hvt, params={'w': '1e+06u', 'l': '150000u'} connections=['d: [connection X26/d =>[signal: X w=1]]', 'g: [connection X26/g =>[signal: a_110_47# w=1]]', 's: [connection X26/s =>[signal: VPWR w=1]]', 'b: [connection X26/b =>[signal: VPB w=1]]']]
X_Xclkbuf_1_0__f_scan_clk_26 _71_/CLK Xclkbuf_1_0__f_scan_clk_a_110_47# VPWR VPWR sky130_fd_pr__pfet_01v8_hvt w=1e+06u l=150000u
** [instance X27 of sky130_fd_pr__nfet_01v8, params={'w': '420000u', 'l': '150000u'} connections=['d: [connection X27/d =>[signal: X w=1]]', 'g: [connection X27/g =>[signal: a_110_47# w=1]]', 's: [connection X27/s =>[signal: VGND w=1]]', 'b: [connection X27/b =>[signal: VNB w=1]]']]
X_Xclkbuf_1_0__f_scan_clk_27 _71_/CLK Xclkbuf_1_0__f_scan_clk_a_110_47# VGND VGND sky130_fd_pr__nfet_01v8 w=420000u l=150000u
** [instance X28 of sky130_fd_pr__pfet_01v8_hvt, params={'w': '1e+06u', 'l': '150000u'} connections=['d: [connection X28/d =>[signal: VPWR w=1]]', 'g: [connection X28/g =>[signal: a_110_47# w=1]]', 's: [connection X28/s =>[signal: X w=1]]', 'b: [connection X28/b =>[signal: VPB w=1]]']]
X_Xclkbuf_1_0__f_scan_clk_28 VPWR Xclkbuf_1_0__f_scan_clk_a_110_47# _71_/CLK VPWR sky130_fd_pr__pfet_01v8_hvt w=1e+06u l=150000u
** [instance X29 of sky130_fd_pr__nfet_01v8, params={'w': '420000u', 'l': '150000u'} connections=['d: [connection X29/d =>[signal: VGND w=1]]', 'g: [connection X29/g =>[signal: a_110_47# w=1]]', 's: [connection X29/s =>[signal: X w=1]]', 'b: [connection X29/b =>[signal: VNB w=1]]']]
X_Xclkbuf_1_0__f_scan_clk_29 VGND Xclkbuf_1_0__f_scan_clk_a_110_47# _71_/CLK VGND sky130_fd_pr__nfet_01v8 w=420000u l=150000u
** [instance X30 of sky130_fd_pr__nfet_01v8, params={'w': '420000u', 'l': '150000u'} connections=['d: [connection X30/d =>[signal: X w=1]]', 'g: [connection X30/g =>[signal: a_110_47# w=1]]', 's: [connection X30/s =>[signal: VGND w=1]]', 'b: [connection X30/b =>[signal: VNB w=1]]']]
X_Xclkbuf_1_0__f_scan_clk_30 _71_/CLK Xclkbuf_1_0__f_scan_clk_a_110_47# VGND VGND sky130_fd_pr__nfet_01v8 w=420000u l=150000u
** [instance X31 of sky130_fd_pr__pfet_01v8_hvt, params={'w': '1e+06u', 'l': '150000u'} connections=['d: [connection X31/d =>[signal: X w=1]]', 'g: [connection X31/g =>[signal: a_110_47# w=1]]', 's: [connection X31/s =>[signal: VPWR w=1]]', 'b: [connection X31/b =>[signal: VPB w=1]]']]
X_Xclkbuf_1_0__f_scan_clk_31 _71_/CLK Xclkbuf_1_0__f_scan_clk_a_110_47# VPWR VPWR sky130_fd_pr__pfet_01v8_hvt w=1e+06u l=150000u
** [instance X32 of sky130_fd_pr__pfet_01v8_hvt, params={'w': '1e+06u', 'l': '150000u'} connections=['d: [connection X32/d =>[signal: X w=1]]', 'g: [connection X32/g =>[signal: a_110_47# w=1]]', 's: [connection X32/s =>[signal: VPWR w=1]]', 'b: [connection X32/b =>[signal: VPB w=1]]']]
X_Xclkbuf_1_0__f_scan_clk_32 _71_/CLK Xclkbuf_1_0__f_scan_clk_a_110_47# VPWR VPWR sky130_fd_pr__pfet_01v8_hvt w=1e+06u l=150000u
** [instance X33 of sky130_fd_pr__pfet_01v8_hvt, params={'w': '1e+06u', 'l': '150000u'} connections=['d: [connection X33/d =>[signal: X w=1]]', 'g: [connection X33/g =>[signal: a_110_47# w=1]]', 's: [connection X33/s =>[signal: VPWR w=1]]', 'b: [connection X33/b =>[signal: VPB w=1]]']]
X_Xclkbuf_1_0__f_scan_clk_33 _71_/CLK Xclkbuf_1_0__f_scan_clk_a_110_47# VPWR VPWR sky130_fd_pr__pfet_01v8_hvt w=1e+06u l=150000u
** [instance X34 of sky130_fd_pr__nfet_01v8, params={'w': '420000u', 'l': '150000u'} connections=['d: [connection X34/d =>[signal: a_110_47# w=1]]', 'g: [connection X34/g =>[signal: A w=1]]', 's: [connection X34/s =>[signal: VGND w=1]]', 'b: [connection X34/b =>[signal: VNB w=1]]']]
X_Xclkbuf_1_0__f_scan_clk_34 Xclkbuf_1_0__f_scan_clk_a_110_47# clkbuf_0_scan_clk/X VGND VGND sky130_fd_pr__nfet_01v8 w=420000u l=150000u
** [instance X35 of sky130_fd_pr__pfet_01v8_hvt, params={'w': '1e+06u', 'l': '150000u'} connections=['d: [connection X35/d =>[signal: VPWR w=1]]', 'g: [connection X35/g =>[signal: a_110_47# w=1]]', 's: [connection X35/s =>[signal: X w=1]]', 'b: [connection X35/b =>[signal: VPB w=1]]']]
X_Xclkbuf_1_0__f_scan_clk_35 VPWR Xclkbuf_1_0__f_scan_clk_a_110_47# _71_/CLK VPWR sky130_fd_pr__pfet_01v8_hvt w=1e+06u l=150000u
** [instance X36 of sky130_fd_pr__nfet_01v8, params={'w': '420000u', 'l': '150000u'} connections=['d: [connection X36/d =>[signal: VGND w=1]]', 'g: [connection X36/g =>[signal: A w=1]]', 's: [connection X36/s =>[signal: a_110_47# w=1]]', 'b: [connection X36/b =>[signal: VNB w=1]]']]
X_Xclkbuf_1_0__f_scan_clk_36 VGND clkbuf_0_scan_clk/X Xclkbuf_1_0__f_scan_clk_a_110_47# VGND sky130_fd_pr__nfet_01v8 w=420000u l=150000u
** [instance X37 of sky130_fd_pr__pfet_01v8_hvt, params={'w': '1e+06u', 'l': '150000u'} connections=['d: [connection X37/d =>[signal: VPWR w=1]]', 'g: [connection X37/g =>[signal: a_110_47# w=1]]', 's: [connection X37/s =>[signal: X w=1]]', 'b: [connection X37/b =>[signal: VPB w=1]]']]
X_Xclkbuf_1_0__f_scan_clk_37 VPWR Xclkbuf_1_0__f_scan_clk_a_110_47# _71_/CLK VPWR sky130_fd_pr__pfet_01v8_hvt w=1e+06u l=150000u
** [instance X38 of sky130_fd_pr__nfet_01v8, params={'w': '420000u', 'l': '150000u'} connections=['d: [connection X38/d =>[signal: VGND w=1]]', 'g: [connection X38/g =>[signal: a_110_47# w=1]]', 's: [connection X38/s =>[signal: X w=1]]', 'b: [connection X38/b =>[signal: VNB w=1]]']]
X_Xclkbuf_1_0__f_scan_clk_38 VGND Xclkbuf_1_0__f_scan_clk_a_110_47# _71_/CLK VGND sky130_fd_pr__nfet_01v8 w=420000u l=150000u
** [instance X39 of sky130_fd_pr__nfet_01v8, params={'w': '420000u', 'l': '150000u'} connections=['d: [connection X39/d =>[signal: VGND w=1]]', 'g: [connection X39/g =>[signal: a_110_47# w=1]]', 's: [connection X39/s =>[signal: X w=1]]', 'b: [connection X39/b =>[signal: VNB w=1]]']]
X_Xclkbuf_1_0__f_scan_clk_39 VGND Xclkbuf_1_0__f_scan_clk_a_110_47# _71_/CLK VGND sky130_fd_pr__nfet_01v8 w=420000u l=150000u

** replacing X_30_ with the contents of sky130_fd_sc_hd__inv_2
** [instance X0 of sky130_fd_pr__nfet_01v8, params={'w': '650000u', 'l': '150000u'} connections=['d: [connection X0/d =>[signal: Y w=1]]', 'g: [connection X0/g =>[signal: A w=1]]', 's: [connection X0/s =>[signal: VGND w=1]]', 'b: [connection X0/b =>[signal: VNB w=1]]']]
X_X_30__0 _30_/Y _30_/A VGND VGND sky130_fd_pr__nfet_01v8 w=650000u l=150000u
** [instance X1 of sky130_fd_pr__pfet_01v8_hvt, params={'w': '1e+06u', 'l': '150000u'} connections=['d: [connection X1/d =>[signal: VPWR w=1]]', 'g: [connection X1/g =>[signal: A w=1]]', 's: [connection X1/s =>[signal: Y w=1]]', 'b: [connection X1/b =>[signal: VPB w=1]]']]
X_X_30__1 VPWR _30_/A _30_/Y VPWR sky130_fd_pr__pfet_01v8_hvt w=1e+06u l=150000u
** [instance X2 of sky130_fd_pr__nfet_01v8, params={'w': '650000u', 'l': '150000u'} connections=['d: [connection X2/d =>[signal: VGND w=1]]', 'g: [connection X2/g =>[signal: A w=1]]', 's: [connection X2/s =>[signal: Y w=1]]', 'b: [connection X2/b =>[signal: VNB w=1]]']]
X_X_30__2 VGND _30_/A _30_/Y VGND sky130_fd_pr__nfet_01v8 w=650000u l=150000u
** [instance X3 of sky130_fd_pr__pfet_01v8_hvt, params={'w': '1e+06u', 'l': '150000u'} connections=['d: [connection X3/d =>[signal: Y w=1]]', 'g: [connection X3/g =>[signal: A w=1]]', 's: [connection X3/s =>[signal: VPWR w=1]]', 'b: [connection X3/b =>[signal: VPB w=1]]']]
X_X_30__3 _30_/Y _30_/A VPWR VPWR sky130_fd_pr__pfet_01v8_hvt w=1e+06u l=150000u

** replacing XPHY_EDGE_ROW_13_Left_27 with the contents of sky130_fd_sc_hd__decap_3
** [instance X0 of sky130_fd_pr__pfet_01v8_hvt, params={'w': '870000u', 'l': '590000u'} connections=['d: [connection X0/d =>[signal: VPWR w=1]]', 'g: [connection X0/g =>[signal: VGND w=1]]', 's: [connection X0/s =>[signal: VPWR w=1]]', 'b: [connection X0/b =>[signal: VPB w=1]]']]
X_XPHY_EDGE_ROW_13_Left_27_0 VPWR VGND VPWR VPWR sky130_fd_pr__pfet_01v8_hvt w=870000u l=590000u
** [instance X1 of sky130_fd_pr__nfet_01v8, params={'w': '550000u', 'l': '590000u'} connections=['d: [connection X1/d =>[signal: VGND w=1]]', 'g: [connection X1/g =>[signal: VPWR w=1]]', 's: [connection X1/s =>[signal: VGND w=1]]', 'b: [connection X1/b =>[signal: VNB w=1]]']]
X_XPHY_EDGE_ROW_13_Left_27_1 VGND VPWR VGND VGND sky130_fd_pr__nfet_01v8 w=550000u l=590000u

** replacing XPHY_EDGE_ROW_7_Right_7 with the contents of sky130_fd_sc_hd__decap_3
** [instance X0 of sky130_fd_pr__pfet_01v8_hvt, params={'w': '870000u', 'l': '590000u'} connections=['d: [connection X0/d =>[signal: VPWR w=1]]', 'g: [connection X0/g =>[signal: VGND w=1]]', 's: [connection X0/s =>[signal: VPWR w=1]]', 'b: [connection X0/b =>[signal: VPB w=1]]']]
X_XPHY_EDGE_ROW_7_Right_7_0 VPWR VGND VPWR VPWR sky130_fd_pr__pfet_01v8_hvt w=870000u l=590000u
** [instance X1 of sky130_fd_pr__nfet_01v8, params={'w': '550000u', 'l': '590000u'} connections=['d: [connection X1/d =>[signal: VGND w=1]]', 'g: [connection X1/g =>[signal: VPWR w=1]]', 's: [connection X1/s =>[signal: VGND w=1]]', 'b: [connection X1/b =>[signal: VNB w=1]]']]
X_XPHY_EDGE_ROW_7_Right_7_1 VGND VPWR VGND VGND sky130_fd_pr__nfet_01v8 w=550000u l=590000u

** replacing XPHY_EDGE_ROW_1_Left_15 with the contents of sky130_fd_sc_hd__decap_3
** [instance X0 of sky130_fd_pr__pfet_01v8_hvt, params={'w': '870000u', 'l': '590000u'} connections=['d: [connection X0/d =>[signal: VPWR w=1]]', 'g: [connection X0/g =>[signal: VGND w=1]]', 's: [connection X0/s =>[signal: VPWR w=1]]', 'b: [connection X0/b =>[signal: VPB w=1]]']]
X_XPHY_EDGE_ROW_1_Left_15_0 VPWR VGND VPWR VPWR sky130_fd_pr__pfet_01v8_hvt w=870000u l=590000u
** [instance X1 of sky130_fd_pr__nfet_01v8, params={'w': '550000u', 'l': '590000u'} connections=['d: [connection X1/d =>[signal: VGND w=1]]', 'g: [connection X1/g =>[signal: VPWR w=1]]', 's: [connection X1/s =>[signal: VGND w=1]]', 'b: [connection X1/b =>[signal: VNB w=1]]']]
X_XPHY_EDGE_ROW_1_Left_15_1 VGND VPWR VGND VGND sky130_fd_pr__nfet_01v8 w=550000u l=590000u

** replacing XFILLER_7_3 with the contents of sky130_fd_sc_hd__decap_3
** [instance X0 of sky130_fd_pr__pfet_01v8_hvt, params={'w': '870000u', 'l': '590000u'} connections=['d: [connection X0/d =>[signal: VPWR w=1]]', 'g: [connection X0/g =>[signal: VGND w=1]]', 's: [connection X0/s =>[signal: VPWR w=1]]', 'b: [connection X0/b =>[signal: VPB w=1]]']]
X_XFILLER_7_3_0 VPWR VGND VPWR VPWR sky130_fd_pr__pfet_01v8_hvt w=870000u l=590000u
** [instance X1 of sky130_fd_pr__nfet_01v8, params={'w': '550000u', 'l': '590000u'} connections=['d: [connection X1/d =>[signal: VGND w=1]]', 'g: [connection X1/g =>[signal: VPWR w=1]]', 's: [connection X1/s =>[signal: VGND w=1]]', 'b: [connection X1/b =>[signal: VNB w=1]]']]
X_XFILLER_7_3_1 VGND VPWR VGND VGND sky130_fd_pr__nfet_01v8 w=550000u l=590000u

** replacing XFILLER_11_19 with the contents of sky130_fd_sc_hd__decap_3
** [instance X0 of sky130_fd_pr__pfet_01v8_hvt, params={'w': '870000u', 'l': '590000u'} connections=['d: [connection X0/d =>[signal: VPWR w=1]]', 'g: [connection X0/g =>[signal: VGND w=1]]', 's: [connection X0/s =>[signal: VPWR w=1]]', 'b: [connection X0/b =>[signal: VPB w=1]]']]
X_XFILLER_11_19_0 VPWR VGND VPWR VPWR sky130_fd_pr__pfet_01v8_hvt w=870000u l=590000u
** [instance X1 of sky130_fd_pr__nfet_01v8, params={'w': '550000u', 'l': '590000u'} connections=['d: [connection X1/d =>[signal: VGND w=1]]', 'g: [connection X1/g =>[signal: VPWR w=1]]', 's: [connection X1/s =>[signal: VGND w=1]]', 'b: [connection X1/b =>[signal: VNB w=1]]']]
X_XFILLER_11_19_1 VGND VPWR VGND VGND sky130_fd_pr__nfet_01v8 w=550000u l=590000u

** replacing XTAP_TAPCELL_ROW_2_31 with the contents of sky130_fd_sc_hd__tapvpwrvgnd_1

** replacing XPHY_EDGE_ROW_5_Left_19 with the contents of sky130_fd_sc_hd__decap_3
** [instance X0 of sky130_fd_pr__pfet_01v8_hvt, params={'w': '870000u', 'l': '590000u'} connections=['d: [connection X0/d =>[signal: VPWR w=1]]', 'g: [connection X0/g =>[signal: VGND w=1]]', 's: [connection X0/s =>[signal: VPWR w=1]]', 'b: [connection X0/b =>[signal: VPB w=1]]']]
X_XPHY_EDGE_ROW_5_Left_19_0 VPWR VGND VPWR VPWR sky130_fd_pr__pfet_01v8_hvt w=870000u l=590000u
** [instance X1 of sky130_fd_pr__nfet_01v8, params={'w': '550000u', 'l': '590000u'} connections=['d: [connection X1/d =>[signal: VGND w=1]]', 'g: [connection X1/g =>[signal: VPWR w=1]]', 's: [connection X1/s =>[signal: VGND w=1]]', 'b: [connection X1/b =>[signal: VNB w=1]]']]
X_XPHY_EDGE_ROW_5_Left_19_1 VGND VPWR VGND VGND sky130_fd_pr__nfet_01v8 w=550000u l=590000u

** replacing XFILLER_12_51 with the contents of sky130_fd_sc_hd__decap_3
** [instance X0 of sky130_fd_pr__pfet_01v8_hvt, params={'w': '870000u', 'l': '590000u'} connections=['d: [connection X0/d =>[signal: VPWR w=1]]', 'g: [connection X0/g =>[signal: VGND w=1]]', 's: [connection X0/s =>[signal: VPWR w=1]]', 'b: [connection X0/b =>[signal: VPB w=1]]']]
X_XFILLER_12_51_0 VPWR VGND VPWR VPWR sky130_fd_pr__pfet_01v8_hvt w=870000u l=590000u
** [instance X1 of sky130_fd_pr__nfet_01v8, params={'w': '550000u', 'l': '590000u'} connections=['d: [connection X1/d =>[signal: VGND w=1]]', 'g: [connection X1/g =>[signal: VPWR w=1]]', 's: [connection X1/s =>[signal: VGND w=1]]', 'b: [connection X1/b =>[signal: VNB w=1]]']]
X_XFILLER_12_51_1 VGND VPWR VGND VGND sky130_fd_pr__nfet_01v8 w=550000u l=590000u

** replacing X_69_ with the contents of sky130_fd_sc_hd__dfxtp_2
** [instance X0 of sky130_fd_pr__pfet_01v8_hvt, params={'w': '420000u', 'l': '150000u'} connections=['d: [connection X0/d =>[signal: a_891_413# w=1]]', 'g: [connection X0/g =>[signal: a_193_47# w=1]]', 's: [connection X0/s =>[signal: a_975_413# w=1]]', 'b: [connection X0/b =>[signal: VPB w=1]]']]
X_X_69__0 X_69__a_891_413# X_69__a_193_47# X_69__a_975_413# VPWR sky130_fd_pr__pfet_01v8_hvt w=420000u l=150000u
** [instance X1 of sky130_fd_pr__nfet_01v8, params={'w': '650000u', 'l': '150000u'} connections=['d: [connection X1/d =>[signal: a_1059_315# w=1]]', 'g: [connection X1/g =>[signal: a_891_413# w=1]]', 's: [connection X1/s =>[signal: VGND w=1]]', 'b: [connection X1/b =>[signal: VNB w=1]]']]
X_X_69__1 X_69__a_1059_315# X_69__a_891_413# VGND VGND sky130_fd_pr__nfet_01v8 w=650000u l=150000u
** [instance X2 of sky130_fd_pr__pfet_01v8_hvt, params={'w': '420000u', 'l': '150000u'} connections=['d: [connection X2/d =>[signal: a_466_413# w=1]]', 'g: [connection X2/g =>[signal: a_27_47# w=1]]', 's: [connection X2/s =>[signal: a_561_413# w=1]]', 'b: [connection X2/b =>[signal: VPB w=1]]']]
X_X_69__2 X_69__a_466_413# X_69__a_27_47# X_69__a_561_413# VPWR sky130_fd_pr__pfet_01v8_hvt w=420000u l=150000u
** [instance X3 of sky130_fd_pr__pfet_01v8_hvt, params={'w': '420000u', 'l': '150000u'} connections=['d: [connection X3/d =>[signal: a_634_159# w=1]]', 'g: [connection X3/g =>[signal: a_27_47# w=1]]', 's: [connection X3/s =>[signal: a_891_413# w=1]]', 'b: [connection X3/b =>[signal: VPB w=1]]']]
X_X_69__3 X_69__a_634_159# X_69__a_27_47# X_69__a_891_413# VPWR sky130_fd_pr__pfet_01v8_hvt w=420000u l=150000u
** [instance X4 of sky130_fd_pr__pfet_01v8_hvt, params={'w': '420000u', 'l': '150000u'} connections=['d: [connection X4/d =>[signal: a_381_47# w=1]]', 'g: [connection X4/g =>[signal: a_193_47# w=1]]', 's: [connection X4/s =>[signal: a_466_413# w=1]]', 'b: [connection X4/b =>[signal: VPB w=1]]']]
X_X_69__4 X_69__a_381_47# X_69__a_193_47# X_69__a_466_413# VPWR sky130_fd_pr__pfet_01v8_hvt w=420000u l=150000u
** [instance X5 of sky130_fd_pr__pfet_01v8_hvt, params={'w': '420000u', 'l': '150000u'} connections=['d: [connection X5/d =>[signal: VPWR w=1]]', 'g: [connection X5/g =>[signal: D w=1]]', 's: [connection X5/s =>[signal: a_381_47# w=1]]', 'b: [connection X5/b =>[signal: VPB w=1]]']]
X_X_69__5 VPWR _69_/D X_69__a_381_47# VPWR sky130_fd_pr__pfet_01v8_hvt w=420000u l=150000u
** [instance X6 of sky130_fd_pr__pfet_01v8_hvt, params={'w': '750000u', 'l': '150000u'} connections=['d: [connection X6/d =>[signal: VPWR w=1]]', 'g: [connection X6/g =>[signal: a_466_413# w=1]]', 's: [connection X6/s =>[signal: a_634_159# w=1]]', 'b: [connection X6/b =>[signal: VPB w=1]]']]
X_X_69__6 VPWR X_69__a_466_413# X_69__a_634_159# VPWR sky130_fd_pr__pfet_01v8_hvt w=750000u l=150000u
** [instance X7 of sky130_fd_pr__nfet_01v8, params={'w': '640000u', 'l': '150000u'} connections=['d: [connection X7/d =>[signal: VGND w=1]]', 'g: [connection X7/g =>[signal: a_466_413# w=1]]', 's: [connection X7/s =>[signal: a_634_159# w=1]]', 'b: [connection X7/b =>[signal: VNB w=1]]']]
X_X_69__7 VGND X_69__a_466_413# X_69__a_634_159# VGND sky130_fd_pr__nfet_01v8 w=640000u l=150000u
** [instance X8 of sky130_fd_pr__nfet_01v8, params={'w': '420000u', 'l': '150000u'} connections=['d: [connection X8/d =>[signal: a_1017_47# w=1]]', 'g: [connection X8/g =>[signal: a_1059_315# w=1]]', 's: [connection X8/s =>[signal: VGND w=1]]', 'b: [connection X8/b =>[signal: VNB w=1]]']]
X_X_69__8 X_69__a_1017_47# X_69__a_1059_315# VGND VGND sky130_fd_pr__nfet_01v8 w=420000u l=150000u
** [instance X9 of sky130_fd_pr__pfet_01v8_hvt, params={'w': '1e+06u', 'l': '150000u'} connections=['d: [connection X9/d =>[signal: a_1059_315# w=1]]', 'g: [connection X9/g =>[signal: a_891_413# w=1]]', 's: [connection X9/s =>[signal: VPWR w=1]]', 'b: [connection X9/b =>[signal: VPB w=1]]']]
X_X_69__9 X_69__a_1059_315# X_69__a_891_413# VPWR VPWR sky130_fd_pr__pfet_01v8_hvt w=1e+06u l=150000u
** [instance X10 of sky130_fd_pr__pfet_01v8_hvt, params={'w': '1e+06u', 'l': '150000u'} connections=['d: [connection X10/d =>[signal: Q w=1]]', 'g: [connection X10/g =>[signal: a_1059_315# w=1]]', 's: [connection X10/s =>[signal: VPWR w=1]]', 'b: [connection X10/b =>[signal: VPB w=1]]']]
X_X_69__10 _69_/Q X_69__a_1059_315# VPWR VPWR sky130_fd_pr__pfet_01v8_hvt w=1e+06u l=150000u
** [instance X11 of sky130_fd_pr__pfet_01v8_hvt, params={'w': '420000u', 'l': '150000u'} connections=['d: [connection X11/d =>[signal: a_561_413# w=1]]', 'g: [connection X11/g =>[signal: a_634_159# w=1]]', 's: [connection X11/s =>[signal: VPWR w=1]]', 'b: [connection X11/b =>[signal: VPB w=1]]']]
X_X_69__11 X_69__a_561_413# X_69__a_634_159# VPWR VPWR sky130_fd_pr__pfet_01v8_hvt w=420000u l=150000u
** [instance X12 of sky130_fd_pr__pfet_01v8_hvt, params={'w': '1e+06u', 'l': '150000u'} connections=['d: [connection X12/d =>[signal: VPWR w=1]]', 'g: [connection X12/g =>[signal: a_1059_315# w=1]]', 's: [connection X12/s =>[signal: Q w=1]]', 'b: [connection X12/b =>[signal: VPB w=1]]']]
X_X_69__12 VPWR X_69__a_1059_315# _69_/Q VPWR sky130_fd_pr__pfet_01v8_hvt w=1e+06u l=150000u
** [instance X13 of sky130_fd_pr__nfet_01v8, params={'w': '360000u', 'l': '150000u'} connections=['d: [connection X13/d =>[signal: a_891_413# w=1]]', 'g: [connection X13/g =>[signal: a_27_47# w=1]]', 's: [connection X13/s =>[signal: a_1017_47# w=1]]', 'b: [connection X13/b =>[signal: VNB w=1]]']]
X_X_69__13 X_69__a_891_413# X_69__a_27_47# X_69__a_1017_47# VGND sky130_fd_pr__nfet_01v8 w=360000u l=150000u
** [instance X14 of sky130_fd_pr__nfet_01v8, params={'w': '360000u', 'l': '150000u'} connections=['d: [connection X14/d =>[signal: a_634_159# w=1]]', 'g: [connection X14/g =>[signal: a_193_47# w=1]]', 's: [connection X14/s =>[signal: a_891_413# w=1]]', 'b: [connection X14/b =>[signal: VNB w=1]]']]
X_X_69__14 X_69__a_634_159# X_69__a_193_47# X_69__a_891_413# VGND sky130_fd_pr__nfet_01v8 w=360000u l=150000u
** [instance X15 of sky130_fd_pr__nfet_01v8, params={'w': '420000u', 'l': '150000u'} connections=['d: [connection X15/d =>[signal: a_592_47# w=1]]', 'g: [connection X15/g =>[signal: a_634_159# w=1]]', 's: [connection X15/s =>[signal: VGND w=1]]', 'b: [connection X15/b =>[signal: VNB w=1]]']]
X_X_69__15 X_69__a_592_47# X_69__a_634_159# VGND VGND sky130_fd_pr__nfet_01v8 w=420000u l=150000u
** [instance X16 of sky130_fd_pr__nfet_01v8, params={'w': '360000u', 'l': '150000u'} connections=['d: [connection X16/d =>[signal: a_466_413# w=1]]', 'g: [connection X16/g =>[signal: a_193_47# w=1]]', 's: [connection X16/s =>[signal: a_592_47# w=1]]', 'b: [connection X16/b =>[signal: VNB w=1]]']]
X_X_69__16 X_69__a_466_413# X_69__a_193_47# X_69__a_592_47# VGND sky130_fd_pr__nfet_01v8 w=360000u l=150000u
** [instance X17 of sky130_fd_pr__nfet_01v8, params={'w': '420000u', 'l': '150000u'} connections=['d: [connection X17/d =>[signal: VGND w=1]]', 'g: [connection X17/g =>[signal: a_27_47# w=1]]', 's: [connection X17/s =>[signal: a_193_47# w=1]]', 'b: [connection X17/b =>[signal: VNB w=1]]']]
X_X_69__17 VGND X_69__a_27_47# X_69__a_193_47# VGND sky130_fd_pr__nfet_01v8 w=420000u l=150000u
** [instance X18 of sky130_fd_pr__nfet_01v8, params={'w': '360000u', 'l': '150000u'} connections=['d: [connection X18/d =>[signal: a_381_47# w=1]]', 'g: [connection X18/g =>[signal: a_27_47# w=1]]', 's: [connection X18/s =>[signal: a_466_413# w=1]]', 'b: [connection X18/b =>[signal: VNB w=1]]']]
X_X_69__18 X_69__a_381_47# X_69__a_27_47# X_69__a_466_413# VGND sky130_fd_pr__nfet_01v8 w=360000u l=150000u
** [instance X19 of sky130_fd_pr__nfet_01v8, params={'w': '420000u', 'l': '150000u'} connections=['d: [connection X19/d =>[signal: a_27_47# w=1]]', 'g: [connection X19/g =>[signal: CLK w=1]]', 's: [connection X19/s =>[signal: VGND w=1]]', 'b: [connection X19/b =>[signal: VNB w=1]]']]
X_X_69__19 X_69__a_27_47# _71_/CLK VGND VGND sky130_fd_pr__nfet_01v8 w=420000u l=150000u
** [instance X20 of sky130_fd_pr__pfet_01v8_hvt, params={'w': '640000u', 'l': '150000u'} connections=['d: [connection X20/d =>[signal: a_27_47# w=1]]', 'g: [connection X20/g =>[signal: CLK w=1]]', 's: [connection X20/s =>[signal: VPWR w=1]]', 'b: [connection X20/b =>[signal: VPB w=1]]']]
X_X_69__20 X_69__a_27_47# _71_/CLK VPWR VPWR sky130_fd_pr__pfet_01v8_hvt w=640000u l=150000u
** [instance X21 of sky130_fd_pr__nfet_01v8, params={'w': '650000u', 'l': '150000u'} connections=['d: [connection X21/d =>[signal: Q w=1]]', 'g: [connection X21/g =>[signal: a_1059_315# w=1]]', 's: [connection X21/s =>[signal: VGND w=1]]', 'b: [connection X21/b =>[signal: VNB w=1]]']]
X_X_69__21 _69_/Q X_69__a_1059_315# VGND VGND sky130_fd_pr__nfet_01v8 w=650000u l=150000u
** [instance X22 of sky130_fd_pr__pfet_01v8_hvt, params={'w': '640000u', 'l': '150000u'} connections=['d: [connection X22/d =>[signal: VPWR w=1]]', 'g: [connection X22/g =>[signal: a_27_47# w=1]]', 's: [connection X22/s =>[signal: a_193_47# w=1]]', 'b: [connection X22/b =>[signal: VPB w=1]]']]
X_X_69__22 VPWR X_69__a_27_47# X_69__a_193_47# VPWR sky130_fd_pr__pfet_01v8_hvt w=640000u l=150000u
** [instance X23 of sky130_fd_pr__nfet_01v8, params={'w': '420000u', 'l': '150000u'} connections=['d: [connection X23/d =>[signal: VGND w=1]]', 'g: [connection X23/g =>[signal: D w=1]]', 's: [connection X23/s =>[signal: a_381_47# w=1]]', 'b: [connection X23/b =>[signal: VNB w=1]]']]
X_X_69__23 VGND _69_/D X_69__a_381_47# VGND sky130_fd_pr__nfet_01v8 w=420000u l=150000u
** [instance X24 of sky130_fd_pr__pfet_01v8_hvt, params={'w': '420000u', 'l': '150000u'} connections=['d: [connection X24/d =>[signal: a_975_413# w=1]]', 'g: [connection X24/g =>[signal: a_1059_315# w=1]]', 's: [connection X24/s =>[signal: VPWR w=1]]', 'b: [connection X24/b =>[signal: VPB w=1]]']]
X_X_69__24 X_69__a_975_413# X_69__a_1059_315# VPWR VPWR sky130_fd_pr__pfet_01v8_hvt w=420000u l=150000u
** [instance X25 of sky130_fd_pr__nfet_01v8, params={'w': '650000u', 'l': '150000u'} connections=['d: [connection X25/d =>[signal: VGND w=1]]', 'g: [connection X25/g =>[signal: a_1059_315# w=1]]', 's: [connection X25/s =>[signal: Q w=1]]', 'b: [connection X25/b =>[signal: VNB w=1]]']]
X_X_69__25 VGND X_69__a_1059_315# _69_/Q VGND sky130_fd_pr__nfet_01v8 w=650000u l=150000u

** replacing XPHY_EDGE_ROW_8_Left_22 with the contents of sky130_fd_sc_hd__decap_3
** [instance X0 of sky130_fd_pr__pfet_01v8_hvt, params={'w': '870000u', 'l': '590000u'} connections=['d: [connection X0/d =>[signal: VPWR w=1]]', 'g: [connection X0/g =>[signal: VGND w=1]]', 's: [connection X0/s =>[signal: VPWR w=1]]', 'b: [connection X0/b =>[signal: VPB w=1]]']]
X_XPHY_EDGE_ROW_8_Left_22_0 VPWR VGND VPWR VPWR sky130_fd_pr__pfet_01v8_hvt w=870000u l=590000u
** [instance X1 of sky130_fd_pr__nfet_01v8, params={'w': '550000u', 'l': '590000u'} connections=['d: [connection X1/d =>[signal: VGND w=1]]', 'g: [connection X1/g =>[signal: VPWR w=1]]', 's: [connection X1/s =>[signal: VGND w=1]]', 'b: [connection X1/b =>[signal: VNB w=1]]']]
X_XPHY_EDGE_ROW_8_Left_22_1 VGND VPWR VGND VGND sky130_fd_pr__nfet_01v8 w=550000u l=590000u

** replacing XFILLER_12_74 with the contents of sky130_fd_sc_hd__fill_1

** replacing XTAP_TAPCELL_ROW_12_41 with the contents of sky130_fd_sc_hd__tapvpwrvgnd_1

** replacing XFILLER_3_54 with the contents of sky130_fd_sc_hd__fill_2

** replacing X_68_ with the contents of sky130_fd_sc_hd__dfxtp_2
** [instance X0 of sky130_fd_pr__pfet_01v8_hvt, params={'w': '420000u', 'l': '150000u'} connections=['d: [connection X0/d =>[signal: a_891_413# w=1]]', 'g: [connection X0/g =>[signal: a_193_47# w=1]]', 's: [connection X0/s =>[signal: a_975_413# w=1]]', 'b: [connection X0/b =>[signal: VPB w=1]]']]
X_X_68__0 X_68__a_891_413# X_68__a_193_47# X_68__a_975_413# VPWR sky130_fd_pr__pfet_01v8_hvt w=420000u l=150000u
** [instance X1 of sky130_fd_pr__nfet_01v8, params={'w': '650000u', 'l': '150000u'} connections=['d: [connection X1/d =>[signal: a_1059_315# w=1]]', 'g: [connection X1/g =>[signal: a_891_413# w=1]]', 's: [connection X1/s =>[signal: VGND w=1]]', 'b: [connection X1/b =>[signal: VNB w=1]]']]
X_X_68__1 X_68__a_1059_315# X_68__a_891_413# VGND VGND sky130_fd_pr__nfet_01v8 w=650000u l=150000u
** [instance X2 of sky130_fd_pr__pfet_01v8_hvt, params={'w': '420000u', 'l': '150000u'} connections=['d: [connection X2/d =>[signal: a_466_413# w=1]]', 'g: [connection X2/g =>[signal: a_27_47# w=1]]', 's: [connection X2/s =>[signal: a_561_413# w=1]]', 'b: [connection X2/b =>[signal: VPB w=1]]']]
X_X_68__2 X_68__a_466_413# X_68__a_27_47# X_68__a_561_413# VPWR sky130_fd_pr__pfet_01v8_hvt w=420000u l=150000u
** [instance X3 of sky130_fd_pr__pfet_01v8_hvt, params={'w': '420000u', 'l': '150000u'} connections=['d: [connection X3/d =>[signal: a_634_159# w=1]]', 'g: [connection X3/g =>[signal: a_27_47# w=1]]', 's: [connection X3/s =>[signal: a_891_413# w=1]]', 'b: [connection X3/b =>[signal: VPB w=1]]']]
X_X_68__3 X_68__a_634_159# X_68__a_27_47# X_68__a_891_413# VPWR sky130_fd_pr__pfet_01v8_hvt w=420000u l=150000u
** [instance X4 of sky130_fd_pr__pfet_01v8_hvt, params={'w': '420000u', 'l': '150000u'} connections=['d: [connection X4/d =>[signal: a_381_47# w=1]]', 'g: [connection X4/g =>[signal: a_193_47# w=1]]', 's: [connection X4/s =>[signal: a_466_413# w=1]]', 'b: [connection X4/b =>[signal: VPB w=1]]']]
X_X_68__4 X_68__a_381_47# X_68__a_193_47# X_68__a_466_413# VPWR sky130_fd_pr__pfet_01v8_hvt w=420000u l=150000u
** [instance X5 of sky130_fd_pr__pfet_01v8_hvt, params={'w': '420000u', 'l': '150000u'} connections=['d: [connection X5/d =>[signal: VPWR w=1]]', 'g: [connection X5/g =>[signal: D w=1]]', 's: [connection X5/s =>[signal: a_381_47# w=1]]', 'b: [connection X5/b =>[signal: VPB w=1]]']]
X_X_68__5 VPWR _68_/D X_68__a_381_47# VPWR sky130_fd_pr__pfet_01v8_hvt w=420000u l=150000u
** [instance X6 of sky130_fd_pr__pfet_01v8_hvt, params={'w': '750000u', 'l': '150000u'} connections=['d: [connection X6/d =>[signal: VPWR w=1]]', 'g: [connection X6/g =>[signal: a_466_413# w=1]]', 's: [connection X6/s =>[signal: a_634_159# w=1]]', 'b: [connection X6/b =>[signal: VPB w=1]]']]
X_X_68__6 VPWR X_68__a_466_413# X_68__a_634_159# VPWR sky130_fd_pr__pfet_01v8_hvt w=750000u l=150000u
** [instance X7 of sky130_fd_pr__nfet_01v8, params={'w': '640000u', 'l': '150000u'} connections=['d: [connection X7/d =>[signal: VGND w=1]]', 'g: [connection X7/g =>[signal: a_466_413# w=1]]', 's: [connection X7/s =>[signal: a_634_159# w=1]]', 'b: [connection X7/b =>[signal: VNB w=1]]']]
X_X_68__7 VGND X_68__a_466_413# X_68__a_634_159# VGND sky130_fd_pr__nfet_01v8 w=640000u l=150000u
** [instance X8 of sky130_fd_pr__nfet_01v8, params={'w': '420000u', 'l': '150000u'} connections=['d: [connection X8/d =>[signal: a_1017_47# w=1]]', 'g: [connection X8/g =>[signal: a_1059_315# w=1]]', 's: [connection X8/s =>[signal: VGND w=1]]', 'b: [connection X8/b =>[signal: VNB w=1]]']]
X_X_68__8 X_68__a_1017_47# X_68__a_1059_315# VGND VGND sky130_fd_pr__nfet_01v8 w=420000u l=150000u
** [instance X9 of sky130_fd_pr__pfet_01v8_hvt, params={'w': '1e+06u', 'l': '150000u'} connections=['d: [connection X9/d =>[signal: a_1059_315# w=1]]', 'g: [connection X9/g =>[signal: a_891_413# w=1]]', 's: [connection X9/s =>[signal: VPWR w=1]]', 'b: [connection X9/b =>[signal: VPB w=1]]']]
X_X_68__9 X_68__a_1059_315# X_68__a_891_413# VPWR VPWR sky130_fd_pr__pfet_01v8_hvt w=1e+06u l=150000u
** [instance X10 of sky130_fd_pr__pfet_01v8_hvt, params={'w': '1e+06u', 'l': '150000u'} connections=['d: [connection X10/d =>[signal: Q w=1]]', 'g: [connection X10/g =>[signal: a_1059_315# w=1]]', 's: [connection X10/s =>[signal: VPWR w=1]]', 'b: [connection X10/b =>[signal: VPB w=1]]']]
X_X_68__10 _68_/Q X_68__a_1059_315# VPWR VPWR sky130_fd_pr__pfet_01v8_hvt w=1e+06u l=150000u
** [instance X11 of sky130_fd_pr__pfet_01v8_hvt, params={'w': '420000u', 'l': '150000u'} connections=['d: [connection X11/d =>[signal: a_561_413# w=1]]', 'g: [connection X11/g =>[signal: a_634_159# w=1]]', 's: [connection X11/s =>[signal: VPWR w=1]]', 'b: [connection X11/b =>[signal: VPB w=1]]']]
X_X_68__11 X_68__a_561_413# X_68__a_634_159# VPWR VPWR sky130_fd_pr__pfet_01v8_hvt w=420000u l=150000u
** [instance X12 of sky130_fd_pr__pfet_01v8_hvt, params={'w': '1e+06u', 'l': '150000u'} connections=['d: [connection X12/d =>[signal: VPWR w=1]]', 'g: [connection X12/g =>[signal: a_1059_315# w=1]]', 's: [connection X12/s =>[signal: Q w=1]]', 'b: [connection X12/b =>[signal: VPB w=1]]']]
X_X_68__12 VPWR X_68__a_1059_315# _68_/Q VPWR sky130_fd_pr__pfet_01v8_hvt w=1e+06u l=150000u
** [instance X13 of sky130_fd_pr__nfet_01v8, params={'w': '360000u', 'l': '150000u'} connections=['d: [connection X13/d =>[signal: a_891_413# w=1]]', 'g: [connection X13/g =>[signal: a_27_47# w=1]]', 's: [connection X13/s =>[signal: a_1017_47# w=1]]', 'b: [connection X13/b =>[signal: VNB w=1]]']]
X_X_68__13 X_68__a_891_413# X_68__a_27_47# X_68__a_1017_47# VGND sky130_fd_pr__nfet_01v8 w=360000u l=150000u
** [instance X14 of sky130_fd_pr__nfet_01v8, params={'w': '360000u', 'l': '150000u'} connections=['d: [connection X14/d =>[signal: a_634_159# w=1]]', 'g: [connection X14/g =>[signal: a_193_47# w=1]]', 's: [connection X14/s =>[signal: a_891_413# w=1]]', 'b: [connection X14/b =>[signal: VNB w=1]]']]
X_X_68__14 X_68__a_634_159# X_68__a_193_47# X_68__a_891_413# VGND sky130_fd_pr__nfet_01v8 w=360000u l=150000u
** [instance X15 of sky130_fd_pr__nfet_01v8, params={'w': '420000u', 'l': '150000u'} connections=['d: [connection X15/d =>[signal: a_592_47# w=1]]', 'g: [connection X15/g =>[signal: a_634_159# w=1]]', 's: [connection X15/s =>[signal: VGND w=1]]', 'b: [connection X15/b =>[signal: VNB w=1]]']]
X_X_68__15 X_68__a_592_47# X_68__a_634_159# VGND VGND sky130_fd_pr__nfet_01v8 w=420000u l=150000u
** [instance X16 of sky130_fd_pr__nfet_01v8, params={'w': '360000u', 'l': '150000u'} connections=['d: [connection X16/d =>[signal: a_466_413# w=1]]', 'g: [connection X16/g =>[signal: a_193_47# w=1]]', 's: [connection X16/s =>[signal: a_592_47# w=1]]', 'b: [connection X16/b =>[signal: VNB w=1]]']]
X_X_68__16 X_68__a_466_413# X_68__a_193_47# X_68__a_592_47# VGND sky130_fd_pr__nfet_01v8 w=360000u l=150000u
** [instance X17 of sky130_fd_pr__nfet_01v8, params={'w': '420000u', 'l': '150000u'} connections=['d: [connection X17/d =>[signal: VGND w=1]]', 'g: [connection X17/g =>[signal: a_27_47# w=1]]', 's: [connection X17/s =>[signal: a_193_47# w=1]]', 'b: [connection X17/b =>[signal: VNB w=1]]']]
X_X_68__17 VGND X_68__a_27_47# X_68__a_193_47# VGND sky130_fd_pr__nfet_01v8 w=420000u l=150000u
** [instance X18 of sky130_fd_pr__nfet_01v8, params={'w': '360000u', 'l': '150000u'} connections=['d: [connection X18/d =>[signal: a_381_47# w=1]]', 'g: [connection X18/g =>[signal: a_27_47# w=1]]', 's: [connection X18/s =>[signal: a_466_413# w=1]]', 'b: [connection X18/b =>[signal: VNB w=1]]']]
X_X_68__18 X_68__a_381_47# X_68__a_27_47# X_68__a_466_413# VGND sky130_fd_pr__nfet_01v8 w=360000u l=150000u
** [instance X19 of sky130_fd_pr__nfet_01v8, params={'w': '420000u', 'l': '150000u'} connections=['d: [connection X19/d =>[signal: a_27_47# w=1]]', 'g: [connection X19/g =>[signal: CLK w=1]]', 's: [connection X19/s =>[signal: VGND w=1]]', 'b: [connection X19/b =>[signal: VNB w=1]]']]
X_X_68__19 X_68__a_27_47# _71_/CLK VGND VGND sky130_fd_pr__nfet_01v8 w=420000u l=150000u
** [instance X20 of sky130_fd_pr__pfet_01v8_hvt, params={'w': '640000u', 'l': '150000u'} connections=['d: [connection X20/d =>[signal: a_27_47# w=1]]', 'g: [connection X20/g =>[signal: CLK w=1]]', 's: [connection X20/s =>[signal: VPWR w=1]]', 'b: [connection X20/b =>[signal: VPB w=1]]']]
X_X_68__20 X_68__a_27_47# _71_/CLK VPWR VPWR sky130_fd_pr__pfet_01v8_hvt w=640000u l=150000u
** [instance X21 of sky130_fd_pr__nfet_01v8, params={'w': '650000u', 'l': '150000u'} connections=['d: [connection X21/d =>[signal: Q w=1]]', 'g: [connection X21/g =>[signal: a_1059_315# w=1]]', 's: [connection X21/s =>[signal: VGND w=1]]', 'b: [connection X21/b =>[signal: VNB w=1]]']]
X_X_68__21 _68_/Q X_68__a_1059_315# VGND VGND sky130_fd_pr__nfet_01v8 w=650000u l=150000u
** [instance X22 of sky130_fd_pr__pfet_01v8_hvt, params={'w': '640000u', 'l': '150000u'} connections=['d: [connection X22/d =>[signal: VPWR w=1]]', 'g: [connection X22/g =>[signal: a_27_47# w=1]]', 's: [connection X22/s =>[signal: a_193_47# w=1]]', 'b: [connection X22/b =>[signal: VPB w=1]]']]
X_X_68__22 VPWR X_68__a_27_47# X_68__a_193_47# VPWR sky130_fd_pr__pfet_01v8_hvt w=640000u l=150000u
** [instance X23 of sky130_fd_pr__nfet_01v8, params={'w': '420000u', 'l': '150000u'} connections=['d: [connection X23/d =>[signal: VGND w=1]]', 'g: [connection X23/g =>[signal: D w=1]]', 's: [connection X23/s =>[signal: a_381_47# w=1]]', 'b: [connection X23/b =>[signal: VNB w=1]]']]
X_X_68__23 VGND _68_/D X_68__a_381_47# VGND sky130_fd_pr__nfet_01v8 w=420000u l=150000u
** [instance X24 of sky130_fd_pr__pfet_01v8_hvt, params={'w': '420000u', 'l': '150000u'} connections=['d: [connection X24/d =>[signal: a_975_413# w=1]]', 'g: [connection X24/g =>[signal: a_1059_315# w=1]]', 's: [connection X24/s =>[signal: VPWR w=1]]', 'b: [connection X24/b =>[signal: VPB w=1]]']]
X_X_68__24 X_68__a_975_413# X_68__a_1059_315# VPWR VPWR sky130_fd_pr__pfet_01v8_hvt w=420000u l=150000u
** [instance X25 of sky130_fd_pr__nfet_01v8, params={'w': '650000u', 'l': '150000u'} connections=['d: [connection X25/d =>[signal: VGND w=1]]', 'g: [connection X25/g =>[signal: a_1059_315# w=1]]', 's: [connection X25/s =>[signal: Q w=1]]', 'b: [connection X25/b =>[signal: VNB w=1]]']]
X_X_68__25 VGND X_68__a_1059_315# _68_/Q VGND sky130_fd_pr__nfet_01v8 w=650000u l=150000u

** replacing XFILLER_0_55 with the contents of sky130_fd_sc_hd__fill_1

** replacing XPHY_EDGE_ROW_2_Right_2 with the contents of sky130_fd_sc_hd__decap_3
** [instance X0 of sky130_fd_pr__pfet_01v8_hvt, params={'w': '870000u', 'l': '590000u'} connections=['d: [connection X0/d =>[signal: VPWR w=1]]', 'g: [connection X0/g =>[signal: VGND w=1]]', 's: [connection X0/s =>[signal: VPWR w=1]]', 'b: [connection X0/b =>[signal: VPB w=1]]']]
X_XPHY_EDGE_ROW_2_Right_2_0 VPWR VGND VPWR VPWR sky130_fd_pr__pfet_01v8_hvt w=870000u l=590000u
** [instance X1 of sky130_fd_pr__nfet_01v8, params={'w': '550000u', 'l': '590000u'} connections=['d: [connection X1/d =>[signal: VGND w=1]]', 'g: [connection X1/g =>[signal: VPWR w=1]]', 's: [connection X1/s =>[signal: VGND w=1]]', 'b: [connection X1/b =>[signal: VNB w=1]]']]
X_XPHY_EDGE_ROW_2_Right_2_1 VGND VPWR VGND VGND sky130_fd_pr__nfet_01v8 w=550000u l=590000u

** replacing XFILLER_7_6 with the contents of sky130_fd_sc_hd__fill_2

** replacing X_67_ with the contents of sky130_fd_sc_hd__dfxtp_2
** [instance X0 of sky130_fd_pr__pfet_01v8_hvt, params={'w': '420000u', 'l': '150000u'} connections=['d: [connection X0/d =>[signal: a_891_413# w=1]]', 'g: [connection X0/g =>[signal: a_193_47# w=1]]', 's: [connection X0/s =>[signal: a_975_413# w=1]]', 'b: [connection X0/b =>[signal: VPB w=1]]']]
X_X_67__0 X_67__a_891_413# X_67__a_193_47# X_67__a_975_413# VPWR sky130_fd_pr__pfet_01v8_hvt w=420000u l=150000u
** [instance X1 of sky130_fd_pr__nfet_01v8, params={'w': '650000u', 'l': '150000u'} connections=['d: [connection X1/d =>[signal: a_1059_315# w=1]]', 'g: [connection X1/g =>[signal: a_891_413# w=1]]', 's: [connection X1/s =>[signal: VGND w=1]]', 'b: [connection X1/b =>[signal: VNB w=1]]']]
X_X_67__1 X_67__a_1059_315# X_67__a_891_413# VGND VGND sky130_fd_pr__nfet_01v8 w=650000u l=150000u
** [instance X2 of sky130_fd_pr__pfet_01v8_hvt, params={'w': '420000u', 'l': '150000u'} connections=['d: [connection X2/d =>[signal: a_466_413# w=1]]', 'g: [connection X2/g =>[signal: a_27_47# w=1]]', 's: [connection X2/s =>[signal: a_561_413# w=1]]', 'b: [connection X2/b =>[signal: VPB w=1]]']]
X_X_67__2 X_67__a_466_413# X_67__a_27_47# X_67__a_561_413# VPWR sky130_fd_pr__pfet_01v8_hvt w=420000u l=150000u
** [instance X3 of sky130_fd_pr__pfet_01v8_hvt, params={'w': '420000u', 'l': '150000u'} connections=['d: [connection X3/d =>[signal: a_634_159# w=1]]', 'g: [connection X3/g =>[signal: a_27_47# w=1]]', 's: [connection X3/s =>[signal: a_891_413# w=1]]', 'b: [connection X3/b =>[signal: VPB w=1]]']]
X_X_67__3 X_67__a_634_159# X_67__a_27_47# X_67__a_891_413# VPWR sky130_fd_pr__pfet_01v8_hvt w=420000u l=150000u
** [instance X4 of sky130_fd_pr__pfet_01v8_hvt, params={'w': '420000u', 'l': '150000u'} connections=['d: [connection X4/d =>[signal: a_381_47# w=1]]', 'g: [connection X4/g =>[signal: a_193_47# w=1]]', 's: [connection X4/s =>[signal: a_466_413# w=1]]', 'b: [connection X4/b =>[signal: VPB w=1]]']]
X_X_67__4 X_67__a_381_47# X_67__a_193_47# X_67__a_466_413# VPWR sky130_fd_pr__pfet_01v8_hvt w=420000u l=150000u
** [instance X5 of sky130_fd_pr__pfet_01v8_hvt, params={'w': '420000u', 'l': '150000u'} connections=['d: [connection X5/d =>[signal: VPWR w=1]]', 'g: [connection X5/g =>[signal: D w=1]]', 's: [connection X5/s =>[signal: a_381_47# w=1]]', 'b: [connection X5/b =>[signal: VPB w=1]]']]
X_X_67__5 VPWR _67_/D X_67__a_381_47# VPWR sky130_fd_pr__pfet_01v8_hvt w=420000u l=150000u
** [instance X6 of sky130_fd_pr__pfet_01v8_hvt, params={'w': '750000u', 'l': '150000u'} connections=['d: [connection X6/d =>[signal: VPWR w=1]]', 'g: [connection X6/g =>[signal: a_466_413# w=1]]', 's: [connection X6/s =>[signal: a_634_159# w=1]]', 'b: [connection X6/b =>[signal: VPB w=1]]']]
X_X_67__6 VPWR X_67__a_466_413# X_67__a_634_159# VPWR sky130_fd_pr__pfet_01v8_hvt w=750000u l=150000u
** [instance X7 of sky130_fd_pr__nfet_01v8, params={'w': '640000u', 'l': '150000u'} connections=['d: [connection X7/d =>[signal: VGND w=1]]', 'g: [connection X7/g =>[signal: a_466_413# w=1]]', 's: [connection X7/s =>[signal: a_634_159# w=1]]', 'b: [connection X7/b =>[signal: VNB w=1]]']]
X_X_67__7 VGND X_67__a_466_413# X_67__a_634_159# VGND sky130_fd_pr__nfet_01v8 w=640000u l=150000u
** [instance X8 of sky130_fd_pr__nfet_01v8, params={'w': '420000u', 'l': '150000u'} connections=['d: [connection X8/d =>[signal: a_1017_47# w=1]]', 'g: [connection X8/g =>[signal: a_1059_315# w=1]]', 's: [connection X8/s =>[signal: VGND w=1]]', 'b: [connection X8/b =>[signal: VNB w=1]]']]
X_X_67__8 X_67__a_1017_47# X_67__a_1059_315# VGND VGND sky130_fd_pr__nfet_01v8 w=420000u l=150000u
** [instance X9 of sky130_fd_pr__pfet_01v8_hvt, params={'w': '1e+06u', 'l': '150000u'} connections=['d: [connection X9/d =>[signal: a_1059_315# w=1]]', 'g: [connection X9/g =>[signal: a_891_413# w=1]]', 's: [connection X9/s =>[signal: VPWR w=1]]', 'b: [connection X9/b =>[signal: VPB w=1]]']]
X_X_67__9 X_67__a_1059_315# X_67__a_891_413# VPWR VPWR sky130_fd_pr__pfet_01v8_hvt w=1e+06u l=150000u
** [instance X10 of sky130_fd_pr__pfet_01v8_hvt, params={'w': '1e+06u', 'l': '150000u'} connections=['d: [connection X10/d =>[signal: Q w=1]]', 'g: [connection X10/g =>[signal: a_1059_315# w=1]]', 's: [connection X10/s =>[signal: VPWR w=1]]', 'b: [connection X10/b =>[signal: VPB w=1]]']]
X_X_67__10 _67_/Q X_67__a_1059_315# VPWR VPWR sky130_fd_pr__pfet_01v8_hvt w=1e+06u l=150000u
** [instance X11 of sky130_fd_pr__pfet_01v8_hvt, params={'w': '420000u', 'l': '150000u'} connections=['d: [connection X11/d =>[signal: a_561_413# w=1]]', 'g: [connection X11/g =>[signal: a_634_159# w=1]]', 's: [connection X11/s =>[signal: VPWR w=1]]', 'b: [connection X11/b =>[signal: VPB w=1]]']]
X_X_67__11 X_67__a_561_413# X_67__a_634_159# VPWR VPWR sky130_fd_pr__pfet_01v8_hvt w=420000u l=150000u
** [instance X12 of sky130_fd_pr__pfet_01v8_hvt, params={'w': '1e+06u', 'l': '150000u'} connections=['d: [connection X12/d =>[signal: VPWR w=1]]', 'g: [connection X12/g =>[signal: a_1059_315# w=1]]', 's: [connection X12/s =>[signal: Q w=1]]', 'b: [connection X12/b =>[signal: VPB w=1]]']]
X_X_67__12 VPWR X_67__a_1059_315# _67_/Q VPWR sky130_fd_pr__pfet_01v8_hvt w=1e+06u l=150000u
** [instance X13 of sky130_fd_pr__nfet_01v8, params={'w': '360000u', 'l': '150000u'} connections=['d: [connection X13/d =>[signal: a_891_413# w=1]]', 'g: [connection X13/g =>[signal: a_27_47# w=1]]', 's: [connection X13/s =>[signal: a_1017_47# w=1]]', 'b: [connection X13/b =>[signal: VNB w=1]]']]
X_X_67__13 X_67__a_891_413# X_67__a_27_47# X_67__a_1017_47# VGND sky130_fd_pr__nfet_01v8 w=360000u l=150000u
** [instance X14 of sky130_fd_pr__nfet_01v8, params={'w': '360000u', 'l': '150000u'} connections=['d: [connection X14/d =>[signal: a_634_159# w=1]]', 'g: [connection X14/g =>[signal: a_193_47# w=1]]', 's: [connection X14/s =>[signal: a_891_413# w=1]]', 'b: [connection X14/b =>[signal: VNB w=1]]']]
X_X_67__14 X_67__a_634_159# X_67__a_193_47# X_67__a_891_413# VGND sky130_fd_pr__nfet_01v8 w=360000u l=150000u
** [instance X15 of sky130_fd_pr__nfet_01v8, params={'w': '420000u', 'l': '150000u'} connections=['d: [connection X15/d =>[signal: a_592_47# w=1]]', 'g: [connection X15/g =>[signal: a_634_159# w=1]]', 's: [connection X15/s =>[signal: VGND w=1]]', 'b: [connection X15/b =>[signal: VNB w=1]]']]
X_X_67__15 X_67__a_592_47# X_67__a_634_159# VGND VGND sky130_fd_pr__nfet_01v8 w=420000u l=150000u
** [instance X16 of sky130_fd_pr__nfet_01v8, params={'w': '360000u', 'l': '150000u'} connections=['d: [connection X16/d =>[signal: a_466_413# w=1]]', 'g: [connection X16/g =>[signal: a_193_47# w=1]]', 's: [connection X16/s =>[signal: a_592_47# w=1]]', 'b: [connection X16/b =>[signal: VNB w=1]]']]
X_X_67__16 X_67__a_466_413# X_67__a_193_47# X_67__a_592_47# VGND sky130_fd_pr__nfet_01v8 w=360000u l=150000u
** [instance X17 of sky130_fd_pr__nfet_01v8, params={'w': '420000u', 'l': '150000u'} connections=['d: [connection X17/d =>[signal: VGND w=1]]', 'g: [connection X17/g =>[signal: a_27_47# w=1]]', 's: [connection X17/s =>[signal: a_193_47# w=1]]', 'b: [connection X17/b =>[signal: VNB w=1]]']]
X_X_67__17 VGND X_67__a_27_47# X_67__a_193_47# VGND sky130_fd_pr__nfet_01v8 w=420000u l=150000u
** [instance X18 of sky130_fd_pr__nfet_01v8, params={'w': '360000u', 'l': '150000u'} connections=['d: [connection X18/d =>[signal: a_381_47# w=1]]', 'g: [connection X18/g =>[signal: a_27_47# w=1]]', 's: [connection X18/s =>[signal: a_466_413# w=1]]', 'b: [connection X18/b =>[signal: VNB w=1]]']]
X_X_67__18 X_67__a_381_47# X_67__a_27_47# X_67__a_466_413# VGND sky130_fd_pr__nfet_01v8 w=360000u l=150000u
** [instance X19 of sky130_fd_pr__nfet_01v8, params={'w': '420000u', 'l': '150000u'} connections=['d: [connection X19/d =>[signal: a_27_47# w=1]]', 'g: [connection X19/g =>[signal: CLK w=1]]', 's: [connection X19/s =>[signal: VGND w=1]]', 'b: [connection X19/b =>[signal: VNB w=1]]']]
X_X_67__19 X_67__a_27_47# _71_/CLK VGND VGND sky130_fd_pr__nfet_01v8 w=420000u l=150000u
** [instance X20 of sky130_fd_pr__pfet_01v8_hvt, params={'w': '640000u', 'l': '150000u'} connections=['d: [connection X20/d =>[signal: a_27_47# w=1]]', 'g: [connection X20/g =>[signal: CLK w=1]]', 's: [connection X20/s =>[signal: VPWR w=1]]', 'b: [connection X20/b =>[signal: VPB w=1]]']]
X_X_67__20 X_67__a_27_47# _71_/CLK VPWR VPWR sky130_fd_pr__pfet_01v8_hvt w=640000u l=150000u
** [instance X21 of sky130_fd_pr__nfet_01v8, params={'w': '650000u', 'l': '150000u'} connections=['d: [connection X21/d =>[signal: Q w=1]]', 'g: [connection X21/g =>[signal: a_1059_315# w=1]]', 's: [connection X21/s =>[signal: VGND w=1]]', 'b: [connection X21/b =>[signal: VNB w=1]]']]
X_X_67__21 _67_/Q X_67__a_1059_315# VGND VGND sky130_fd_pr__nfet_01v8 w=650000u l=150000u
** [instance X22 of sky130_fd_pr__pfet_01v8_hvt, params={'w': '640000u', 'l': '150000u'} connections=['d: [connection X22/d =>[signal: VPWR w=1]]', 'g: [connection X22/g =>[signal: a_27_47# w=1]]', 's: [connection X22/s =>[signal: a_193_47# w=1]]', 'b: [connection X22/b =>[signal: VPB w=1]]']]
X_X_67__22 VPWR X_67__a_27_47# X_67__a_193_47# VPWR sky130_fd_pr__pfet_01v8_hvt w=640000u l=150000u
** [instance X23 of sky130_fd_pr__nfet_01v8, params={'w': '420000u', 'l': '150000u'} connections=['d: [connection X23/d =>[signal: VGND w=1]]', 'g: [connection X23/g =>[signal: D w=1]]', 's: [connection X23/s =>[signal: a_381_47# w=1]]', 'b: [connection X23/b =>[signal: VNB w=1]]']]
X_X_67__23 VGND _67_/D X_67__a_381_47# VGND sky130_fd_pr__nfet_01v8 w=420000u l=150000u
** [instance X24 of sky130_fd_pr__pfet_01v8_hvt, params={'w': '420000u', 'l': '150000u'} connections=['d: [connection X24/d =>[signal: a_975_413# w=1]]', 'g: [connection X24/g =>[signal: a_1059_315# w=1]]', 's: [connection X24/s =>[signal: VPWR w=1]]', 'b: [connection X24/b =>[signal: VPB w=1]]']]
X_X_67__24 X_67__a_975_413# X_67__a_1059_315# VPWR VPWR sky130_fd_pr__pfet_01v8_hvt w=420000u l=150000u
** [instance X25 of sky130_fd_pr__nfet_01v8, params={'w': '650000u', 'l': '150000u'} connections=['d: [connection X25/d =>[signal: VGND w=1]]', 'g: [connection X25/g =>[signal: a_1059_315# w=1]]', 's: [connection X25/s =>[signal: Q w=1]]', 'b: [connection X25/b =>[signal: VNB w=1]]']]
X_X_67__25 VGND X_67__a_1059_315# _67_/Q VGND sky130_fd_pr__nfet_01v8 w=650000u l=150000u

** replacing XFILLER_5_3 with the contents of sky130_fd_sc_hd__decap_3
** [instance X0 of sky130_fd_pr__pfet_01v8_hvt, params={'w': '870000u', 'l': '590000u'} connections=['d: [connection X0/d =>[signal: VPWR w=1]]', 'g: [connection X0/g =>[signal: VGND w=1]]', 's: [connection X0/s =>[signal: VPWR w=1]]', 'b: [connection X0/b =>[signal: VPB w=1]]']]
X_XFILLER_5_3_0 VPWR VGND VPWR VPWR sky130_fd_pr__pfet_01v8_hvt w=870000u l=590000u
** [instance X1 of sky130_fd_pr__nfet_01v8, params={'w': '550000u', 'l': '590000u'} connections=['d: [connection X1/d =>[signal: VGND w=1]]', 'g: [connection X1/g =>[signal: VPWR w=1]]', 's: [connection X1/s =>[signal: VGND w=1]]', 'b: [connection X1/b =>[signal: VNB w=1]]']]
X_XFILLER_5_3_1 VGND VPWR VGND VGND sky130_fd_pr__nfet_01v8 w=550000u l=590000u

** replacing XFILLER_9_54 with the contents of sky130_fd_sc_hd__fill_2

** [instance C0 of CAPACITOR, params={'capacitance': 0.000972149 prefix:SIUnitPrefix.PICO} connections=['A: [connection C0/A =>[signal: VSS w=1]]', 'B: [connection C0/B =>[slice: addr[0:0]]]']]
C0 VSS addr.0  C=9.72149E-16
** [instance C1 of CAPACITOR, params={'capacitance': 0.000918182 prefix:SIUnitPrefix.PICO} connections=['A: [connection C1/A =>[signal: VSS w=1]]', 'B: [connection C1/B =>[slice: addr[1:1]]]']]
C1 VSS addr.1  C=9.18182E-16
** [instance C2 of CAPACITOR, params={'capacitance': 0.000782325 prefix:SIUnitPrefix.PICO} connections=['A: [connection C2/A =>[signal: VSS w=1]]', 'B: [connection C2/B =>[slice: addr[2:2]]]']]
C2 VSS addr.2  C=7.823249999999999E-16
** [instance C3 of CAPACITOR, params={'capacitance': 0.00121992 prefix:SIUnitPrefix.PICO} connections=['A: [connection C3/A =>[signal: VSS w=1]]', 'B: [connection C3/B =>[slice: addr[3:3]]]']]
C3 VSS addr.3  C=1.21992E-15
** [instance C4 of CAPACITOR, params={'capacitance': 0.000891769 prefix:SIUnitPrefix.PICO} connections=['A: [connection C4/A =>[signal: VSS w=1]]', 'B: [connection C4/B =>[signal: clk w=1]]']]
C4 VSS clk  C=8.91769E-16
** [instance C5 of CAPACITOR, params={'capacitance': 0.000412011 prefix:SIUnitPrefix.PICO} connections=['A: [connection C5/A =>[signal: VSS w=1]]', 'B: [connection C5/B =>[signal: mux w=1]]']]
C5 VSS mux  C=4.12011E-16
** [instance C6 of CAPACITOR, params={'capacitance': 0.00105989 prefix:SIUnitPrefix.PICO} connections=['A: [connection C6/A =>[signal: VSS w=1]]', 'B: [connection C6/B =>[signal: q w=1]]']]
C6 VSS q  C=1.05989E-15
** [instance C7 of CAPACITOR, params={'capacitance': 0.00177182 prefix:SIUnitPrefix.PICO} connections=['A: [connection C7/A =>[signal: VSS w=1]]', 'B: [connection C7/B =>[signal: scan_clk w=1]]']]
C7 VSS scan_clk  C=1.7718199999999999E-15
** [instance C8 of CAPACITOR, params={'capacitance': 0.000467448 prefix:SIUnitPrefix.PICO} connections=['A: [connection C8/A =>[signal: VSS w=1]]', 'B: [connection C8/B =>[signal: scan_en w=1]]']]
C8 VSS scan_en  C=4.67448E-16
** [instance C9 of CAPACITOR, params={'capacitance': 0.00153788 prefix:SIUnitPrefix.PICO} connections=['A: [connection C9/A =>[signal: VSS w=1]]', 'B: [connection C9/B =>[signal: scan_in w=1]]']]
C9 VSS scan_in  C=1.5378799999999999E-15
** [instance C10 of CAPACITOR, params={'capacitance': 0.00063607 prefix:SIUnitPrefix.PICO} connections=['A: [connection C10/A =>[signal: VSS w=1]]', 'B: [connection C10/B =>[signal: scan_out w=1]]']]
C10 VSS scan_out  C=6.3607E-16
** [instance C11 of CAPACITOR, params={'capacitance': 0.000540073 prefix:SIUnitPrefix.PICO} connections=['A: [connection C11/A =>[signal: VSS w=1]]', 'B: [connection C11/B =>[signal: x w=1]]']]
C11 VSS x  C=5.40073E-16
** [instance C12 of CAPACITOR, params={'capacitance': 0.000972149 prefix:SIUnitPrefix.PICO} connections=['A: [connection C12/A =>[signal: input1:A w=1]]', 'B: [connection C12/B =>[signal: VSS w=1]]']]
C12 input1:A VSS  C=9.72149E-16
** [instance C13 of CAPACITOR, params={'capacitance': 0.000113626 prefix:SIUnitPrefix.PICO} connections=['A: [connection C13/A =>[signal: input1:A w=1]]', 'B: [connection C13/B =>[signal: input2:A w=1]]']]
C13 input1:A input2:A  C=1.13626E-16
** [instance C14 of CAPACITOR, params={'capacitance': 5.67975e-05 prefix:SIUnitPrefix.PICO} connections=['A: [connection C14/A =>[signal: input1:A w=1]]', 'B: [connection C14/B =>[signal: input6:A w=1]]']]
C14 input1:A input6:A  C=5.67975E-17
** [instance C15 of CAPACITOR, params={'capacitance': 0.0 prefix:SIUnitPrefix.PICO} connections=['A: [connection C15/A =>[signal: scan_clk:18 w=1]]', 'B: [connection C15/B =>[signal: input1:A w=1]]']]
** C15 scan_clk:18 input1:A  C=0.0 [skipped because C=0]
** [instance C16 of CAPACITOR, params={'capacitance': 0.000233872 prefix:SIUnitPrefix.PICO} connections=['A: [connection C16/A =>[signal: scan_clk:18 w=1]]', 'B: [connection C16/B =>[signal: input2:A w=1]]']]
C16 scan_clk:18 input2:A  C=2.3387200000000003E-16
** [instance C17 of CAPACITOR, params={'capacitance': 0.00188054 prefix:SIUnitPrefix.PICO} connections=['A: [connection C17/A =>[signal: scan_clk:18 w=1]]', 'B: [connection C17/B =>[signal: VSS w=1]]']]
C17 scan_clk:18 VSS  C=1.88054E-15
** [instance C18 of CAPACITOR, params={'capacitance': 0.0 prefix:SIUnitPrefix.PICO} connections=['A: [connection C18/A =>[signal: scan_clk:18 w=1]]', 'B: [connection C18/B =>[signal: _67_:D w=1]]']]
** C18 scan_clk:18 _67_:D  C=0.0 [skipped because C=0]
** [instance C19 of CAPACITOR, params={'capacitance': 0.000295537 prefix:SIUnitPrefix.PICO} connections=['A: [connection C19/A =>[signal: scan_clk:18 w=1]]', 'B: [connection C19/B =>[signal: input6:A w=1]]']]
C19 scan_clk:18 input6:A  C=2.95537E-16
** [instance C20 of CAPACITOR, params={'capacitance': 3.65826e-05 prefix:SIUnitPrefix.PICO} connections=['A: [connection C20/A =>[signal: scan_clk:18 w=1]]', 'B: [connection C20/B =>[signal: clknet_0_scan_clk:33 w=1]]']]
C20 scan_clk:18 clknet_0_scan_clk:33  C=3.6582599999999995E-17
** [instance C21 of CAPACITOR, params={'capacitance': 0.0 prefix:SIUnitPrefix.PICO} connections=['A: [connection C21/A =>[signal: scan_clk:18 w=1]]', 'B: [connection C21/B =>[signal: clknet_1_0__leaf_scan_clk:10 w=1]]']]
** C21 scan_clk:18 clknet_1_0__leaf_scan_clk:10  C=0.0 [skipped because C=0]
** [instance C22 of CAPACITOR, params={'capacitance': 4.00537e-05 prefix:SIUnitPrefix.PICO} connections=['A: [connection C22/A =>[signal: scan_clk:18 w=1]]', 'B: [connection C22/B =>[signal: mem[8]:10 w=1]]']]
C22 scan_clk:18 mem[8]:10  C=4.00537E-17
** [instance C23 of CAPACITOR, params={'capacitance': 0.000918182 prefix:SIUnitPrefix.PICO} connections=['A: [connection C23/A =>[signal: input2:A w=1]]', 'B: [connection C23/B =>[signal: VSS w=1]]']]
C23 input2:A VSS  C=9.18182E-16
** [instance C24 of CAPACITOR, params={'capacitance': 0.000247249 prefix:SIUnitPrefix.PICO} connections=['A: [connection C24/A =>[signal: input2:A w=1]]', 'B: [connection C24/B =>[signal: input6:A w=1]]']]
C24 input2:A input6:A  C=2.47249E-16
** [instance C25 of CAPACITOR, params={'capacitance': 2.59355e-05 prefix:SIUnitPrefix.PICO} connections=['A: [connection C25/A =>[signal: input2:A w=1]]', 'B: [connection C25/B =>[signal: net6:6 w=1]]']]
C25 input2:A net6:6  C=2.59355E-17
** [instance C26 of CAPACITOR, params={'capacitance': 0.0 prefix:SIUnitPrefix.PICO} connections=['A: [connection C26/A =>[signal: _67_:D w=1]]', 'B: [connection C26/B =>[signal: input2:A w=1]]']]
** C26 _67_:D input2:A  C=0.0 [skipped because C=0]
** [instance C27 of CAPACITOR, params={'capacitance': 1.76699e-05 prefix:SIUnitPrefix.PICO} connections=['A: [connection C27/A =>[signal: _67_:D w=1]]', 'B: [connection C27/B =>[signal: input6:A w=1]]']]
C27 _67_:D input6:A  C=1.76699E-17
** [instance C28 of CAPACITOR, params={'capacitance': 0.0 prefix:SIUnitPrefix.PICO} connections=['A: [connection C28/A =>[signal: _67_:D w=1]]', 'B: [connection C28/B =>[signal: _09_:12 w=1]]']]
** C28 _67_:D _09_:12  C=0.0 [skipped because C=0]
** [instance C29 of CAPACITOR, params={'capacitance': 0.000188194 prefix:SIUnitPrefix.PICO} connections=['A: [connection C29/A =>[signal: _67_:D w=1]]', 'B: [connection C29/B =>[signal: clknet_1_0__leaf_scan_clk:10 w=1]]']]
C29 _67_:D clknet_1_0__leaf_scan_clk:10  C=1.88194E-16
** [instance C30 of CAPACITOR, params={'capacitance': 0.000213802 prefix:SIUnitPrefix.PICO} connections=['A: [connection C30/A =>[signal: _67_:D w=1]]', 'B: [connection C30/B =>[signal: clknet_1_0__leaf_scan_clk:12 w=1]]']]
C30 _67_:D clknet_1_0__leaf_scan_clk:12  C=2.13802E-16
** [instance C31 of CAPACITOR, params={'capacitance': 4.46186e-06 prefix:SIUnitPrefix.PICO} connections=['A: [connection C31/A =>[signal: _67_:D w=1]]', 'B: [connection C31/B =>[signal: clknet_1_0__leaf_scan_clk:14 w=1]]']]
C31 _67_:D clknet_1_0__leaf_scan_clk:14  C=4.46186E-18
** [instance C32 of CAPACITOR, params={'capacitance': 0.000174918 prefix:SIUnitPrefix.PICO} connections=['A: [connection C32/A =>[signal: _67_:D w=1]]', 'B: [connection C32/B =>[signal: net12:22 w=1]]']]
C32 _67_:D net12:22  C=1.74918E-16
** [instance C33 of CAPACITOR, params={'capacitance': 0.000402286 prefix:SIUnitPrefix.PICO} connections=['A: [connection C33/A =>[signal: _67_:D w=1]]', 'B: [connection C33/B =>[signal: net12:26 w=1]]']]
C33 _67_:D net12:26  C=4.02286E-16
** [instance C34 of CAPACITOR, params={'capacitance': 0.000396804 prefix:SIUnitPrefix.PICO} connections=['A: [connection C34/A =>[signal: _67_:D w=1]]', 'B: [connection C34/B =>[signal: net12:32 w=1]]']]
C34 _67_:D net12:32  C=3.96804E-16
** [instance C35 of CAPACITOR, params={'capacitance': 0.000565997 prefix:SIUnitPrefix.PICO} connections=['A: [connection C35/A =>[signal: _67_:D w=1]]', 'B: [connection C35/B =>[signal: VSS w=1]]']]
C35 _67_:D VSS  C=5.659970000000001E-16
** [instance C36 of CAPACITOR, params={'capacitance': 0.00145364 prefix:SIUnitPrefix.PICO} connections=['A: [connection C36/A =>[signal: input3:A w=1]]', 'B: [connection C36/B =>[signal: VSS w=1]]']]
C36 input3:A VSS  C=1.4536399999999999E-15
** [instance C37 of CAPACITOR, params={'capacitance': 9.90367e-05 prefix:SIUnitPrefix.PICO} connections=['A: [connection C37/A =>[signal: input3:A w=1]]', 'B: [connection C37/B =>[signal: input7:A w=1]]']]
C37 input3:A input7:A  C=9.903669999999999E-17
** [instance C38 of CAPACITOR, params={'capacitance': 2.34204e-05 prefix:SIUnitPrefix.PICO} connections=['A: [connection C38/A =>[signal: input3:A w=1]]', 'B: [connection C38/B =>[signal: net22:12 w=1]]']]
C38 input3:A net22:12  C=2.34204E-17
** [instance C39 of CAPACITOR, params={'capacitance': 0.0 prefix:SIUnitPrefix.PICO} connections=['A: [connection C39/A =>[signal: input3:A w=1]]', 'B: [connection C39/B =>[signal: net3:12 w=1]]']]
** C39 input3:A net3:12  C=0.0 [skipped because C=0]
** [instance C40 of CAPACITOR, params={'capacitance': 0.0 prefix:SIUnitPrefix.PICO} connections=['A: [connection C40/A =>[signal: input3:A w=1]]', 'B: [connection C40/B =>[signal: net37:14 w=1]]']]
** C40 input3:A net37:14  C=0.0 [skipped because C=0]
** [instance C41 of CAPACITOR, params={'capacitance': 0.0 prefix:SIUnitPrefix.PICO} connections=['A: [connection C41/A =>[signal: input3:A w=1]]', 'B: [connection C41/B =>[signal: net4:18 w=1]]']]
** C41 input3:A net4:18  C=0.0 [skipped because C=0]
** [instance C42 of CAPACITOR, params={'capacitance': 0.00223596 prefix:SIUnitPrefix.PICO} connections=['A: [connection C42/A =>[signal: addr.2:11 w=1]]', 'B: [connection C42/B =>[signal: VSS w=1]]']]
C42 addr.2:11 VSS  C=2.2359599999999998E-15
** [instance C43 of CAPACITOR, params={'capacitance': 0.000246782 prefix:SIUnitPrefix.PICO} connections=['A: [connection C43/A =>[signal: _50_:A1 w=1]]', 'B: [connection C43/B =>[signal: input3:A w=1]]']]
C43 _50_:A1 input3:A  C=2.46782E-16
** [instance C44 of CAPACITOR, params={'capacitance': 0.000336946 prefix:SIUnitPrefix.PICO} connections=['A: [connection C44/A =>[signal: _50_:A1 w=1]]', 'B: [connection C44/B =>[signal: _74_:D w=1]]']]
C44 _50_:A1 _74_:D  C=3.36946E-16
** [instance C45 of CAPACITOR, params={'capacitance': 0.0 prefix:SIUnitPrefix.PICO} connections=['A: [connection C45/A =>[signal: _50_:A1 w=1]]', 'B: [connection C45/B =>[signal: hold26:A w=1]]']]
** C45 _50_:A1 hold26:A  C=0.0 [skipped because C=0]
** [instance C46 of CAPACITOR, params={'capacitance': 8.68665e-05 prefix:SIUnitPrefix.PICO} connections=['A: [connection C46/A =>[signal: _50_:A1 w=1]]', 'B: [connection C46/B =>[signal: _50_:S w=1]]']]
C46 _50_:A1 _50_:S  C=8.68665E-17
** [instance C47 of CAPACITOR, params={'capacitance': 0.00033349 prefix:SIUnitPrefix.PICO} connections=['A: [connection C47/A =>[signal: _50_:A1 w=1]]', 'B: [connection C47/B =>[signal: _75_:D w=1]]']]
C47 _50_:A1 _75_:D  C=3.3348999999999997E-16
** [instance C48 of CAPACITOR, params={'capacitance': 0.000209534 prefix:SIUnitPrefix.PICO} connections=['A: [connection C48/A =>[signal: _50_:A1 w=1]]', 'B: [connection C48/B =>[signal: net3:12 w=1]]']]
C48 _50_:A1 net3:12  C=2.09534E-16
** [instance C49 of CAPACITOR, params={'capacitance': 0.000871335 prefix:SIUnitPrefix.PICO} connections=['A: [connection C49/A =>[signal: _50_:A1 w=1]]', 'B: [connection C49/B =>[signal: VSS w=1]]']]
C49 _50_:A1 VSS  C=8.71335E-16
** [instance C50 of CAPACITOR, params={'capacitance': 4.15469e-05 prefix:SIUnitPrefix.PICO} connections=['A: [connection C50/A =>[signal: _50_:A1 w=1]]', 'B: [connection C50/B =>[signal: _56_:A1 w=1]]']]
C50 _50_:A1 _56_:A1  C=4.15469E-17
** [instance C51 of CAPACITOR, params={'capacitance': 0.000173083 prefix:SIUnitPrefix.PICO} connections=['A: [connection C51/A =>[signal: _50_:S w=1]]', 'B: [connection C51/B =>[signal: input3:A w=1]]']]
C51 _50_:S input3:A  C=1.73083E-16
** [instance C52 of CAPACITOR, params={'capacitance': 7.3237e-05 prefix:SIUnitPrefix.PICO} connections=['A: [connection C52/A =>[signal: _50_:S w=1]]', 'B: [connection C52/B =>[signal: hold24:A w=1]]']]
C52 _50_:S hold24:A  C=7.3237E-17
** [instance C53 of CAPACITOR, params={'capacitance': 0.000235485 prefix:SIUnitPrefix.PICO} connections=['A: [connection C53/A =>[signal: _50_:S w=1]]', 'B: [connection C53/B =>[signal: VSS w=1]]']]
C53 _50_:S VSS  C=2.35485E-16
** [instance C54 of CAPACITOR, params={'capacitance': 4.43256e-05 prefix:SIUnitPrefix.PICO} connections=['A: [connection C54/A =>[signal: _50_:S w=1]]', 'B: [connection C54/B =>[signal: net24:10 w=1]]']]
C54 _50_:S net24:10  C=4.43256E-17
** [instance C55 of CAPACITOR, params={'capacitance': 6.57032e-05 prefix:SIUnitPrefix.PICO} connections=['A: [connection C55/A =>[signal: _50_:S w=1]]', 'B: [connection C55/B =>[signal: net26:14 w=1]]']]
C55 _50_:S net26:14  C=6.57032E-17
** [instance C56 of CAPACITOR, params={'capacitance': 0.0 prefix:SIUnitPrefix.PICO} connections=['A: [connection C56/A =>[signal: _56_:A0 w=1]]', 'B: [connection C56/B =>[signal: input3:A w=1]]']]
** C56 _56_:A0 input3:A  C=0.0 [skipped because C=0]
** [instance C57 of CAPACITOR, params={'capacitance': 3.32737e-05 prefix:SIUnitPrefix.PICO} connections=['A: [connection C57/A =>[signal: _56_:A0 w=1]]', 'B: [connection C57/B =>[signal: _75_:CLK w=1]]']]
C57 _56_:A0 _75_:CLK  C=3.32737E-17
** [instance C58 of CAPACITOR, params={'capacitance': 9.71197e-05 prefix:SIUnitPrefix.PICO} connections=['A: [connection C58/A =>[signal: _56_:A0 w=1]]', 'B: [connection C58/B =>[signal: _56_:S w=1]]']]
C58 _56_:A0 _56_:S  C=9.711969999999999E-17
** [instance C59 of CAPACITOR, params={'capacitance': 4.34742e-05 prefix:SIUnitPrefix.PICO} connections=['A: [connection C59/A =>[signal: _56_:A0 w=1]]', 'B: [connection C59/B =>[signal: _75_:D w=1]]']]
C59 _56_:A0 _75_:D  C=4.3474199999999996E-17
** [instance C60 of CAPACITOR, params={'capacitance': 1.02821e-05 prefix:SIUnitPrefix.PICO} connections=['A: [connection C60/A =>[signal: _56_:A0 w=1]]', 'B: [connection C60/B =>[signal: net3:33 w=1]]']]
C60 _56_:A0 net3:33  C=1.0282099999999999E-17
** [instance C61 of CAPACITOR, params={'capacitance': 0.000606476 prefix:SIUnitPrefix.PICO} connections=['A: [connection C61/A =>[signal: _56_:A0 w=1]]', 'B: [connection C61/B =>[signal: VSS w=1]]']]
C61 _56_:A0 VSS  C=6.06476E-16
** [instance C62 of CAPACITOR, params={'capacitance': 9.61553e-05 prefix:SIUnitPrefix.PICO} connections=['A: [connection C62/A =>[signal: _56_:A0 w=1]]', 'B: [connection C62/B =>[signal: _56_:A1 w=1]]']]
C62 _56_:A0 _56_:A1  C=9.615529999999999E-17
** [instance C63 of CAPACITOR, params={'capacitance': 0.00010326 prefix:SIUnitPrefix.PICO} connections=['A: [connection C63/A =>[signal: _56_:A0 w=1]]', 'B: [connection C63/B =>[signal: net37:14 w=1]]']]
C63 _56_:A0 net37:14  C=1.0326E-16
** [instance C64 of CAPACITOR, params={'capacitance': 0.000384643 prefix:SIUnitPrefix.PICO} connections=['A: [connection C64/A =>[signal: _57_:A0 w=1]]', 'B: [connection C64/B =>[signal: input3:A w=1]]']]
C64 _57_:A0 input3:A  C=3.84643E-16
** [instance C65 of CAPACITOR, params={'capacitance': 0.000125555 prefix:SIUnitPrefix.PICO} connections=['A: [connection C65/A =>[signal: _57_:A0 w=1]]', 'B: [connection C65/B =>[signal: hold25:A w=1]]']]
C65 _57_:A0 hold25:A  C=1.25555E-16
** [instance C66 of CAPACITOR, params={'capacitance': 0.000139834 prefix:SIUnitPrefix.PICO} connections=['A: [connection C66/A =>[signal: _57_:A0 w=1]]', 'B: [connection C66/B =>[signal: VSS w=1]]']]
C66 _57_:A0 VSS  C=1.39834E-16
** [instance C67 of CAPACITOR, params={'capacitance': 0.000146474 prefix:SIUnitPrefix.PICO} connections=['A: [connection C67/A =>[signal: _57_:A0 w=1]]', 'B: [connection C67/B =>[signal: net26:14 w=1]]']]
C67 _57_:A0 net26:14  C=1.46474E-16
** [instance C68 of CAPACITOR, params={'capacitance': 2.96805e-05 prefix:SIUnitPrefix.PICO} connections=['A: [connection C68/A =>[signal: _57_:A0 w=1]]', 'B: [connection C68/B =>[signal: net37:14 w=1]]']]
C68 _57_:A0 net37:14  C=2.96805E-17
** [instance C69 of CAPACITOR, params={'capacitance': 0.000146991 prefix:SIUnitPrefix.PICO} connections=['A: [connection C69/A =>[signal: _74_:D w=1]]', 'B: [connection C69/B =>[signal: input3:A w=1]]']]
C69 _74_:D input3:A  C=1.46991E-16
** [instance C70 of CAPACITOR, params={'capacitance': 1.70581e-05 prefix:SIUnitPrefix.PICO} connections=['A: [connection C70/A =>[signal: _74_:D w=1]]', 'B: [connection C70/B =>[signal: _77_:D w=1]]']]
C70 _74_:D _77_:D  C=1.7058099999999997E-17
** [instance C71 of CAPACITOR, params={'capacitance': 0.000600984 prefix:SIUnitPrefix.PICO} connections=['A: [connection C71/A =>[signal: _74_:D w=1]]', 'B: [connection C71/B =>[signal: VSS w=1]]']]
C71 _74_:D VSS  C=6.00984E-16
** [instance C72 of CAPACITOR, params={'capacitance': 1.39726e-05 prefix:SIUnitPrefix.PICO} connections=['A: [connection C72/A =>[signal: _74_:D w=1]]', 'B: [connection C72/B =>[signal: _77_:CLK w=1]]']]
C72 _74_:D _77_:CLK  C=1.39726E-17
** [instance C73 of CAPACITOR, params={'capacitance': 0.000431851 prefix:SIUnitPrefix.PICO} connections=['A: [connection C73/A =>[signal: _74_:D w=1]]', 'B: [connection C73/B =>[signal: net3:33 w=1]]']]
C73 _74_:D net3:33  C=4.31851E-16
** [instance C74 of CAPACITOR, params={'capacitance': 0.00130528 prefix:SIUnitPrefix.PICO} connections=['A: [connection C74/A =>[signal: _77_:CLK w=1]]', 'B: [connection C74/B =>[signal: input3:A w=1]]']]
C74 _77_:CLK input3:A  C=1.30528E-15
** [instance C75 of CAPACITOR, params={'capacitance': 5.71472e-05 prefix:SIUnitPrefix.PICO} connections=['A: [connection C75/A =>[signal: _77_:CLK w=1]]', 'B: [connection C75/B =>[signal: _77_:D w=1]]']]
C75 _77_:CLK _77_:D  C=5.71472E-17
** [instance C76 of CAPACITOR, params={'capacitance': 0.000221317 prefix:SIUnitPrefix.PICO} connections=['A: [connection C76/A =>[signal: _77_:CLK w=1]]', 'B: [connection C76/B =>[signal: net3:33 w=1]]']]
C76 _77_:CLK net3:33  C=2.2131700000000001E-16
** [instance C77 of CAPACITOR, params={'capacitance': 0.000149389 prefix:SIUnitPrefix.PICO} connections=['A: [connection C77/A =>[signal: _77_:CLK w=1]]', 'B: [connection C77/B =>[signal: net4:18 w=1]]']]
C77 _77_:CLK net4:18  C=1.4938899999999998E-16
** [instance C78 of CAPACITOR, params={'capacitance': 0.000438127 prefix:SIUnitPrefix.PICO} connections=['A: [connection C78/A =>[signal: _77_:CLK w=1]]', 'B: [connection C78/B =>[signal: VSS w=1]]']]
C78 _77_:CLK VSS  C=4.3812700000000003E-16
** [instance C79 of CAPACITOR, params={'capacitance': 0.0 prefix:SIUnitPrefix.PICO} connections=['A: [connection C79/A =>[signal: hold22:A w=1]]', 'B: [connection C79/B =>[signal: input3:A w=1]]']]
** C79 hold22:A input3:A  C=0.0 [skipped because C=0]
** [instance C80 of CAPACITOR, params={'capacitance': 0.000231621 prefix:SIUnitPrefix.PICO} connections=['A: [connection C80/A =>[signal: hold22:A w=1]]', 'B: [connection C80/B =>[signal: VSS w=1]]']]
C80 hold22:A VSS  C=2.3162099999999997E-16
** [instance C81 of CAPACITOR, params={'capacitance': 7.6644e-05 prefix:SIUnitPrefix.PICO} connections=['A: [connection C81/A =>[signal: hold22:A w=1]]', 'B: [connection C81/B =>[signal: net22:12 w=1]]']]
C81 hold22:A net22:12  C=7.664399999999999E-17
** [instance C82 of CAPACITOR, params={'capacitance': 0.000315894 prefix:SIUnitPrefix.PICO} connections=['A: [connection C82/A =>[signal: hold22:A w=1]]', 'B: [connection C82/B =>[signal: net3:12 w=1]]']]
C82 hold22:A net3:12  C=3.15894E-16
** [instance C83 of CAPACITOR, params={'capacitance': 0.00121992 prefix:SIUnitPrefix.PICO} connections=['A: [connection C83/A =>[signal: input4:A w=1]]', 'B: [connection C83/B =>[signal: VSS w=1]]']]
C83 input4:A VSS  C=1.21992E-15
** [instance C84 of CAPACITOR, params={'capacitance': 0.000253314 prefix:SIUnitPrefix.PICO} connections=['A: [connection C84/A =>[signal: input4:A w=1]]', 'B: [connection C84/B =>[signal: q w=1]]']]
C84 input4:A q  C=2.53314E-16
** [instance C85 of CAPACITOR, params={'capacitance': 0.0 prefix:SIUnitPrefix.PICO} connections=['A: [connection C85/A =>[signal: input4:A w=1]]', 'B: [connection C85/B =>[signal: scan_out w=1]]']]
** C85 input4:A scan_out  C=0.0 [skipped because C=0]
** [instance C86 of CAPACITOR, params={'capacitance': 0.000655416 prefix:SIUnitPrefix.PICO} connections=['A: [connection C86/A =>[signal: input4:A w=1]]', 'B: [connection C86/B =>[signal: input5:A w=1]]']]
C86 input4:A input5:A  C=6.55416E-16
** [instance C87 of CAPACITOR, params={'capacitance': 0.000241158 prefix:SIUnitPrefix.PICO} connections=['A: [connection C87/A =>[signal: input4:A w=1]]', 'B: [connection C87/B =>[signal: input7:A w=1]]']]
C87 input4:A input7:A  C=2.4115799999999997E-16
** [instance C88 of CAPACITOR, params={'capacitance': 0.0 prefix:SIUnitPrefix.PICO} connections=['A: [connection C88/A =>[signal: input4:A w=1]]', 'B: [connection C88/B =>[signal: input8:A w=1]]']]
** C88 input4:A input8:A  C=0.0 [skipped because C=0]
** [instance C89 of CAPACITOR, params={'capacitance': 0.000230475 prefix:SIUnitPrefix.PICO} connections=['A: [connection C89/A =>[signal: input4:A w=1]]', 'B: [connection C89/B =>[signal: net10:14 w=1]]']]
C89 input4:A net10:14  C=2.30475E-16
** [instance C90 of CAPACITOR, params={'capacitance': 0.0 prefix:SIUnitPrefix.PICO} connections=['A: [connection C90/A =>[signal: hold28:A w=1]]', 'B: [connection C90/B =>[signal: input4:A w=1]]']]
** C90 hold28:A input4:A  C=0.0 [skipped because C=0]
** [instance C91 of CAPACITOR, params={'capacitance': 7.92975e-05 prefix:SIUnitPrefix.PICO} connections=['A: [connection C91/A =>[signal: hold28:A w=1]]', 'B: [connection C91/B =>[signal: input7:A w=1]]']]
C91 hold28:A input7:A  C=7.929750000000001E-17
** [instance C92 of CAPACITOR, params={'capacitance': 0.000166276 prefix:SIUnitPrefix.PICO} connections=['A: [connection C92/A =>[signal: hold28:A w=1]]', 'B: [connection C92/B =>[signal: net10:14 w=1]]']]
C92 hold28:A net10:14  C=1.66276E-16
** [instance C93 of CAPACITOR, params={'capacitance': 6.10003e-05 prefix:SIUnitPrefix.PICO} connections=['A: [connection C93/A =>[signal: hold28:A w=1]]', 'B: [connection C93/B =>[signal: VSS w=1]]']]
C93 hold28:A VSS  C=6.10003E-17
** [instance C94 of CAPACITOR, params={'capacitance': 0.000891769 prefix:SIUnitPrefix.PICO} connections=['A: [connection C94/A =>[signal: input5:A w=1]]', 'B: [connection C94/B =>[signal: VSS w=1]]']]
C94 input5:A VSS  C=8.91769E-16
** [instance C95 of CAPACITOR, params={'capacitance': 8.62161e-05 prefix:SIUnitPrefix.PICO} connections=['A: [connection C95/A =>[signal: input5:A w=1]]', 'B: [connection C95/B =>[signal: mux w=1]]']]
C95 input5:A mux  C=8.62161E-17
** [instance C96 of CAPACITOR, params={'capacitance': 7.78217e-05 prefix:SIUnitPrefix.PICO} connections=['A: [connection C96/A =>[signal: input5:A w=1]]', 'B: [connection C96/B =>[signal: q w=1]]']]
C96 input5:A q  C=7.782169999999999E-17
** [instance C97 of CAPACITOR, params={'capacitance': 0.000227532 prefix:SIUnitPrefix.PICO} connections=['A: [connection C97/A =>[signal: input5:A w=1]]', 'B: [connection C97/B =>[signal: scan_out w=1]]']]
C97 input5:A scan_out  C=2.27532E-16
** [instance C98 of CAPACITOR, params={'capacitance': 0.0 prefix:SIUnitPrefix.PICO} connections=['A: [connection C98/A =>[signal: input5:A w=1]]', 'B: [connection C98/B =>[signal: input7:A w=1]]']]
** C98 input5:A input7:A  C=0.0 [skipped because C=0]
** [instance C99 of CAPACITOR, params={'capacitance': 0.000100313 prefix:SIUnitPrefix.PICO} connections=['A: [connection C99/A =>[signal: input5:A w=1]]', 'B: [connection C99/B =>[signal: input8:A w=1]]']]
C99 input5:A input8:A  C=1.00313E-16
** [instance C100 of CAPACITOR, params={'capacitance': 0.000271339 prefix:SIUnitPrefix.PICO} connections=['A: [connection C100/A =>[signal: input5:A w=1]]', 'B: [connection C100/B =>[signal: output11:A w=1]]']]
C100 input5:A output11:A  C=2.7133899999999997E-16
** [instance C101 of CAPACITOR, params={'capacitance': 0.000412011 prefix:SIUnitPrefix.PICO} connections=['A: [connection C101/A =>[signal: output9:X w=1]]', 'B: [connection C101/B =>[signal: VSS w=1]]']]
C101 output9:X VSS  C=4.12011E-16
** [instance C102 of CAPACITOR, params={'capacitance': 0.000122795 prefix:SIUnitPrefix.PICO} connections=['A: [connection C102/A =>[signal: mux w=1]]', 'B: [connection C102/B =>[signal: scan_out w=1]]']]
C102 mux scan_out  C=1.22795E-16
** [instance C103 of CAPACITOR, params={'capacitance': 0.00040499 prefix:SIUnitPrefix.PICO} connections=['A: [connection C103/A =>[signal: input7:A w=1]]', 'B: [connection C103/B =>[signal: mux w=1]]']]
C103 input7:A mux  C=4.0499E-16
** [instance C104 of CAPACITOR, params={'capacitance': 0.00153788 prefix:SIUnitPrefix.PICO} connections=['A: [connection C104/A =>[signal: input7:A w=1]]', 'B: [connection C104/B =>[signal: VSS w=1]]']]
C104 input7:A VSS  C=1.5378799999999999E-15
** [instance C105 of CAPACITOR, params={'capacitance': 0.000146903 prefix:SIUnitPrefix.PICO} connections=['A: [connection C105/A =>[signal: input7:A w=1]]', 'B: [connection C105/B =>[signal: net10:14 w=1]]']]
C105 input7:A net10:14  C=1.46903E-16
** [instance C106 of CAPACITOR, params={'capacitance': 0.000249333 prefix:SIUnitPrefix.PICO} connections=['A: [connection C106/A =>[signal: input7:A w=1]]', 'B: [connection C106/B =>[signal: net11:21 w=1]]']]
C106 input7:A net11:21  C=2.49333E-16
** [instance C107 of CAPACITOR, params={'capacitance': 9.63964e-05 prefix:SIUnitPrefix.PICO} connections=['A: [connection C107/A =>[signal: input8:A w=1]]', 'B: [connection C107/B =>[signal: mux w=1]]']]
C107 input8:A mux  C=9.63964E-17
** [instance C108 of CAPACITOR, params={'capacitance': 0.000758931 prefix:SIUnitPrefix.PICO} connections=['A: [connection C108/A =>[signal: input8:A w=1]]', 'B: [connection C108/B =>[signal: q w=1]]']]
C108 input8:A q  C=7.58931E-16
** [instance C109 of CAPACITOR, params={'capacitance': 0.000566594 prefix:SIUnitPrefix.PICO} connections=['A: [connection C109/A =>[signal: input8:A w=1]]', 'B: [connection C109/B =>[signal: scan_out w=1]]']]
C109 input8:A scan_out  C=5.66594E-16
** [instance C110 of CAPACITOR, params={'capacitance': 0.000540073 prefix:SIUnitPrefix.PICO} connections=['A: [connection C110/A =>[signal: input8:A w=1]]', 'B: [connection C110/B =>[signal: VSS w=1]]']]
C110 input8:A VSS  C=5.40073E-16
** [instance C111 of CAPACITOR, params={'capacitance': 7.24957e-05 prefix:SIUnitPrefix.PICO} connections=['A: [connection C111/A =>[signal: net10:14 w=1]]', 'B: [connection C111/B =>[signal: mux w=1]]']]
C111 net10:14 mux  C=7.249569999999999E-17
** [instance C112 of CAPACITOR, params={'capacitance': 0.00104205 prefix:SIUnitPrefix.PICO} connections=['A: [connection C112/A =>[signal: net10:14 w=1]]', 'B: [connection C112/B =>[signal: VSS w=1]]']]
C112 net10:14 VSS  C=1.04205E-15
** [instance C113 of CAPACITOR, params={'capacitance': 0.000149481 prefix:SIUnitPrefix.PICO} connections=['A: [connection C113/A =>[signal: net10:14 w=1]]', 'B: [connection C113/B =>[signal: net11:10 w=1]]']]
C113 net10:14 net11:10  C=1.49481E-16
** [instance C114 of CAPACITOR, params={'capacitance': 0.000578047 prefix:SIUnitPrefix.PICO} connections=['A: [connection C114/A =>[signal: net10:14 w=1]]', 'B: [connection C114/B =>[signal: net11:21 w=1]]']]
C114 net10:14 net11:21  C=5.78047E-16
** [instance C115 of CAPACITOR, params={'capacitance': 0.0 prefix:SIUnitPrefix.PICO} connections=['A: [connection C115/A =>[signal: net10:14 w=1]]', 'B: [connection C115/B =>[signal: net8:12 w=1]]']]
** C115 net10:14 net8:12  C=0.0 [skipped because C=0]
** [instance C116 of CAPACITOR, params={'capacitance': 0.000149481 prefix:SIUnitPrefix.PICO} connections=['A: [connection C116/A =>[signal: net11:10 w=1]]', 'B: [connection C116/B =>[signal: mux w=1]]']]
C116 net11:10 mux  C=1.49481E-16
** [instance C117 of CAPACITOR, params={'capacitance': 0.000368972 prefix:SIUnitPrefix.PICO} connections=['A: [connection C117/A =>[signal: net11:10 w=1]]', 'B: [connection C117/B =>[signal: VSS w=1]]']]
C117 net11:10 VSS  C=3.68972E-16
** [instance C118 of CAPACITOR, params={'capacitance': 0.000128161 prefix:SIUnitPrefix.PICO} connections=['A: [connection C118/A =>[signal: net11:21 w=1]]', 'B: [connection C118/B =>[signal: mux w=1]]']]
C118 net11:21 mux  C=1.2816100000000001E-16
** [instance C119 of CAPACITOR, params={'capacitance': 0.000327897 prefix:SIUnitPrefix.PICO} connections=['A: [connection C119/A =>[signal: net11:21 w=1]]', 'B: [connection C119/B =>[signal: VSS w=1]]']]
C119 net11:21 VSS  C=3.27897E-16
** [instance C120 of CAPACITOR, params={'capacitance': 0.00105989 prefix:SIUnitPrefix.PICO} connections=['A: [connection C120/A =>[signal: output10:X w=1]]', 'B: [connection C120/B =>[signal: VSS w=1]]']]
C120 output10:X VSS  C=1.05989E-15
** [instance C121 of CAPACITOR, params={'capacitance': 9.54627e-05 prefix:SIUnitPrefix.PICO} connections=['A: [connection C121/A =>[signal: q w=1]]', 'B: [connection C121/B =>[signal: scan_out w=1]]']]
C121 q scan_out  C=9.54627E-17
** [instance C122 of CAPACITOR, params={'capacitance': 0.000108719 prefix:SIUnitPrefix.PICO} connections=['A: [connection C122/A =>[signal: clkbuf_0_scan_clk:A w=1]]', 'B: [connection C122/B =>[signal: VSS w=1]]']]
C122 clkbuf_0_scan_clk:A VSS  C=1.08719E-16
** [instance C123 of CAPACITOR, params={'capacitance': 5.09021e-06 prefix:SIUnitPrefix.PICO} connections=['A: [connection C123/A =>[signal: _66_:CLK w=1]]', 'B: [connection C123/B =>[signal: clkbuf_0_scan_clk:A w=1]]']]
C123 _66_:CLK clkbuf_0_scan_clk:A  C=5.09021E-18
** [instance C124 of CAPACITOR, params={'capacitance': 8.81327e-05 prefix:SIUnitPrefix.PICO} connections=['A: [connection C124/A =>[signal: _66_:CLK w=1]]', 'B: [connection C124/B =>[signal: clknet_0_scan_clk:33 w=1]]']]
C124 _66_:CLK clknet_0_scan_clk:33  C=8.81327E-17
** [instance C125 of CAPACITOR, params={'capacitance': 0.000330357 prefix:SIUnitPrefix.PICO} connections=['A: [connection C125/A =>[signal: _66_:CLK w=1]]', 'B: [connection C125/B =>[signal: VSS w=1]]']]
C125 _66_:CLK VSS  C=3.3035699999999996E-16
** [instance C126 of CAPACITOR, params={'capacitance': 6.05161e-06 prefix:SIUnitPrefix.PICO} connections=['A: [connection C126/A =>[signal: _66_:D w=1]]', 'B: [connection C126/B =>[signal: clkbuf_0_scan_clk:A w=1]]']]
C126 _66_:D clkbuf_0_scan_clk:A  C=6.051609999999999E-18
** [instance C127 of CAPACITOR, params={'capacitance': 0.000495255 prefix:SIUnitPrefix.PICO} connections=['A: [connection C127/A =>[signal: _66_:D w=1]]', 'B: [connection C127/B =>[signal: VSS w=1]]']]
C127 _66_:D VSS  C=4.95255E-16
** [instance C128 of CAPACITOR, params={'capacitance': 0.0 prefix:SIUnitPrefix.PICO} connections=['A: [connection C128/A =>[signal: _66_:D w=1]]', 'B: [connection C128/B =>[signal: _23_:24 w=1]]']]
** C128 _66_:D _23_:24  C=0.0 [skipped because C=0]
** [instance C129 of CAPACITOR, params={'capacitance': 1.00399e-05 prefix:SIUnitPrefix.PICO} connections=['A: [connection C129/A =>[signal: _66_:D w=1]]', 'B: [connection C129/B =>[signal: clknet_0_scan_clk:33 w=1]]']]
C129 _66_:D clknet_0_scan_clk:33  C=1.00399E-17
** [instance C130 of CAPACITOR, params={'capacitance': 0.0 prefix:SIUnitPrefix.PICO} connections=['A: [connection C130/A =>[signal: _66_:D w=1]]', 'B: [connection C130/B =>[signal: mem[5]:10 w=1]]']]
** C130 _66_:D mem[5]:10  C=0.0 [skipped because C=0]
** [instance C131 of CAPACITOR, params={'capacitance': 4.26014e-05 prefix:SIUnitPrefix.PICO} connections=['A: [connection C131/A =>[signal: _66_:D w=1]]', 'B: [connection C131/B =>[signal: mem[8]:10 w=1]]']]
C131 _66_:D mem[8]:10  C=4.26014E-17
** [instance C132 of CAPACITOR, params={'capacitance': 0.00010096 prefix:SIUnitPrefix.PICO} connections=['A: [connection C132/A =>[signal: _66_:D w=1]]', 'B: [connection C132/B =>[signal: net12:46 w=1]]']]
C132 _66_:D net12:46  C=1.0095999999999999E-16
** [instance C133 of CAPACITOR, params={'capacitance': 0.0 prefix:SIUnitPrefix.PICO} connections=['A: [connection C133/A =>[signal: _66_:D w=1]]', 'B: [connection C133/B =>[signal: net18:10 w=1]]']]
** C133 _66_:D net18:10  C=0.0 [skipped because C=0]
** [instance C134 of CAPACITOR, params={'capacitance': 0.000467448 prefix:SIUnitPrefix.PICO} connections=['A: [connection C134/A =>[signal: input6:A w=1]]', 'B: [connection C134/B =>[signal: VSS w=1]]']]
C134 input6:A VSS  C=4.67448E-16
** [instance C135 of CAPACITOR, params={'capacitance': 0.0 prefix:SIUnitPrefix.PICO} connections=['A: [connection C135/A =>[signal: input6:A w=1]]', 'B: [connection C135/B =>[signal: net19:12 w=1]]']]
** C135 input6:A net19:12  C=0.0 [skipped because C=0]
** [instance C136 of CAPACITOR, params={'capacitance': 0.000138859 prefix:SIUnitPrefix.PICO} connections=['A: [connection C136/A =>[signal: _64_:D w=1]]', 'B: [connection C136/B =>[signal: input6:A w=1]]']]
C136 _64_:D input6:A  C=1.3885899999999999E-16
** [instance C137 of CAPACITOR, params={'capacitance': 0.00018853 prefix:SIUnitPrefix.PICO} connections=['A: [connection C137/A =>[signal: _64_:D w=1]]', 'B: [connection C137/B =>[signal: VSS w=1]]']]
C137 _64_:D VSS  C=1.8853E-16
** [instance C138 of CAPACITOR, params={'capacitance': 0.000487014 prefix:SIUnitPrefix.PICO} connections=['A: [connection C138/A =>[signal: _64_:D w=1]]', 'B: [connection C138/B =>[signal: net19:12 w=1]]']]
C138 _64_:D net19:12  C=4.87014E-16
** [instance C139 of CAPACITOR, params={'capacitance': 5.52302e-05 prefix:SIUnitPrefix.PICO} connections=['A: [connection C139/A =>[signal: _58_:A0 w=1]]', 'B: [connection C139/B =>[signal: input7:A w=1]]']]
C139 _58_:A0 input7:A  C=5.5230199999999994E-17
** [instance C140 of CAPACITOR, params={'capacitance': 0.0 prefix:SIUnitPrefix.PICO} connections=['A: [connection C140/A =>[signal: _58_:A0 w=1]]', 'B: [connection C140/B =>[signal: net10:14 w=1]]']]
** C140 _58_:A0 net10:14  C=0.0 [skipped because C=0]
** [instance C141 of CAPACITOR, params={'capacitance': 5.33334e-05 prefix:SIUnitPrefix.PICO} connections=['A: [connection C141/A =>[signal: _58_:A0 w=1]]', 'B: [connection C141/B =>[signal: _58_:S w=1]]']]
C141 _58_:A0 _58_:S  C=5.33334E-17
** [instance C142 of CAPACITOR, params={'capacitance': 0.000377006 prefix:SIUnitPrefix.PICO} connections=['A: [connection C142/A =>[signal: _58_:A0 w=1]]', 'B: [connection C142/B =>[signal: VSS w=1]]']]
C142 _58_:A0 VSS  C=3.7700599999999997E-16
** [instance C143 of CAPACITOR, params={'capacitance': 0.000489443 prefix:SIUnitPrefix.PICO} connections=['A: [connection C143/A =>[signal: _58_:A0 w=1]]', 'B: [connection C143/B =>[signal: net3:12 w=1]]']]
C143 _58_:A0 net3:12  C=4.89443E-16
** [instance C144 of CAPACITOR, params={'capacitance': 5.33978e-05 prefix:SIUnitPrefix.PICO} connections=['A: [connection C144/A =>[signal: _58_:A0 w=1]]', 'B: [connection C144/B =>[signal: net8:12 w=1]]']]
C144 _58_:A0 net8:12  C=5.33978E-17
** [instance C145 of CAPACITOR, params={'capacitance': 0.0 prefix:SIUnitPrefix.PICO} connections=['A: [connection C145/A =>[signal: q_control:23 w=1]]', 'B: [connection C145/B =>[signal: input7:A w=1]]']]
** C145 q_control:23 input7:A  C=0.0 [skipped because C=0]
** [instance C146 of CAPACITOR, params={'capacitance': 0.0 prefix:SIUnitPrefix.PICO} connections=['A: [connection C146/A =>[signal: q_control:23 w=1]]', 'B: [connection C146/B =>[signal: _50_:A1 w=1]]']]
** C146 q_control:23 _50_:A1  C=0.0 [skipped because C=0]
** [instance C147 of CAPACITOR, params={'capacitance': 0.000671946 prefix:SIUnitPrefix.PICO} connections=['A: [connection C147/A =>[signal: q_control:23 w=1]]', 'B: [connection C147/B =>[signal: VSS w=1]]']]
C147 q_control:23 VSS  C=6.719459999999999E-16
** [instance C148 of CAPACITOR, params={'capacitance': 0.00063607 prefix:SIUnitPrefix.PICO} connections=['A: [connection C148/A =>[signal: output11:X w=1]]', 'B: [connection C148/B =>[signal: VSS w=1]]']]
C148 output11:X VSS  C=6.3607E-16
** [instance C149 of CAPACITOR, params={'capacitance': 0.000109857 prefix:SIUnitPrefix.PICO} connections=['A: [connection C149/A =>[signal: _77_:D w=1]]', 'B: [connection C149/B =>[signal: VSS w=1]]']]
C149 _77_:D VSS  C=1.09857E-16
** [instance C150 of CAPACITOR, params={'capacitance': 1.21289e-05 prefix:SIUnitPrefix.PICO} connections=['A: [connection C150/A =>[signal: _77_:D w=1]]', 'B: [connection C150/B =>[signal: net3:33 w=1]]']]
C150 _77_:D net3:33  C=1.21289E-17
** [instance C151 of CAPACITOR, params={'capacitance': 0.000109857 prefix:SIUnitPrefix.PICO} connections=['A: [connection C151/A =>[signal: _39_:X w=1]]', 'B: [connection C151/B =>[signal: VSS w=1]]']]
C151 _39_:X VSS  C=1.09857E-16
** [instance C152 of CAPACITOR, params={'capacitance': 1.33343e-05 prefix:SIUnitPrefix.PICO} connections=['A: [connection C152/A =>[signal: _39_:A1 w=1]]', 'B: [connection C152/B =>[signal: _77_:D w=1]]']]
C152 _39_:A1 _77_:D  C=1.33343E-17
** [instance C153 of CAPACITOR, params={'capacitance': 0.00012415 prefix:SIUnitPrefix.PICO} connections=['A: [connection C153/A =>[signal: _39_:A1 w=1]]', 'B: [connection C153/B =>[signal: _76_:D w=1]]']]
C153 _39_:A1 _76_:D  C=1.2415E-16
** [instance C154 of CAPACITOR, params={'capacitance': 0.000477576 prefix:SIUnitPrefix.PICO} connections=['A: [connection C154/A =>[signal: _39_:A1 w=1]]', 'B: [connection C154/B =>[signal: _40_:A0 w=1]]']]
C154 _39_:A1 _40_:A0  C=4.77576E-16
** [instance C155 of CAPACITOR, params={'capacitance': 0.000235347 prefix:SIUnitPrefix.PICO} connections=['A: [connection C155/A =>[signal: _39_:A1 w=1]]', 'B: [connection C155/B =>[signal: net3:33 w=1]]']]
C155 _39_:A1 net3:33  C=2.35347E-16
** [instance C156 of CAPACITOR, params={'capacitance': 0.000180764 prefix:SIUnitPrefix.PICO} connections=['A: [connection C156/A =>[signal: _39_:A1 w=1]]', 'B: [connection C156/B =>[signal: _56_:A0 w=1]]']]
C156 _39_:A1 _56_:A0  C=1.80764E-16
** [instance C157 of CAPACITOR, params={'capacitance': 0.000232456 prefix:SIUnitPrefix.PICO} connections=['A: [connection C157/A =>[signal: _39_:A1 w=1]]', 'B: [connection C157/B =>[signal: net37:14 w=1]]']]
C157 _39_:A1 net37:14  C=2.32456E-16
** [instance C158 of CAPACITOR, params={'capacitance': 0.000148651 prefix:SIUnitPrefix.PICO} connections=['A: [connection C158/A =>[signal: _39_:A1 w=1]]', 'B: [connection C158/B =>[signal: net4:18 w=1]]']]
C158 _39_:A1 net4:18  C=1.48651E-16
** [instance C159 of CAPACITOR, params={'capacitance': 0.000205086 prefix:SIUnitPrefix.PICO} connections=['A: [connection C159/A =>[signal: _39_:A1 w=1]]', 'B: [connection C159/B =>[signal: _77_:CLK w=1]]']]
C159 _39_:A1 _77_:CLK  C=2.05086E-16
** [instance C160 of CAPACITOR, params={'capacitance': 0.000503755 prefix:SIUnitPrefix.PICO} connections=['A: [connection C160/A =>[signal: _39_:A1 w=1]]', 'B: [connection C160/B =>[signal: VSS w=1]]']]
C160 _39_:A1 VSS  C=5.03755E-16
** [instance C161 of CAPACITOR, params={'capacitance': 0.000303449 prefix:SIUnitPrefix.PICO} connections=['A: [connection C161/A =>[signal: _39_:A1 w=1]]', 'B: [connection C161/B =>[signal: _39_:S w=1]]']]
C161 _39_:A1 _39_:S  C=3.03449E-16
** [instance C162 of CAPACITOR, params={'capacitance': 7.08071e-05 prefix:SIUnitPrefix.PICO} connections=['A: [connection C162/A =>[signal: _59_:D w=1]]', 'B: [connection C162/B =>[signal: VSS w=1]]']]
C162 _59_:D VSS  C=7.080709999999999E-17
** [instance C163 of CAPACITOR, params={'capacitance': 8.03949e-05 prefix:SIUnitPrefix.PICO} connections=['A: [connection C163/A =>[signal: _59_:D w=1]]', 'B: [connection C163/B =>[signal: clknet_1_1__leaf_scan_clk:75 w=1]]']]
C163 _59_:D clknet_1_1__leaf_scan_clk:75  C=8.039489999999999E-17
** [instance C164 of CAPACITOR, params={'capacitance': 0.000176663 prefix:SIUnitPrefix.PICO} connections=['A: [connection C164/A =>[signal: _59_:D w=1]]', 'B: [connection C164/B =>[signal: net35:10 w=1]]']]
C164 _59_:D net35:10  C=1.76663E-16
** [instance C165 of CAPACITOR, params={'capacitance': 7.08071e-05 prefix:SIUnitPrefix.PICO} connections=['A: [connection C165/A =>[signal: _41_:X w=1]]', 'B: [connection C165/B =>[signal: VSS w=1]]']]
C165 _41_:X VSS  C=7.080709999999999E-17
** [instance C166 of CAPACITOR, params={'capacitance': 8.20939e-05 prefix:SIUnitPrefix.PICO} connections=['A: [connection C166/A =>[signal: _33_:A3 w=1]]', 'B: [connection C166/B =>[signal: _59_:D w=1]]']]
C166 _33_:A3 _59_:D  C=8.20939E-17
** [instance C167 of CAPACITOR, params={'capacitance': 0.000191423 prefix:SIUnitPrefix.PICO} connections=['A: [connection C167/A =>[signal: _33_:A3 w=1]]', 'B: [connection C167/B =>[signal: _40_:A0 w=1]]']]
C167 _33_:A3 _40_:A0  C=1.91423E-16
** [instance C168 of CAPACITOR, params={'capacitance': 3.71434e-05 prefix:SIUnitPrefix.PICO} connections=['A: [connection C168/A =>[signal: _33_:A3 w=1]]', 'B: [connection C168/B =>[signal: clknet_1_1__leaf_scan_clk:75 w=1]]']]
C168 _33_:A3 clknet_1_1__leaf_scan_clk:75  C=3.71434E-17
** [instance C169 of CAPACITOR, params={'capacitance': 0.000149463 prefix:SIUnitPrefix.PICO} connections=['A: [connection C169/A =>[signal: _33_:A3 w=1]]', 'B: [connection C169/B =>[signal: clknet_1_1__leaf_scan_clk:79 w=1]]']]
C169 _33_:A3 clknet_1_1__leaf_scan_clk:79  C=1.49463E-16
** [instance C170 of CAPACITOR, params={'capacitance': 0.000731256 prefix:SIUnitPrefix.PICO} connections=['A: [connection C170/A =>[signal: _33_:A3 w=1]]', 'B: [connection C170/B =>[signal: VSS w=1]]']]
C170 _33_:A3 VSS  C=7.31256E-16
** [instance C171 of CAPACITOR, params={'capacitance': 0.000264532 prefix:SIUnitPrefix.PICO} connections=['A: [connection C171/A =>[signal: _33_:A3 w=1]]', 'B: [connection C171/B =>[signal: _39_:A1 w=1]]']]
C171 _33_:A3 _39_:A1  C=2.6453199999999997E-16
** [instance C172 of CAPACITOR, params={'capacitance': 0.00017514 prefix:SIUnitPrefix.PICO} connections=['A: [connection C172/A =>[signal: _56_:A1 w=1]]', 'B: [connection C172/B =>[signal: _59_:D w=1]]']]
C172 _56_:A1 _59_:D  C=1.7514E-16
** [instance C173 of CAPACITOR, params={'capacitance': 0.000457434 prefix:SIUnitPrefix.PICO} connections=['A: [connection C173/A =>[signal: _56_:A1 w=1]]', 'B: [connection C173/B =>[signal: _28_:8 w=1]]']]
C173 _56_:A1 _28_:8  C=4.57434E-16
** [instance C174 of CAPACITOR, params={'capacitance': 0.000137983 prefix:SIUnitPrefix.PICO} connections=['A: [connection C174/A =>[signal: _56_:A1 w=1]]', 'B: [connection C174/B =>[signal: _56_:S w=1]]']]
C174 _56_:A1 _56_:S  C=1.37983E-16
** [instance C175 of CAPACITOR, params={'capacitance': 0.0 prefix:SIUnitPrefix.PICO} connections=['A: [connection C175/A =>[signal: _56_:A1 w=1]]', 'B: [connection C175/B =>[signal: net13:31 w=1]]']]
** C175 _56_:A1 net13:31  C=0.0 [skipped because C=0]
** [instance C176 of CAPACITOR, params={'capacitance': 0.0 prefix:SIUnitPrefix.PICO} connections=['A: [connection C176/A =>[signal: _56_:A1 w=1]]', 'B: [connection C176/B =>[signal: net16:10 w=1]]']]
** C176 _56_:A1 net16:10  C=0.0 [skipped because C=0]
** [instance C177 of CAPACITOR, params={'capacitance': 0.000310292 prefix:SIUnitPrefix.PICO} connections=['A: [connection C177/A =>[signal: _56_:A1 w=1]]', 'B: [connection C177/B =>[signal: net3:33 w=1]]']]
C177 _56_:A1 net3:33  C=3.10292E-16
** [instance C178 of CAPACITOR, params={'capacitance': 0.000533592 prefix:SIUnitPrefix.PICO} connections=['A: [connection C178/A =>[signal: _56_:A1 w=1]]', 'B: [connection C178/B =>[signal: net35:10 w=1]]']]
C178 _56_:A1 net35:10  C=5.33592E-16
** [instance C179 of CAPACITOR, params={'capacitance': 0.0 prefix:SIUnitPrefix.PICO} connections=['A: [connection C179/A =>[signal: _56_:A1 w=1]]', 'B: [connection C179/B =>[signal: net37:14 w=1]]']]
** C179 _56_:A1 net37:14  C=0.0 [skipped because C=0]
** [instance C180 of CAPACITOR, params={'capacitance': 0.00063921 prefix:SIUnitPrefix.PICO} connections=['A: [connection C180/A =>[signal: _56_:A1 w=1]]', 'B: [connection C180/B =>[signal: VSS w=1]]']]
C180 _56_:A1 VSS  C=6.3921E-16
** [instance C181 of CAPACITOR, params={'capacitance': 0.000421191 prefix:SIUnitPrefix.PICO} connections=['A: [connection C181/A =>[signal: hold17:A w=1]]', 'B: [connection C181/B =>[signal: VSS w=1]]']]
C181 hold17:A VSS  C=4.21191E-16
** [instance C182 of CAPACITOR, params={'capacitance': 0.000269097 prefix:SIUnitPrefix.PICO} connections=['A: [connection C182/A =>[signal: hold17:A w=1]]', 'B: [connection C182/B =>[signal: _23_:24 w=1]]']]
C182 hold17:A _23_:24  C=2.6909699999999997E-16
** [instance C183 of CAPACITOR, params={'capacitance': 0.000212448 prefix:SIUnitPrefix.PICO} connections=['A: [connection C183/A =>[signal: hold17:A w=1]]', 'B: [connection C183/B =>[signal: clknet_1_1__leaf_scan_clk:81 w=1]]']]
C183 hold17:A clknet_1_1__leaf_scan_clk:81  C=2.12448E-16
** [instance C184 of CAPACITOR, params={'capacitance': 0.000421191 prefix:SIUnitPrefix.PICO} connections=['A: [connection C184/A =>[signal: _42_:X w=1]]', 'B: [connection C184/B =>[signal: VSS w=1]]']]
C184 _42_:X VSS  C=4.21191E-16
** [instance C185 of CAPACITOR, params={'capacitance': 9.57311e-05 prefix:SIUnitPrefix.PICO} connections=['A: [connection C185/A =>[signal: _32_:B w=1]]', 'B: [connection C185/B =>[signal: hold17:A w=1]]']]
C185 _32_:B hold17:A  C=9.57311E-17
** [instance C186 of CAPACITOR, params={'capacitance': 0.000587672 prefix:SIUnitPrefix.PICO} connections=['A: [connection C186/A =>[signal: _32_:B w=1]]', 'B: [connection C186/B =>[signal: VSS w=1]]']]
C186 _32_:B VSS  C=5.87672E-16
** [instance C187 of CAPACITOR, params={'capacitance': 0.000230155 prefix:SIUnitPrefix.PICO} connections=['A: [connection C187/A =>[signal: _32_:B w=1]]', 'B: [connection C187/B =>[signal: _37_:A0 w=1]]']]
C187 _32_:B _37_:A0  C=2.30155E-16
** [instance C188 of CAPACITOR, params={'capacitance': 0.000264703 prefix:SIUnitPrefix.PICO} connections=['A: [connection C188/A =>[signal: _32_:B w=1]]', 'B: [connection C188/B =>[signal: _66_:CLK w=1]]']]
C188 _32_:B _66_:CLK  C=2.64703E-16
** [instance C189 of CAPACITOR, params={'capacitance': 0.000559987 prefix:SIUnitPrefix.PICO} connections=['A: [connection C189/A =>[signal: _32_:B w=1]]', 'B: [connection C189/B =>[signal: _23_:24 w=1]]']]
C189 _32_:B _23_:24  C=5.599869999999999E-16
** [instance C190 of CAPACITOR, params={'capacitance': 0.00012384 prefix:SIUnitPrefix.PICO} connections=['A: [connection C190/A =>[signal: _32_:B w=1]]', 'B: [connection C190/B =>[signal: _24_:36 w=1]]']]
C190 _32_:B _24_:36  C=1.2384E-16
** [instance C191 of CAPACITOR, params={'capacitance': 0.00012249 prefix:SIUnitPrefix.PICO} connections=['A: [connection C191/A =>[signal: _32_:B w=1]]', 'B: [connection C191/B =>[signal: clknet_1_1__leaf_scan_clk:81 w=1]]']]
C191 _32_:B clknet_1_1__leaf_scan_clk:81  C=1.2249E-16
** [instance C192 of CAPACITOR, params={'capacitance': 0.00030121 prefix:SIUnitPrefix.PICO} connections=['A: [connection C192/A =>[signal: _32_:B w=1]]', 'B: [connection C192/B =>[signal: net3:33 w=1]]']]
C192 _32_:B net3:33  C=3.0120999999999997E-16
** [instance C193 of CAPACITOR, params={'capacitance': 0.000226867 prefix:SIUnitPrefix.PICO} connections=['A: [connection C193/A =>[signal: _33_:S0 w=1]]', 'B: [connection C193/B =>[signal: hold17:A w=1]]']]
C193 _33_:S0 hold17:A  C=2.26867E-16
** [instance C194 of CAPACITOR, params={'capacitance': 6.92801e-05 prefix:SIUnitPrefix.PICO} connections=['A: [connection C194/A =>[signal: _33_:S0 w=1]]', 'B: [connection C194/B =>[signal: _23_:24 w=1]]']]
C194 _33_:S0 _23_:24  C=6.92801E-17
** [instance C195 of CAPACITOR, params={'capacitance': 0.000132612 prefix:SIUnitPrefix.PICO} connections=['A: [connection C195/A =>[signal: _33_:S0 w=1]]', 'B: [connection C195/B =>[signal: clknet_1_1__leaf_scan_clk:79 w=1]]']]
C195 _33_:S0 clknet_1_1__leaf_scan_clk:79  C=1.3261199999999998E-16
** [instance C196 of CAPACITOR, params={'capacitance': 0.000324844 prefix:SIUnitPrefix.PICO} connections=['A: [connection C196/A =>[signal: _33_:S0 w=1]]', 'B: [connection C196/B =>[signal: VSS w=1]]']]
C196 _33_:S0 VSS  C=3.2484400000000004E-16
** [instance C197 of CAPACITOR, params={'capacitance': 0.00021984 prefix:SIUnitPrefix.PICO} connections=['A: [connection C197/A =>[signal: _33_:S0 w=1]]', 'B: [connection C197/B =>[signal: _44_:A1 w=1]]']]
C197 _33_:S0 _44_:A1  C=2.1984000000000001E-16
** [instance C198 of CAPACITOR, params={'capacitance': 4.4873e-05 prefix:SIUnitPrefix.PICO} connections=['A: [connection C198/A =>[signal: _43_:A1 w=1]]', 'B: [connection C198/B =>[signal: hold17:A w=1]]']]
C198 _43_:A1 hold17:A  C=4.4873E-17
** [instance C199 of CAPACITOR, params={'capacitance': 9.16877e-05 prefix:SIUnitPrefix.PICO} connections=['A: [connection C199/A =>[signal: _43_:A1 w=1]]', 'B: [connection C199/B =>[signal: clknet_1_1__leaf_scan_clk:79 w=1]]']]
C199 _43_:A1 clknet_1_1__leaf_scan_clk:79  C=9.16877E-17
** [instance C200 of CAPACITOR, params={'capacitance': 0.000262608 prefix:SIUnitPrefix.PICO} connections=['A: [connection C200/A =>[signal: _43_:A1 w=1]]', 'B: [connection C200/B =>[signal: VSS w=1]]']]
C200 _43_:A1 VSS  C=2.62608E-16
** [instance C201 of CAPACITOR, params={'capacitance': 9.75173e-05 prefix:SIUnitPrefix.PICO} connections=['A: [connection C201/A =>[signal: _43_:A1 w=1]]', 'B: [connection C201/B =>[signal: _43_:S w=1]]']]
C201 _43_:A1 _43_:S  C=9.75173E-17
** [instance C202 of CAPACITOR, params={'capacitance': 0.000121842 prefix:SIUnitPrefix.PICO} connections=['A: [connection C202/A =>[signal: _43_:A1 w=1]]', 'B: [connection C202/B =>[signal: _44_:A0 w=1]]']]
C202 _43_:A1 _44_:A0  C=1.21842E-16
** [instance C203 of CAPACITOR, params={'capacitance': 1.24368e-05 prefix:SIUnitPrefix.PICO} connections=['A: [connection C203/A =>[signal: _43_:A1 w=1]]', 'B: [connection C203/B =>[signal: _60_:D w=1]]']]
C203 _43_:A1 _60_:D  C=1.2436799999999998E-17
** [instance C204 of CAPACITOR, params={'capacitance': 9.75173e-05 prefix:SIUnitPrefix.PICO} connections=['A: [connection C204/A =>[signal: _43_:S w=1]]', 'B: [connection C204/B =>[signal: hold17:A w=1]]']]
C204 _43_:S hold17:A  C=9.75173E-17
** [instance C205 of CAPACITOR, params={'capacitance': 0.000117227 prefix:SIUnitPrefix.PICO} connections=['A: [connection C205/A =>[signal: _43_:S w=1]]', 'B: [connection C205/B =>[signal: VSS w=1]]']]
C205 _43_:S VSS  C=1.1722699999999998E-16
** [instance C206 of CAPACITOR, params={'capacitance': 0.000125621 prefix:SIUnitPrefix.PICO} connections=['A: [connection C206/A =>[signal: _60_:D w=1]]', 'B: [connection C206/B =>[signal: hold17:A w=1]]']]
C206 _60_:D hold17:A  C=1.25621E-16
** [instance C207 of CAPACITOR, params={'capacitance': 0.000139208 prefix:SIUnitPrefix.PICO} connections=['A: [connection C207/A =>[signal: _60_:D w=1]]', 'B: [connection C207/B =>[signal: hold21:A w=1]]']]
C207 _60_:D hold21:A  C=1.3920800000000001E-16
** [instance C208 of CAPACITOR, params={'capacitance': 0.000287136 prefix:SIUnitPrefix.PICO} connections=['A: [connection C208/A =>[signal: _60_:D w=1]]', 'B: [connection C208/B =>[signal: _23_:24 w=1]]']]
C208 _60_:D _23_:24  C=2.87136E-16
** [instance C209 of CAPACITOR, params={'capacitance': 0.000311006 prefix:SIUnitPrefix.PICO} connections=['A: [connection C209/A =>[signal: _60_:D w=1]]', 'B: [connection C209/B =>[signal: VSS w=1]]']]
C209 _60_:D VSS  C=3.11006E-16
** [instance C210 of CAPACITOR, params={'capacitance': 0.000405643 prefix:SIUnitPrefix.PICO} connections=['A: [connection C210/A =>[signal: hold21:A w=1]]', 'B: [connection C210/B =>[signal: VSS w=1]]']]
C210 hold21:A VSS  C=4.05643E-16
** [instance C211 of CAPACITOR, params={'capacitance': 0.000126439 prefix:SIUnitPrefix.PICO} connections=['A: [connection C211/A =>[signal: hold21:A w=1]]', 'B: [connection C211/B =>[signal: hold27:A w=1]]']]
C211 hold21:A hold27:A  C=1.26439E-16
** [instance C212 of CAPACITOR, params={'capacitance': 5.92441e-05 prefix:SIUnitPrefix.PICO} connections=['A: [connection C212/A =>[signal: hold21:A w=1]]', 'B: [connection C212/B =>[signal: clknet_1_1__leaf_scan_clk:81 w=1]]']]
C212 hold21:A clknet_1_1__leaf_scan_clk:81  C=5.924409999999999E-17
** [instance C213 of CAPACITOR, params={'capacitance': 0.000112224 prefix:SIUnitPrefix.PICO} connections=['A: [connection C213/A =>[signal: hold21:A w=1]]', 'B: [connection C213/B =>[signal: mem[12]:27 w=1]]']]
C213 hold21:A mem[12]:27  C=1.12224E-16
** [instance C214 of CAPACITOR, params={'capacitance': 0.000405643 prefix:SIUnitPrefix.PICO} connections=['A: [connection C214/A =>[signal: _43_:X w=1]]', 'B: [connection C214/B =>[signal: VSS w=1]]']]
C214 _43_:X VSS  C=4.05643E-16
** [instance C215 of CAPACITOR, params={'capacitance': 1.58163e-05 prefix:SIUnitPrefix.PICO} connections=['A: [connection C215/A =>[signal: _38_:A1 w=1]]', 'B: [connection C215/B =>[signal: hold21:A w=1]]']]
C215 _38_:A1 hold21:A  C=1.5816299999999998E-17
** [instance C216 of CAPACITOR, params={'capacitance': 0.00133449 prefix:SIUnitPrefix.PICO} connections=['A: [connection C216/A =>[signal: _38_:A1 w=1]]', 'B: [connection C216/B =>[signal: VSS w=1]]']]
C216 _38_:A1 VSS  C=1.33449E-15
** [instance C217 of CAPACITOR, params={'capacitance': 7.95804e-05 prefix:SIUnitPrefix.PICO} connections=['A: [connection C217/A =>[signal: _38_:A1 w=1]]', 'B: [connection C217/B =>[signal: fanout13:A w=1]]']]
C217 _38_:A1 fanout13:A  C=7.958039999999999E-17
** [instance C218 of CAPACITOR, params={'capacitance': 9.49532e-05 prefix:SIUnitPrefix.PICO} connections=['A: [connection C218/A =>[signal: _38_:A1 w=1]]', 'B: [connection C218/B =>[signal: _24_:36 w=1]]']]
C218 _38_:A1 _24_:36  C=9.49532E-17
** [instance C219 of CAPACITOR, params={'capacitance': 0.00081832 prefix:SIUnitPrefix.PICO} connections=['A: [connection C219/A =>[signal: _38_:A1 w=1]]', 'B: [connection C219/B =>[signal: net29:14 w=1]]']]
C219 _38_:A1 net29:14  C=8.1832E-16
** [instance C220 of CAPACITOR, params={'capacitance': 0.0 prefix:SIUnitPrefix.PICO} connections=['A: [connection C220/A =>[signal: _44_:A0 w=1]]', 'B: [connection C220/B =>[signal: hold21:A w=1]]']]
** C220 _44_:A0 hold21:A  C=0.0 [skipped because C=0]
** [instance C221 of CAPACITOR, params={'capacitance': 0.000279597 prefix:SIUnitPrefix.PICO} connections=['A: [connection C221/A =>[signal: _44_:A0 w=1]]', 'B: [connection C221/B =>[signal: _24_:36 w=1]]']]
C221 _44_:A0 _24_:36  C=2.7959700000000004E-16
** [instance C222 of CAPACITOR, params={'capacitance': 1.6271e-05 prefix:SIUnitPrefix.PICO} connections=['A: [connection C222/A =>[signal: _44_:A0 w=1]]', 'B: [connection C222/B =>[signal: clknet_0_scan_clk:49 w=1]]']]
C222 _44_:A0 clknet_0_scan_clk:49  C=1.6271E-17
** [instance C223 of CAPACITOR, params={'capacitance': 4.18217e-05 prefix:SIUnitPrefix.PICO} connections=['A: [connection C223/A =>[signal: _44_:A0 w=1]]', 'B: [connection C223/B =>[signal: _60_:CLK w=1]]']]
C223 _44_:A0 _60_:CLK  C=4.1821699999999997E-17
** [instance C224 of CAPACITOR, params={'capacitance': 0.000139637 prefix:SIUnitPrefix.PICO} connections=['A: [connection C224/A =>[signal: _44_:A0 w=1]]', 'B: [connection C224/B =>[signal: hold27:A w=1]]']]
C224 _44_:A0 hold27:A  C=1.3963699999999999E-16
** [instance C225 of CAPACITOR, params={'capacitance': 9.00919e-05 prefix:SIUnitPrefix.PICO} connections=['A: [connection C225/A =>[signal: _44_:A0 w=1]]', 'B: [connection C225/B =>[signal: mem[12]:27 w=1]]']]
C225 _44_:A0 mem[12]:27  C=9.009189999999999E-17
** [instance C226 of CAPACITOR, params={'capacitance': 0.000118502 prefix:SIUnitPrefix.PICO} connections=['A: [connection C226/A =>[signal: _44_:A0 w=1]]', 'B: [connection C226/B =>[signal: _60_:D w=1]]']]
C226 _44_:A0 _60_:D  C=1.18502E-16
** [instance C227 of CAPACITOR, params={'capacitance': 1.28171e-05 prefix:SIUnitPrefix.PICO} connections=['A: [connection C227/A =>[signal: _44_:A0 w=1]]', 'B: [connection C227/B =>[signal: _44_:A1 w=1]]']]
C227 _44_:A0 _44_:A1  C=1.28171E-17
** [instance C228 of CAPACITOR, params={'capacitance': 0.00123218 prefix:SIUnitPrefix.PICO} connections=['A: [connection C228/A =>[signal: _44_:A0 w=1]]', 'B: [connection C228/B =>[signal: VSS w=1]]']]
C228 _44_:A0 VSS  C=1.23218E-15
** [instance C229 of CAPACITOR, params={'capacitance': 4.64895e-05 prefix:SIUnitPrefix.PICO} connections=['A: [connection C229/A =>[signal: _44_:A0 w=1]]', 'B: [connection C229/B =>[signal: fanout13:A w=1]]']]
C229 _44_:A0 fanout13:A  C=4.64895E-17
** [instance C230 of CAPACITOR, params={'capacitance': 0.0 prefix:SIUnitPrefix.PICO} connections=['A: [connection C230/A =>[signal: _44_:A1 w=1]]', 'B: [connection C230/B =>[signal: hold21:A w=1]]']]
** C230 _44_:A1 hold21:A  C=0.0 [skipped because C=0]
** [instance C231 of CAPACITOR, params={'capacitance': 2.85234e-05 prefix:SIUnitPrefix.PICO} connections=['A: [connection C231/A =>[signal: _44_:A1 w=1]]', 'B: [connection C231/B =>[signal: clknet_0_scan_clk:33 w=1]]']]
C231 _44_:A1 clknet_0_scan_clk:33  C=2.85234E-17
** [instance C232 of CAPACITOR, params={'capacitance': 0.0 prefix:SIUnitPrefix.PICO} connections=['A: [connection C232/A =>[signal: _44_:A1 w=1]]', 'B: [connection C232/B =>[signal: _61_:CLK w=1]]']]
** C232 _44_:A1 _61_:CLK  C=0.0 [skipped because C=0]
** [instance C233 of CAPACITOR, params={'capacitance': 0.0 prefix:SIUnitPrefix.PICO} connections=['A: [connection C233/A =>[signal: _44_:A1 w=1]]', 'B: [connection C233/B =>[signal: hold27:A w=1]]']]
** C233 _44_:A1 hold27:A  C=0.0 [skipped because C=0]
** [instance C234 of CAPACITOR, params={'capacitance': 0.000485429 prefix:SIUnitPrefix.PICO} connections=['A: [connection C234/A =>[signal: _44_:A1 w=1]]', 'B: [connection C234/B =>[signal: hold29:A w=1]]']]
C234 _44_:A1 hold29:A  C=4.85429E-16
** [instance C235 of CAPACITOR, params={'capacitance': 0.000193596 prefix:SIUnitPrefix.PICO} connections=['A: [connection C235/A =>[signal: _44_:A1 w=1]]', 'B: [connection C235/B =>[signal: mem[8]:10 w=1]]']]
C235 _44_:A1 mem[8]:10  C=1.93596E-16
** [instance C236 of CAPACITOR, params={'capacitance': 0.00036015 prefix:SIUnitPrefix.PICO} connections=['A: [connection C236/A =>[signal: _44_:A1 w=1]]', 'B: [connection C236/B =>[signal: VSS w=1]]']]
C236 _44_:A1 VSS  C=3.6015E-16
** [instance C237 of CAPACITOR, params={'capacitance': 0.00020256 prefix:SIUnitPrefix.PICO} connections=['A: [connection C237/A =>[signal: _61_:CLK w=1]]', 'B: [connection C237/B =>[signal: hold21:A w=1]]']]
C237 _61_:CLK hold21:A  C=2.0256E-16
** [instance C238 of CAPACITOR, params={'capacitance': 0.000140524 prefix:SIUnitPrefix.PICO} connections=['A: [connection C238/A =>[signal: _61_:CLK w=1]]', 'B: [connection C238/B =>[signal: VSS w=1]]']]
C238 _61_:CLK VSS  C=1.4052399999999998E-16
** [instance C239 of CAPACITOR, params={'capacitance': 2.84026e-05 prefix:SIUnitPrefix.PICO} connections=['A: [connection C239/A =>[signal: _61_:CLK w=1]]', 'B: [connection C239/B =>[signal: mem[12]:6 w=1]]']]
C239 _61_:CLK mem[12]:6  C=2.8402600000000003E-17
** [instance C240 of CAPACITOR, params={'capacitance': 0.000102545 prefix:SIUnitPrefix.PICO} connections=['A: [connection C240/A =>[signal: _61_:D w=1]]', 'B: [connection C240/B =>[signal: hold21:A w=1]]']]
C240 _61_:D hold21:A  C=1.02545E-16
** [instance C241 of CAPACITOR, params={'capacitance': 3.05985e-05 prefix:SIUnitPrefix.PICO} connections=['A: [connection C241/A =>[signal: _61_:D w=1]]', 'B: [connection C241/B =>[signal: mem[12]:27 w=1]]']]
C241 _61_:D mem[12]:27  C=3.05985E-17
** [instance C242 of CAPACITOR, params={'capacitance': 0.000206631 prefix:SIUnitPrefix.PICO} connections=['A: [connection C242/A =>[signal: _61_:D w=1]]', 'B: [connection C242/B =>[signal: VSS w=1]]']]
C242 _61_:D VSS  C=2.06631E-16
** [instance C243 of CAPACITOR, params={'capacitance': 9.63055e-05 prefix:SIUnitPrefix.PICO} connections=['A: [connection C243/A =>[signal: _61_:D w=1]]', 'B: [connection C243/B =>[signal: fanout13:A w=1]]']]
C243 _61_:D fanout13:A  C=9.63055E-17
** [instance C244 of CAPACITOR, params={'capacitance': 9.25014e-06 prefix:SIUnitPrefix.PICO} connections=['A: [connection C244/A =>[signal: fanout13:A w=1]]', 'B: [connection C244/B =>[signal: hold21:A w=1]]']]
C244 fanout13:A hold21:A  C=9.250139999999999E-18
** [instance C245 of CAPACITOR, params={'capacitance': 5.03772e-05 prefix:SIUnitPrefix.PICO} connections=['A: [connection C245/A =>[signal: fanout13:A w=1]]', 'B: [connection C245/B =>[signal: hold23:A w=1]]']]
C245 fanout13:A hold23:A  C=5.0377200000000003E-17
** [instance C246 of CAPACITOR, params={'capacitance': 0.000146885 prefix:SIUnitPrefix.PICO} connections=['A: [connection C246/A =>[signal: fanout13:A w=1]]', 'B: [connection C246/B =>[signal: hold27:A w=1]]']]
C246 fanout13:A hold27:A  C=1.46885E-16
** [instance C247 of CAPACITOR, params={'capacitance': 6.24758e-05 prefix:SIUnitPrefix.PICO} connections=['A: [connection C247/A =>[signal: fanout13:A w=1]]', 'B: [connection C247/B =>[signal: net2:10 w=1]]']]
C247 fanout13:A net2:10  C=6.24758E-17
** [instance C248 of CAPACITOR, params={'capacitance': 1.40306e-05 prefix:SIUnitPrefix.PICO} connections=['A: [connection C248/A =>[signal: fanout13:A w=1]]', 'B: [connection C248/B =>[signal: net23:10 w=1]]']]
C248 fanout13:A net23:10  C=1.40306E-17
** [instance C249 of CAPACITOR, params={'capacitance': 0.000814417 prefix:SIUnitPrefix.PICO} connections=['A: [connection C249/A =>[signal: fanout13:A w=1]]', 'B: [connection C249/B =>[signal: VSS w=1]]']]
C249 fanout13:A VSS  C=8.14417E-16
** [instance C250 of CAPACITOR, params={'capacitance': 0.000346408 prefix:SIUnitPrefix.PICO} connections=['A: [connection C250/A =>[signal: _62_:D w=1]]', 'B: [connection C250/B =>[signal: VSS w=1]]']]
C250 _62_:D VSS  C=3.4640799999999996E-16
** [instance C251 of CAPACITOR, params={'capacitance': 8.95221e-05 prefix:SIUnitPrefix.PICO} connections=['A: [connection C251/A =>[signal: _62_:D w=1]]', 'B: [connection C251/B =>[signal: hold23:A w=1]]']]
C251 _62_:D hold23:A  C=8.952209999999999E-17
** [instance C252 of CAPACITOR, params={'capacitance': 0.000359715 prefix:SIUnitPrefix.PICO} connections=['A: [connection C252/A =>[signal: _62_:D w=1]]', 'B: [connection C252/B =>[signal: hold29:A w=1]]']]
C252 _62_:D hold29:A  C=3.5971499999999997E-16
** [instance C253 of CAPACITOR, params={'capacitance': 0.000176941 prefix:SIUnitPrefix.PICO} connections=['A: [connection C253/A =>[signal: _62_:D w=1]]', 'B: [connection C253/B =>[signal: mem[8]:10 w=1]]']]
C253 _62_:D mem[8]:10  C=1.7694100000000001E-16
** [instance C254 of CAPACITOR, params={'capacitance': 8.01554e-05 prefix:SIUnitPrefix.PICO} connections=['A: [connection C254/A =>[signal: _62_:D w=1]]', 'B: [connection C254/B =>[signal: mem[9]:10 w=1]]']]
C254 _62_:D mem[9]:10  C=8.01554E-17
** [instance C255 of CAPACITOR, params={'capacitance': 7.7939e-05 prefix:SIUnitPrefix.PICO} connections=['A: [connection C255/A =>[signal: _62_:D w=1]]', 'B: [connection C255/B =>[signal: mem[9]:23 w=1]]']]
C255 _62_:D mem[9]:23  C=7.7939E-17
** [instance C256 of CAPACITOR, params={'capacitance': 0.000346408 prefix:SIUnitPrefix.PICO} connections=['A: [connection C256/A =>[signal: _44_:X w=1]]', 'B: [connection C256/B =>[signal: VSS w=1]]']]
C256 _44_:X VSS  C=3.4640799999999996E-16
** [instance C257 of CAPACITOR, params={'capacitance': 0.000140799 prefix:SIUnitPrefix.PICO} connections=['A: [connection C257/A =>[signal: _63_:D w=1]]', 'B: [connection C257/B =>[signal: VSS w=1]]']]
C257 _63_:D VSS  C=1.40799E-16
** [instance C258 of CAPACITOR, params={'capacitance': 0.000343053 prefix:SIUnitPrefix.PICO} connections=['A: [connection C258/A =>[signal: _63_:D w=1]]', 'B: [connection C258/B =>[signal: hold18:A w=1]]']]
C258 _63_:D hold18:A  C=3.4305300000000002E-16
** [instance C259 of CAPACITOR, params={'capacitance': 1.74816e-05 prefix:SIUnitPrefix.PICO} connections=['A: [connection C259/A =>[signal: _63_:D w=1]]', 'B: [connection C259/B =>[signal: mem[9]:23 w=1]]']]
C259 _63_:D mem[9]:23  C=1.7481599999999998E-17
** [instance C260 of CAPACITOR, params={'capacitance': 0.000140799 prefix:SIUnitPrefix.PICO} connections=['A: [connection C260/A =>[signal: _45_:X w=1]]', 'B: [connection C260/B =>[signal: VSS w=1]]']]
C260 _45_:X VSS  C=1.40799E-16
** [instance C261 of CAPACITOR, params={'capacitance': 5.33005e-05 prefix:SIUnitPrefix.PICO} connections=['A: [connection C261/A =>[signal: _45_:S w=1]]', 'B: [connection C261/B =>[signal: _63_:D w=1]]']]
C261 _45_:S _63_:D  C=5.33005E-17
** [instance C262 of CAPACITOR, params={'capacitance': 4.18895e-05 prefix:SIUnitPrefix.PICO} connections=['A: [connection C262/A =>[signal: _45_:S w=1]]', 'B: [connection C262/B =>[signal: _46_:A1 w=1]]']]
C262 _45_:S _46_:A1  C=4.18895E-17
** [instance C263 of CAPACITOR, params={'capacitance': 0.000211476 prefix:SIUnitPrefix.PICO} connections=['A: [connection C263/A =>[signal: _45_:S w=1]]', 'B: [connection C263/B =>[signal: VSS w=1]]']]
C263 _45_:S VSS  C=2.11476E-16
** [instance C264 of CAPACITOR, params={'capacitance': 0.000140933 prefix:SIUnitPrefix.PICO} connections=['A: [connection C264/A =>[signal: _45_:S w=1]]', 'B: [connection C264/B =>[signal: _46_:A0 w=1]]']]
C264 _45_:S _46_:A0  C=1.4093299999999998E-16
** [instance C265 of CAPACITOR, params={'capacitance': 1.21258e-05 prefix:SIUnitPrefix.PICO} connections=['A: [connection C265/A =>[signal: _45_:S w=1]]', 'B: [connection C265/B =>[signal: net29:14 w=1]]']]
C265 _45_:S net29:14  C=1.2125799999999999E-17
** [instance C266 of CAPACITOR, params={'capacitance': 0.000344641 prefix:SIUnitPrefix.PICO} connections=['A: [connection C266/A =>[signal: _46_:A1 w=1]]', 'B: [connection C266/B =>[signal: _63_:D w=1]]']]
C266 _46_:A1 _63_:D  C=3.4464100000000003E-16
** [instance C267 of CAPACITOR, params={'capacitance': 3.38136e-05 prefix:SIUnitPrefix.PICO} connections=['A: [connection C267/A =>[signal: _46_:A1 w=1]]', 'B: [connection C267/B =>[signal: _09_:12 w=1]]']]
C267 _46_:A1 _09_:12  C=3.3813599999999994E-17
** [instance C268 of CAPACITOR, params={'capacitance': 5.7616e-05 prefix:SIUnitPrefix.PICO} connections=['A: [connection C268/A =>[signal: _46_:A1 w=1]]', 'B: [connection C268/B =>[signal: _62_:CLK w=1]]']]
C268 _46_:A1 _62_:CLK  C=5.761599999999999E-17
** [instance C269 of CAPACITOR, params={'capacitance': 1.6815e-05 prefix:SIUnitPrefix.PICO} connections=['A: [connection C269/A =>[signal: _46_:A1 w=1]]', 'B: [connection C269/B =>[signal: clknet_1_0__leaf_scan_clk:81 w=1]]']]
C269 _46_:A1 clknet_1_0__leaf_scan_clk:81  C=1.6815000000000002E-17
** [instance C270 of CAPACITOR, params={'capacitance': 8.11424e-05 prefix:SIUnitPrefix.PICO} connections=['A: [connection C270/A =>[signal: _46_:A1 w=1]]', 'B: [connection C270/B =>[signal: clknet_1_0__leaf_scan_clk:90 w=1]]']]
C270 _46_:A1 clknet_1_0__leaf_scan_clk:90  C=8.11424E-17
** [instance C271 of CAPACITOR, params={'capacitance': 1.12669e-05 prefix:SIUnitPrefix.PICO} connections=['A: [connection C271/A =>[signal: _46_:A1 w=1]]', 'B: [connection C271/B =>[signal: hold18:A w=1]]']]
C271 _46_:A1 hold18:A  C=1.12669E-17
** [instance C272 of CAPACITOR, params={'capacitance': 0.000187022 prefix:SIUnitPrefix.PICO} connections=['A: [connection C272/A =>[signal: _46_:A1 w=1]]', 'B: [connection C272/B =>[signal: VSS w=1]]']]
C272 _46_:A1 VSS  C=1.8702200000000001E-16
** [instance C273 of CAPACITOR, params={'capacitance': 5.71472e-05 prefix:SIUnitPrefix.PICO} connections=['A: [connection C273/A =>[signal: _46_:A1 w=1]]', 'B: [connection C273/B =>[signal: net12:22 w=1]]']]
C273 _46_:A1 net12:22  C=5.71472E-17
** [instance C274 of CAPACITOR, params={'capacitance': 0.000327885 prefix:SIUnitPrefix.PICO} connections=['A: [connection C274/A =>[signal: hold15:A w=1]]', 'B: [connection C274/B =>[signal: VSS w=1]]']]
C274 hold15:A VSS  C=3.2788499999999995E-16
** [instance C275 of CAPACITOR, params={'capacitance': 0.000170532 prefix:SIUnitPrefix.PICO} connections=['A: [connection C275/A =>[signal: hold15:A w=1]]', 'B: [connection C275/B =>[signal: hold18:A w=1]]']]
C275 hold15:A hold18:A  C=1.7053200000000002E-16
** [instance C276 of CAPACITOR, params={'capacitance': 0.000317609 prefix:SIUnitPrefix.PICO} connections=['A: [connection C276/A =>[signal: hold15:A w=1]]', 'B: [connection C276/B =>[signal: net12:8 w=1]]']]
C276 hold15:A net12:8  C=3.17609E-16
** [instance C277 of CAPACITOR, params={'capacitance': 8.25843e-06 prefix:SIUnitPrefix.PICO} connections=['A: [connection C277/A =>[signal: hold15:A w=1]]', 'B: [connection C277/B =>[signal: net12:22 w=1]]']]
C277 hold15:A net12:22  C=8.25843E-18
** [instance C278 of CAPACITOR, params={'capacitance': 0.000136958 prefix:SIUnitPrefix.PICO} connections=['A: [connection C278/A =>[signal: hold15:A w=1]]', 'B: [connection C278/B =>[signal: net29:14 w=1]]']]
C278 hold15:A net29:14  C=1.36958E-16
** [instance C279 of CAPACITOR, params={'capacitance': 0.000327885 prefix:SIUnitPrefix.PICO} connections=['A: [connection C279/A =>[signal: _46_:X w=1]]', 'B: [connection C279/B =>[signal: VSS w=1]]']]
C279 _46_:X VSS  C=3.2788499999999995E-16
** [instance C280 of CAPACITOR, params={'capacitance': 0.000182444 prefix:SIUnitPrefix.PICO} connections=['A: [connection C280/A =>[signal: _65_:D w=1]]', 'B: [connection C280/B =>[signal: VSS w=1]]']]
C280 _65_:D VSS  C=1.82444E-16
** [instance C281 of CAPACITOR, params={'capacitance': 0.000275298 prefix:SIUnitPrefix.PICO} connections=['A: [connection C281/A =>[signal: _65_:D w=1]]', 'B: [connection C281/B =>[signal: _09_:12 w=1]]']]
C281 _65_:D _09_:12  C=2.7529799999999997E-16
** [instance C282 of CAPACITOR, params={'capacitance': 0.000337211 prefix:SIUnitPrefix.PICO} connections=['A: [connection C282/A =>[signal: _65_:D w=1]]', 'B: [connection C282/B =>[signal: net12:26 w=1]]']]
C282 _65_:D net12:26  C=3.3721100000000003E-16
** [instance C283 of CAPACITOR, params={'capacitance': 0.000200838 prefix:SIUnitPrefix.PICO} connections=['A: [connection C283/A =>[signal: _65_:D w=1]]', 'B: [connection C283/B =>[signal: net12:32 w=1]]']]
C283 _65_:D net12:32  C=2.00838E-16
** [instance C284 of CAPACITOR, params={'capacitance': 0.000182444 prefix:SIUnitPrefix.PICO} connections=['A: [connection C284/A =>[signal: _47_:X w=1]]', 'B: [connection C284/B =>[signal: VSS w=1]]']]
C284 _47_:X VSS  C=1.82444E-16
** [instance C285 of CAPACITOR, params={'capacitance': 0.000495255 prefix:SIUnitPrefix.PICO} connections=['A: [connection C285/A =>[signal: _48_:X w=1]]', 'B: [connection C285/B =>[signal: VSS w=1]]']]
C285 _48_:X VSS  C=4.95255E-16
** [instance C286 of CAPACITOR, params={'capacitance': 0.000171368 prefix:SIUnitPrefix.PICO} connections=['A: [connection C286/A =>[signal: _36_:A0 w=1]]', 'B: [connection C286/B =>[signal: _66_:D w=1]]']]
C286 _36_:A0 _66_:D  C=1.71368E-16
** [instance C287 of CAPACITOR, params={'capacitance': 0.000338493 prefix:SIUnitPrefix.PICO} connections=['A: [connection C287/A =>[signal: _36_:A0 w=1]]', 'B: [connection C287/B =>[signal: VSS w=1]]']]
C287 _36_:A0 VSS  C=3.3849299999999996E-16
** [instance C288 of CAPACITOR, params={'capacitance': 0.0 prefix:SIUnitPrefix.PICO} connections=['A: [connection C288/A =>[signal: _36_:A0 w=1]]', 'B: [connection C288/B =>[signal: mem[5]:10 w=1]]']]
** C288 _36_:A0 mem[5]:10  C=0.0 [skipped because C=0]
** [instance C289 of CAPACITOR, params={'capacitance': 7.33819e-05 prefix:SIUnitPrefix.PICO} connections=['A: [connection C289/A =>[signal: _37_:A1 w=1]]', 'B: [connection C289/B =>[signal: _66_:D w=1]]']]
C289 _37_:A1 _66_:D  C=7.33819E-17
** [instance C290 of CAPACITOR, params={'capacitance': 4.64259e-05 prefix:SIUnitPrefix.PICO} connections=['A: [connection C290/A =>[signal: _37_:A1 w=1]]', 'B: [connection C290/B =>[signal: VSS w=1]]']]
C290 _37_:A1 VSS  C=4.6425899999999996E-17
** [instance C291 of CAPACITOR, params={'capacitance': 0.00116104 prefix:SIUnitPrefix.PICO} connections=['A: [connection C291/A =>[signal: hold19:A w=1]]', 'B: [connection C291/B =>[signal: VSS w=1]]']]
C291 hold19:A VSS  C=1.1610399999999998E-15
** [instance C292 of CAPACITOR, params={'capacitance': 9.48443e-05 prefix:SIUnitPrefix.PICO} connections=['A: [connection C292/A =>[signal: hold19:A w=1]]', 'B: [connection C292/B =>[signal: hold37:A w=1]]']]
C292 hold19:A hold37:A  C=9.484429999999999E-17
** [instance C293 of CAPACITOR, params={'capacitance': 0.000447719 prefix:SIUnitPrefix.PICO} connections=['A: [connection C293/A =>[signal: hold19:A w=1]]', 'B: [connection C293/B =>[signal: mem[5]:26 w=1]]']]
C293 hold19:A mem[5]:26  C=4.47719E-16
** [instance C294 of CAPACITOR, params={'capacitance': 0.000679752 prefix:SIUnitPrefix.PICO} connections=['A: [connection C294/A =>[signal: _49_:X w=1]]', 'B: [connection C294/B =>[signal: VSS w=1]]']]
C294 _49_:X VSS  C=6.79752E-16
** [instance C295 of CAPACITOR, params={'capacitance': 0.00184079 prefix:SIUnitPrefix.PICO} connections=['A: [connection C295/A =>[signal: _09_:12 w=1]]', 'B: [connection C295/B =>[signal: VSS w=1]]']]
C295 _09_:12 VSS  C=1.8407899999999997E-15
** [instance C296 of CAPACITOR, params={'capacitance': 0.0 prefix:SIUnitPrefix.PICO} connections=['A: [connection C296/A =>[signal: _09_:12 w=1]]', 'B: [connection C296/B =>[signal: hold18:A w=1]]']]
** C296 _09_:12 hold18:A  C=0.0 [skipped because C=0]
** [instance C297 of CAPACITOR, params={'capacitance': 0.000308594 prefix:SIUnitPrefix.PICO} connections=['A: [connection C297/A =>[signal: _09_:12 w=1]]', 'B: [connection C297/B =>[signal: clknet_1_0__leaf_scan_clk:81 w=1]]']]
C297 _09_:12 clknet_1_0__leaf_scan_clk:81  C=3.0859399999999997E-16
** [instance C298 of CAPACITOR, params={'capacitance': 0.000142675 prefix:SIUnitPrefix.PICO} connections=['A: [connection C298/A =>[signal: _09_:12 w=1]]', 'B: [connection C298/B =>[signal: clknet_1_0__leaf_scan_clk:90 w=1]]']]
C298 _09_:12 clknet_1_0__leaf_scan_clk:90  C=1.4267500000000002E-16
** [instance C299 of CAPACITOR, params={'capacitance': 0.000426969 prefix:SIUnitPrefix.PICO} connections=['A: [connection C299/A =>[signal: _09_:12 w=1]]', 'B: [connection C299/B =>[signal: net12:8 w=1]]']]
C299 _09_:12 net12:8  C=4.26969E-16
** [instance C300 of CAPACITOR, params={'capacitance': 5.00869e-05 prefix:SIUnitPrefix.PICO} connections=['A: [connection C300/A =>[signal: _09_:12 w=1]]', 'B: [connection C300/B =>[signal: net12:16 w=1]]']]
C300 _09_:12 net12:16  C=5.00869E-17
** [instance C301 of CAPACITOR, params={'capacitance': 1.41665e-05 prefix:SIUnitPrefix.PICO} connections=['A: [connection C301/A =>[signal: _09_:12 w=1]]', 'B: [connection C301/B =>[signal: net12:26 w=1]]']]
C301 _09_:12 net12:26  C=1.41665E-17
** [instance C302 of CAPACITOR, params={'capacitance': 7.17333e-05 prefix:SIUnitPrefix.PICO} connections=['A: [connection C302/A =>[signal: _09_:12 w=1]]', 'B: [connection C302/B =>[signal: net12:32 w=1]]']]
C302 _09_:12 net12:32  C=7.173330000000001E-17
** [instance C303 of CAPACITOR, params={'capacitance': 0.000221634 prefix:SIUnitPrefix.PICO} connections=['A: [connection C303/A =>[signal: _09_:12 w=1]]', 'B: [connection C303/B =>[signal: net12:46 w=1]]']]
C303 _09_:12 net12:46  C=2.21634E-16
** [instance C304 of CAPACITOR, params={'capacitance': 0.000151628 prefix:SIUnitPrefix.PICO} connections=['A: [connection C304/A =>[signal: _09_:12 w=1]]', 'B: [connection C304/B =>[signal: net19:12 w=1]]']]
C304 _09_:12 net19:12  C=1.51628E-16
** [instance C305 of CAPACITOR, params={'capacitance': 0.000626832 prefix:SIUnitPrefix.PICO} connections=['A: [connection C305/A =>[signal: _09_:12 w=1]]', 'B: [connection C305/B =>[signal: net29:14 w=1]]']]
C305 _09_:12 net29:14  C=6.26832E-16
** [instance C306 of CAPACITOR, params={'capacitance': 7.02611e-05 prefix:SIUnitPrefix.PICO} connections=['A: [connection C306/A =>[signal: _36_:A3 w=1]]', 'B: [connection C306/B =>[signal: _09_:12 w=1]]']]
C306 _36_:A3 _09_:12  C=7.02611E-17
** [instance C307 of CAPACITOR, params={'capacitance': 2.28598e-05 prefix:SIUnitPrefix.PICO} connections=['A: [connection C307/A =>[signal: _36_:A3 w=1]]', 'B: [connection C307/B =>[signal: mem[5]:26 w=1]]']]
C307 _36_:A3 mem[5]:26  C=2.28598E-17
** [instance C308 of CAPACITOR, params={'capacitance': 0.00026546 prefix:SIUnitPrefix.PICO} connections=['A: [connection C308/A =>[signal: _36_:A3 w=1]]', 'B: [connection C308/B =>[signal: _49_:A1 w=1]]']]
C308 _36_:A3 _49_:A1  C=2.6546000000000003E-16
** [instance C309 of CAPACITOR, params={'capacitance': 8.27532e-05 prefix:SIUnitPrefix.PICO} connections=['A: [connection C309/A =>[signal: _36_:A3 w=1]]', 'B: [connection C309/B =>[signal: mem[6]:18 w=1]]']]
C309 _36_:A3 mem[6]:18  C=8.275319999999999E-17
** [instance C310 of CAPACITOR, params={'capacitance': 0.000151053 prefix:SIUnitPrefix.PICO} connections=['A: [connection C310/A =>[signal: _36_:A3 w=1]]', 'B: [connection C310/B =>[signal: VSS w=1]]']]
C310 _36_:A3 VSS  C=1.51053E-16
** [instance C311 of CAPACITOR, params={'capacitance': 0.000659214 prefix:SIUnitPrefix.PICO} connections=['A: [connection C311/A =>[signal: _48_:A0 w=1]]', 'B: [connection C311/B =>[signal: _09_:12 w=1]]']]
C311 _48_:A0 _09_:12  C=6.59214E-16
** [instance C312 of CAPACITOR, params={'capacitance': 3.79197e-05 prefix:SIUnitPrefix.PICO} connections=['A: [connection C312/A =>[signal: _48_:A0 w=1]]', 'B: [connection C312/B =>[signal: _69_:D w=1]]']]
C312 _48_:A0 _69_:D  C=3.79197E-17
** [instance C313 of CAPACITOR, params={'capacitance': 0.0 prefix:SIUnitPrefix.PICO} connections=['A: [connection C313/A =>[signal: _48_:A0 w=1]]', 'B: [connection C313/B =>[signal: clknet_1_0__leaf_scan_clk:14 w=1]]']]
** C313 _48_:A0 clknet_1_0__leaf_scan_clk:14  C=0.0 [skipped because C=0]
** [instance C314 of CAPACITOR, params={'capacitance': 0.000124749 prefix:SIUnitPrefix.PICO} connections=['A: [connection C314/A =>[signal: _48_:A0 w=1]]', 'B: [connection C314/B =>[signal: clknet_1_0__leaf_scan_clk:81 w=1]]']]
C314 _48_:A0 clknet_1_0__leaf_scan_clk:81  C=1.2474900000000001E-16
** [instance C315 of CAPACITOR, params={'capacitance': 0.000275513 prefix:SIUnitPrefix.PICO} connections=['A: [connection C315/A =>[signal: _48_:A0 w=1]]', 'B: [connection C315/B =>[signal: hold30:A w=1]]']]
C315 _48_:A0 hold30:A  C=2.75513E-16
** [instance C316 of CAPACITOR, params={'capacitance': 0.000226265 prefix:SIUnitPrefix.PICO} connections=['A: [connection C316/A =>[signal: _48_:A0 w=1]]', 'B: [connection C316/B =>[signal: hold18:A w=1]]']]
C316 _48_:A0 hold18:A  C=2.26265E-16
** [instance C317 of CAPACITOR, params={'capacitance': 9.65846e-05 prefix:SIUnitPrefix.PICO} connections=['A: [connection C317/A =>[signal: _48_:A0 w=1]]', 'B: [connection C317/B =>[signal: mem[7]:10 w=1]]']]
C317 _48_:A0 mem[7]:10  C=9.658459999999999E-17
** [instance C318 of CAPACITOR, params={'capacitance': 0.000146321 prefix:SIUnitPrefix.PICO} connections=['A: [connection C318/A =>[signal: _48_:A0 w=1]]', 'B: [connection C318/B =>[signal: net12:46 w=1]]']]
C318 _48_:A0 net12:46  C=1.46321E-16
** [instance C319 of CAPACITOR, params={'capacitance': 6.87574e-05 prefix:SIUnitPrefix.PICO} connections=['A: [connection C319/A =>[signal: _48_:A0 w=1]]', 'B: [connection C319/B =>[signal: _48_:A1 w=1]]']]
C319 _48_:A0 _48_:A1  C=6.87574E-17
** [instance C320 of CAPACITOR, params={'capacitance': 8.00806e-05 prefix:SIUnitPrefix.PICO} connections=['A: [connection C320/A =>[signal: _48_:A0 w=1]]', 'B: [connection C320/B =>[signal: _49_:A0 w=1]]']]
C320 _48_:A0 _49_:A0  C=8.008059999999999E-17
** [instance C321 of CAPACITOR, params={'capacitance': 0.0 prefix:SIUnitPrefix.PICO} connections=['A: [connection C321/A =>[signal: _48_:A0 w=1]]', 'B: [connection C321/B =>[signal: _67_:D w=1]]']]
** C321 _48_:A0 _67_:D  C=0.0 [skipped because C=0]
** [instance C322 of CAPACITOR, params={'capacitance': 0.000748084 prefix:SIUnitPrefix.PICO} connections=['A: [connection C322/A =>[signal: _48_:A0 w=1]]', 'B: [connection C322/B =>[signal: VSS w=1]]']]
C322 _48_:A0 VSS  C=7.48084E-16
** [instance C323 of CAPACITOR, params={'capacitance': 0.00053128 prefix:SIUnitPrefix.PICO} connections=['A: [connection C323/A =>[signal: _48_:A0 w=1]]', 'B: [connection C323/B =>[signal: _54_:A0 w=1]]']]
C323 _48_:A0 _54_:A0  C=5.312799999999999E-16
** [instance C324 of CAPACITOR, params={'capacitance': 3.91935e-05 prefix:SIUnitPrefix.PICO} connections=['A: [connection C324/A =>[signal: _49_:A1 w=1]]', 'B: [connection C324/B =>[signal: _09_:12 w=1]]']]
C324 _49_:A1 _09_:12  C=3.9193499999999994E-17
** [instance C325 of CAPACITOR, params={'capacitance': 0.00018077 prefix:SIUnitPrefix.PICO} connections=['A: [connection C325/A =>[signal: _49_:A1 w=1]]', 'B: [connection C325/B =>[signal: mem[5]:26 w=1]]']]
C325 _49_:A1 mem[5]:26  C=1.8076999999999998E-16
** [instance C326 of CAPACITOR, params={'capacitance': 0.000157256 prefix:SIUnitPrefix.PICO} connections=['A: [connection C326/A =>[signal: _49_:A1 w=1]]', 'B: [connection C326/B =>[signal: VSS w=1]]']]
C326 _49_:A1 VSS  C=1.5725599999999997E-16
** [instance C327 of CAPACITOR, params={'capacitance': 9.88679e-05 prefix:SIUnitPrefix.PICO} connections=['A: [connection C327/A =>[signal: _62_:CLK w=1]]', 'B: [connection C327/B =>[signal: _09_:12 w=1]]']]
C327 _62_:CLK _09_:12  C=9.886789999999999E-17
** [instance C328 of CAPACITOR, params={'capacitance': 0.000329065 prefix:SIUnitPrefix.PICO} connections=['A: [connection C328/A =>[signal: _62_:CLK w=1]]', 'B: [connection C328/B =>[signal: VSS w=1]]']]
C328 _62_:CLK VSS  C=3.29065E-16
** [instance C329 of CAPACITOR, params={'capacitance': 4.87854e-05 prefix:SIUnitPrefix.PICO} connections=['A: [connection C329/A =>[signal: _62_:CLK w=1]]', 'B: [connection C329/B =>[signal: mem[10]:8 w=1]]']]
C329 _62_:CLK mem[10]:8  C=4.87854E-17
** [instance C330 of CAPACITOR, params={'capacitance': 0.0 prefix:SIUnitPrefix.PICO} connections=['A: [connection C330/A =>[signal: _68_:D w=1]]', 'B: [connection C330/B =>[signal: VSS w=1]]']]
** C330 _68_:D VSS  C=0.0 [skipped because C=0]
** [instance C331 of CAPACITOR, params={'capacitance': 0.00111478 prefix:SIUnitPrefix.PICO} connections=['A: [connection C331/A =>[signal: _50_:X w=1]]', 'B: [connection C331/B =>[signal: VSS w=1]]']]
C331 _50_:X VSS  C=1.11478E-15
** [instance C332 of CAPACITOR, params={'capacitance': 0.00111478 prefix:SIUnitPrefix.PICO} connections=['A: [connection C332/A =>[signal: _10_:26 w=1]]', 'B: [connection C332/B =>[signal: VSS w=1]]']]
C332 _10_:26 VSS  C=1.11478E-15
** [instance C333 of CAPACITOR, params={'capacitance': 0.000356022 prefix:SIUnitPrefix.PICO} connections=['A: [connection C333/A =>[signal: _10_:26 w=1]]', 'B: [connection C333/B =>[signal: hold24:A w=1]]']]
C333 _10_:26 hold24:A  C=3.56022E-16
** [instance C334 of CAPACITOR, params={'capacitance': 0.000182256 prefix:SIUnitPrefix.PICO} connections=['A: [connection C334/A =>[signal: _10_:26 w=1]]', 'B: [connection C334/B =>[signal: _12_:26 w=1]]']]
C334 _10_:26 _12_:26  C=1.8225599999999998E-16
** [instance C335 of CAPACITOR, params={'capacitance': 0.000115997 prefix:SIUnitPrefix.PICO} connections=['A: [connection C335/A =>[signal: _10_:26 w=1]]', 'B: [connection C335/B =>[signal: clknet_1_0__leaf_scan_clk:40 w=1]]']]
C335 _10_:26 clknet_1_0__leaf_scan_clk:40  C=1.1599699999999998E-16
** [instance C336 of CAPACITOR, params={'capacitance': 5.65955e-05 prefix:SIUnitPrefix.PICO} connections=['A: [connection C336/A =>[signal: _10_:26 w=1]]', 'B: [connection C336/B =>[signal: mem[3]:10 w=1]]']]
C336 _10_:26 mem[3]:10  C=5.65955E-17
** [instance C337 of CAPACITOR, params={'capacitance': 5.76848e-05 prefix:SIUnitPrefix.PICO} connections=['A: [connection C337/A =>[signal: _10_:26 w=1]]', 'B: [connection C337/B =>[signal: mem[6]:14 w=1]]']]
C337 _10_:26 mem[6]:14  C=5.768479999999999E-17
** [instance C338 of CAPACITOR, params={'capacitance': 0.00040381 prefix:SIUnitPrefix.PICO} connections=['A: [connection C338/A =>[signal: _10_:26 w=1]]', 'B: [connection C338/B =>[signal: net13:44 w=1]]']]
C338 _10_:26 net13:44  C=4.0381E-16
** [instance C339 of CAPACITOR, params={'capacitance': 6.57914e-05 prefix:SIUnitPrefix.PICO} connections=['A: [connection C339/A =>[signal: _10_:26 w=1]]', 'B: [connection C339/B =>[signal: net26:14 w=1]]']]
C339 _10_:26 net26:14  C=6.57914E-17
** [instance C340 of CAPACITOR, params={'capacitance': 0.000114255 prefix:SIUnitPrefix.PICO} connections=['A: [connection C340/A =>[signal: _54_:A0 w=1]]', 'B: [connection C340/B =>[signal: _10_:26 w=1]]']]
C340 _54_:A0 _10_:26  C=1.14255E-16
** [instance C341 of CAPACITOR, params={'capacitance': 0.000174389 prefix:SIUnitPrefix.PICO} connections=['A: [connection C341/A =>[signal: _54_:A0 w=1]]', 'B: [connection C341/B =>[signal: _12_:26 w=1]]']]
C341 _54_:A0 _12_:26  C=1.74389E-16
** [instance C342 of CAPACITOR, params={'capacitance': 2.16315e-05 prefix:SIUnitPrefix.PICO} connections=['A: [connection C342/A =>[signal: _54_:A0 w=1]]', 'B: [connection C342/B =>[signal: mem[4]:8 w=1]]']]
C342 _54_:A0 mem[4]:8  C=2.16315E-17
** [instance C343 of CAPACITOR, params={'capacitance': 0.0 prefix:SIUnitPrefix.PICO} connections=['A: [connection C343/A =>[signal: _54_:A0 w=1]]', 'B: [connection C343/B =>[signal: mem[5]:10 w=1]]']]
** C343 _54_:A0 mem[5]:10  C=0.0 [skipped because C=0]
** [instance C344 of CAPACITOR, params={'capacitance': 0.000451463 prefix:SIUnitPrefix.PICO} connections=['A: [connection C344/A =>[signal: _54_:A0 w=1]]', 'B: [connection C344/B =>[signal: _55_:A1 w=1]]']]
C344 _54_:A0 _55_:A1  C=4.51463E-16
** [instance C345 of CAPACITOR, params={'capacitance': 2.44318e-05 prefix:SIUnitPrefix.PICO} connections=['A: [connection C345/A =>[signal: _54_:A0 w=1]]', 'B: [connection C345/B =>[signal: _55_:A0 w=1]]']]
C345 _54_:A0 _55_:A0  C=2.44318E-17
** [instance C346 of CAPACITOR, params={'capacitance': 0.00150543 prefix:SIUnitPrefix.PICO} connections=['A: [connection C346/A =>[signal: _54_:A0 w=1]]', 'B: [connection C346/B =>[signal: VSS w=1]]']]
C346 _54_:A0 VSS  C=1.50543E-15
** [instance C347 of CAPACITOR, params={'capacitance': 7.32955e-05 prefix:SIUnitPrefix.PICO} connections=['A: [connection C347/A =>[signal: _55_:A0 w=1]]', 'B: [connection C347/B =>[signal: _10_:26 w=1]]']]
C347 _55_:A0 _10_:26  C=7.32955E-17
** [instance C348 of CAPACITOR, params={'capacitance': 5.71472e-05 prefix:SIUnitPrefix.PICO} connections=['A: [connection C348/A =>[signal: _55_:A0 w=1]]', 'B: [connection C348/B =>[signal: _55_:S w=1]]']]
C348 _55_:A0 _55_:S  C=5.71472E-17
** [instance C349 of CAPACITOR, params={'capacitance': 0.000350503 prefix:SIUnitPrefix.PICO} connections=['A: [connection C349/A =>[signal: _55_:A0 w=1]]', 'B: [connection C349/B =>[signal: net13:44 w=1]]']]
C349 _55_:A0 net13:44  C=3.50503E-16
** [instance C350 of CAPACITOR, params={'capacitance': 0.000495276 prefix:SIUnitPrefix.PICO} connections=['A: [connection C350/A =>[signal: _55_:A0 w=1]]', 'B: [connection C350/B =>[signal: _55_:A1 w=1]]']]
C350 _55_:A0 _55_:A1  C=4.95276E-16
** [instance C351 of CAPACITOR, params={'capacitance': 6.3602e-05 prefix:SIUnitPrefix.PICO} connections=['A: [connection C351/A =>[signal: _55_:A0 w=1]]', 'B: [connection C351/B =>[signal: VSS w=1]]']]
C351 _55_:A0 VSS  C=6.3602E-17
** [instance C352 of CAPACITOR, params={'capacitance': 5.52238e-05 prefix:SIUnitPrefix.PICO} connections=['A: [connection C352/A =>[signal: _55_:S w=1]]', 'B: [connection C352/B =>[signal: _10_:26 w=1]]']]
C352 _55_:S _10_:26  C=5.5223799999999994E-17
** [instance C353 of CAPACITOR, params={'capacitance': 8.95943e-06 prefix:SIUnitPrefix.PICO} connections=['A: [connection C353/A =>[signal: _55_:S w=1]]', 'B: [connection C353/B =>[signal: VSS w=1]]']]
C353 _55_:S VSS  C=8.95943E-18
** [instance C354 of CAPACITOR, params={'capacitance': 5.52302e-05 prefix:SIUnitPrefix.PICO} connections=['A: [connection C354/A =>[signal: _70_:CLK w=1]]', 'B: [connection C354/B =>[signal: _10_:26 w=1]]']]
C354 _70_:CLK _10_:26  C=5.5230199999999994E-17
** [instance C355 of CAPACITOR, params={'capacitance': 2.10759e-05 prefix:SIUnitPrefix.PICO} connections=['A: [connection C355/A =>[signal: _70_:CLK w=1]]', 'B: [connection C355/B =>[signal: VSS w=1]]']]
C355 _70_:CLK VSS  C=2.1075899999999997E-17
** [instance C356 of CAPACITOR, params={'capacitance': 9.24603e-05 prefix:SIUnitPrefix.PICO} connections=['A: [connection C356/A =>[signal: _70_:D w=1]]', 'B: [connection C356/B =>[signal: _10_:26 w=1]]']]
C356 _70_:D _10_:26  C=9.24603E-17
** [instance C357 of CAPACITOR, params={'capacitance': 0.000163757 prefix:SIUnitPrefix.PICO} connections=['A: [connection C357/A =>[signal: _70_:D w=1]]', 'B: [connection C357/B =>[signal: _71_:CLK w=1]]']]
C357 _70_:D _71_:CLK  C=1.63757E-16
** [instance C358 of CAPACITOR, params={'capacitance': 3.18676e-05 prefix:SIUnitPrefix.PICO} connections=['A: [connection C358/A =>[signal: _70_:D w=1]]', 'B: [connection C358/B =>[signal: clknet_1_0__leaf_scan_clk:20 w=1]]']]
C358 _70_:D clknet_1_0__leaf_scan_clk:20  C=3.18676E-17
** [instance C359 of CAPACITOR, params={'capacitance': 0.0 prefix:SIUnitPrefix.PICO} connections=['A: [connection C359/A =>[signal: _70_:D w=1]]', 'B: [connection C359/B =>[signal: mem[5]:10 w=1]]']]
** C359 _70_:D mem[5]:10  C=0.0 [skipped because C=0]
** [instance C360 of CAPACITOR, params={'capacitance': 4.02462e-05 prefix:SIUnitPrefix.PICO} connections=['A: [connection C360/A =>[signal: _70_:D w=1]]', 'B: [connection C360/B =>[signal: mem[6]:14 w=1]]']]
C360 _70_:D mem[6]:14  C=4.02462E-17
** [instance C361 of CAPACITOR, params={'capacitance': 0.000511771 prefix:SIUnitPrefix.PICO} connections=['A: [connection C361/A =>[signal: _70_:D w=1]]', 'B: [connection C361/B =>[signal: VSS w=1]]']]
C361 _70_:D VSS  C=5.1177099999999995E-16
** [instance C362 of CAPACITOR, params={'capacitance': 0.000127353 prefix:SIUnitPrefix.PICO} connections=['A: [connection C362/A =>[signal: _71_:CLK w=1]]', 'B: [connection C362/B =>[signal: _10_:26 w=1]]']]
C362 _71_:CLK _10_:26  C=1.27353E-16
** [instance C363 of CAPACITOR, params={'capacitance': 0.000722096 prefix:SIUnitPrefix.PICO} connections=['A: [connection C363/A =>[signal: _71_:CLK w=1]]', 'B: [connection C363/B =>[signal: _12_:26 w=1]]']]
C363 _71_:CLK _12_:26  C=7.22096E-16
** [instance C364 of CAPACITOR, params={'capacitance': 0.000168582 prefix:SIUnitPrefix.PICO} connections=['A: [connection C364/A =>[signal: _71_:CLK w=1]]', 'B: [connection C364/B =>[signal: VSS w=1]]']]
C364 _71_:CLK VSS  C=1.6858199999999998E-16
** [instance C365 of CAPACITOR, params={'capacitance': 0.000229456 prefix:SIUnitPrefix.PICO} connections=['A: [connection C365/A =>[signal: _72_:D w=1]]', 'B: [connection C365/B =>[signal: _10_:26 w=1]]']]
C365 _72_:D _10_:26  C=2.29456E-16
** [instance C366 of CAPACITOR, params={'capacitance': 3.29239e-05 prefix:SIUnitPrefix.PICO} connections=['A: [connection C366/A =>[signal: _72_:D w=1]]', 'B: [connection C366/B =>[signal: _12_:26 w=1]]']]
C366 _72_:D _12_:26  C=3.2923899999999995E-17
** [instance C367 of CAPACITOR, params={'capacitance': 0.000263695 prefix:SIUnitPrefix.PICO} connections=['A: [connection C367/A =>[signal: _72_:D w=1]]', 'B: [connection C367/B =>[signal: VSS w=1]]']]
C367 _72_:D VSS  C=2.63695E-16
** [instance C368 of CAPACITOR, params={'capacitance': 0.0 prefix:SIUnitPrefix.PICO} connections=['A: [connection C368/A =>[signal: _72_:D w=1]]', 'B: [connection C368/B =>[signal: _73_:D w=1]]']]
** C368 _72_:D _73_:D  C=0.0 [skipped because C=0]
** [instance C369 of CAPACITOR, params={'capacitance': 7.15591e-05 prefix:SIUnitPrefix.PICO} connections=['A: [connection C369/A =>[signal: _72_:D w=1]]', 'B: [connection C369/B =>[signal: net13:35 w=1]]']]
C369 _72_:D net13:35  C=7.15591E-17
** [instance C370 of CAPACITOR, params={'capacitance': 0.00010096 prefix:SIUnitPrefix.PICO} connections=['A: [connection C370/A =>[signal: _73_:D w=1]]', 'B: [connection C370/B =>[signal: _10_:26 w=1]]']]
C370 _73_:D _10_:26  C=1.0095999999999999E-16
** [instance C371 of CAPACITOR, params={'capacitance': 0.000278879 prefix:SIUnitPrefix.PICO} connections=['A: [connection C371/A =>[signal: _73_:D w=1]]', 'B: [connection C371/B =>[signal: VSS w=1]]']]
C371 _73_:D VSS  C=2.78879E-16
** [instance C372 of CAPACITOR, params={'capacitance': 5.09156e-05 prefix:SIUnitPrefix.PICO} connections=['A: [connection C372/A =>[signal: _73_:D w=1]]', 'B: [connection C372/B =>[signal: mem[3]:10 w=1]]']]
C372 _73_:D mem[3]:10  C=5.0915599999999994E-17
** [instance C373 of CAPACITOR, params={'capacitance': 3.12654e-05 prefix:SIUnitPrefix.PICO} connections=['A: [connection C373/A =>[signal: _73_:D w=1]]', 'B: [connection C373/B =>[signal: mem[3]:23 w=1]]']]
C373 _73_:D mem[3]:23  C=3.12654E-17
** [instance C374 of CAPACITOR, params={'capacitance': 1.64343e-05 prefix:SIUnitPrefix.PICO} connections=['A: [connection C374/A =>[signal: _73_:D w=1]]', 'B: [connection C374/B =>[signal: net12:103 w=1]]']]
C374 _73_:D net12:103  C=1.64343E-17
** [instance C375 of CAPACITOR, params={'capacitance': 0.000846573 prefix:SIUnitPrefix.PICO} connections=['A: [connection C375/A =>[signal: _69_:D w=1]]', 'B: [connection C375/B =>[signal: VSS w=1]]']]
C375 _69_:D VSS  C=8.465729999999999E-16
** [instance C376 of CAPACITOR, params={'capacitance': 1.64343e-05 prefix:SIUnitPrefix.PICO} connections=['A: [connection C376/A =>[signal: _69_:D w=1]]', 'B: [connection C376/B =>[signal: _71_:CLK w=1]]']]
C376 _69_:D _71_:CLK  C=1.64343E-17
** [instance C377 of CAPACITOR, params={'capacitance': 0.000290259 prefix:SIUnitPrefix.PICO} connections=['A: [connection C377/A =>[signal: _69_:D w=1]]', 'B: [connection C377/B =>[signal: _71_:D w=1]]']]
C377 _69_:D _71_:D  C=2.90259E-16
** [instance C378 of CAPACITOR, params={'capacitance': 0.000148196 prefix:SIUnitPrefix.PICO} connections=['A: [connection C378/A =>[signal: _69_:D w=1]]', 'B: [connection C378/B =>[signal: hold18:A w=1]]']]
C378 _69_:D hold18:A  C=1.4819599999999998E-16
** [instance C379 of CAPACITOR, params={'capacitance': 1.76204e-05 prefix:SIUnitPrefix.PICO} connections=['A: [connection C379/A =>[signal: _69_:D w=1]]', 'B: [connection C379/B =>[signal: _12_:26 w=1]]']]
C379 _69_:D _12_:26  C=1.7620400000000002E-17
** [instance C380 of CAPACITOR, params={'capacitance': 0.000133938 prefix:SIUnitPrefix.PICO} connections=['A: [connection C380/A =>[signal: _69_:D w=1]]', 'B: [connection C380/B =>[signal: _22_:12 w=1]]']]
C380 _69_:D _22_:12  C=1.33938E-16
** [instance C381 of CAPACITOR, params={'capacitance': 0.0 prefix:SIUnitPrefix.PICO} connections=['A: [connection C381/A =>[signal: _69_:D w=1]]', 'B: [connection C381/B =>[signal: clknet_1_0__leaf_scan_clk:14 w=1]]']]
** C381 _69_:D clknet_1_0__leaf_scan_clk:14  C=0.0 [skipped because C=0]
** [instance C382 of CAPACITOR, params={'capacitance': 0.0 prefix:SIUnitPrefix.PICO} connections=['A: [connection C382/A =>[signal: _69_:D w=1]]', 'B: [connection C382/B =>[signal: clknet_1_0__leaf_scan_clk:20 w=1]]']]
** C382 _69_:D clknet_1_0__leaf_scan_clk:20  C=0.0 [skipped because C=0]
** [instance C383 of CAPACITOR, params={'capacitance': 0.000100823 prefix:SIUnitPrefix.PICO} connections=['A: [connection C383/A =>[signal: _69_:D w=1]]', 'B: [connection C383/B =>[signal: mem[5]:26 w=1]]']]
C383 _69_:D mem[5]:26  C=1.00823E-16
** [instance C384 of CAPACITOR, params={'capacitance': 0.000146474 prefix:SIUnitPrefix.PICO} connections=['A: [connection C384/A =>[signal: _69_:D w=1]]', 'B: [connection C384/B =>[signal: mem[7]:10 w=1]]']]
C384 _69_:D mem[7]:10  C=1.46474E-16
** [instance C385 of CAPACITOR, params={'capacitance': 0.000123379 prefix:SIUnitPrefix.PICO} connections=['A: [connection C385/A =>[signal: _69_:D w=1]]', 'B: [connection C385/B =>[signal: mem[9]:10 w=1]]']]
C385 _69_:D mem[9]:10  C=1.23379E-16
** [instance C386 of CAPACITOR, params={'capacitance': 0.000100823 prefix:SIUnitPrefix.PICO} connections=['A: [connection C386/A =>[signal: _69_:D w=1]]', 'B: [connection C386/B =>[signal: net12:46 w=1]]']]
C386 _69_:D net12:46  C=1.00823E-16
** [instance C387 of CAPACITOR, params={'capacitance': 0.000313647 prefix:SIUnitPrefix.PICO} connections=['A: [connection C387/A =>[signal: _69_:D w=1]]', 'B: [connection C387/B =>[signal: net3:33 w=1]]']]
C387 _69_:D net3:33  C=3.1364700000000003E-16
** [instance C388 of CAPACITOR, params={'capacitance': 0.000846573 prefix:SIUnitPrefix.PICO} connections=['A: [connection C388/A =>[signal: _51_:X w=1]]', 'B: [connection C388/B =>[signal: VSS w=1]]']]
C388 _51_:X VSS  C=8.465729999999999E-16
** [instance C389 of CAPACITOR, params={'capacitance': 0.000335488 prefix:SIUnitPrefix.PICO} connections=['A: [connection C389/A =>[signal: _32_:A w=1]]', 'B: [connection C389/B =>[signal: _69_:D w=1]]']]
C389 _32_:A _69_:D  C=3.3548799999999997E-16
** [instance C390 of CAPACITOR, params={'capacitance': 0.000230475 prefix:SIUnitPrefix.PICO} connections=['A: [connection C390/A =>[signal: _32_:A w=1]]', 'B: [connection C390/B =>[signal: _32_:B w=1]]']]
C390 _32_:A _32_:B  C=2.30475E-16
** [instance C391 of CAPACITOR, params={'capacitance': 9.65403e-05 prefix:SIUnitPrefix.PICO} connections=['A: [connection C391/A =>[signal: _32_:A w=1]]', 'B: [connection C391/B =>[signal: VSS w=1]]']]
C391 _32_:A VSS  C=9.65403E-17
** [instance C392 of CAPACITOR, params={'capacitance': 5.49489e-05 prefix:SIUnitPrefix.PICO} connections=['A: [connection C392/A =>[signal: _38_:B1 w=1]]', 'B: [connection C392/B =>[signal: _69_:D w=1]]']]
C392 _38_:B1 _69_:D  C=5.49489E-17
** [instance C393 of CAPACITOR, params={'capacitance': 0.000861278 prefix:SIUnitPrefix.PICO} connections=['A: [connection C393/A =>[signal: _38_:B1 w=1]]', 'B: [connection C393/B =>[signal: VSS w=1]]']]
C393 _38_:B1 VSS  C=8.61278E-16
** [instance C394 of CAPACITOR, params={'capacitance': 8.19254e-05 prefix:SIUnitPrefix.PICO} connections=['A: [connection C394/A =>[signal: _38_:B1 w=1]]', 'B: [connection C394/B =>[signal: _50_:A1 w=1]]']]
C394 _38_:B1 _50_:A1  C=8.19254E-17
** [instance C395 of CAPACITOR, params={'capacitance': 3.43051e-05 prefix:SIUnitPrefix.PICO} connections=['A: [connection C395/A =>[signal: _38_:B1 w=1]]', 'B: [connection C395/B =>[signal: _56_:A1 w=1]]']]
C395 _38_:B1 _56_:A1  C=3.43051E-17
** [instance C396 of CAPACITOR, params={'capacitance': 0.000389482 prefix:SIUnitPrefix.PICO} connections=['A: [connection C396/A =>[signal: _38_:B1 w=1]]', 'B: [connection C396/B =>[signal: hold16:A w=1]]']]
C396 _38_:B1 hold16:A  C=3.89482E-16
** [instance C397 of CAPACITOR, params={'capacitance': 0.000282701 prefix:SIUnitPrefix.PICO} connections=['A: [connection C397/A =>[signal: _38_:B1 w=1]]', 'B: [connection C397/B =>[signal: mem[14]:10 w=1]]']]
C397 _38_:B1 mem[14]:10  C=2.82701E-16
** [instance C398 of CAPACITOR, params={'capacitance': 0.000362269 prefix:SIUnitPrefix.PICO} connections=['A: [connection C398/A =>[signal: _38_:B1 w=1]]', 'B: [connection C398/B =>[signal: net13:31 w=1]]']]
C398 _38_:B1 net13:31  C=3.62269E-16
** [instance C399 of CAPACITOR, params={'capacitance': 0.000581285 prefix:SIUnitPrefix.PICO} connections=['A: [connection C399/A =>[signal: _38_:B1 w=1]]', 'B: [connection C399/B =>[signal: net3:33 w=1]]']]
C399 _38_:B1 net3:33  C=5.812849999999999E-16
** [instance C400 of CAPACITOR, params={'capacitance': 0.000842685 prefix:SIUnitPrefix.PICO} connections=['A: [connection C400/A =>[signal: _38_:B1 w=1]]', 'B: [connection C400/B =>[signal: net35:10 w=1]]']]
C400 _38_:B1 net35:10  C=8.42685E-16
** [instance C401 of CAPACITOR, params={'capacitance': 0.000296776 prefix:SIUnitPrefix.PICO} connections=['A: [connection C401/A =>[signal: _49_:A0 w=1]]', 'B: [connection C401/B =>[signal: _69_:D w=1]]']]
C401 _49_:A0 _69_:D  C=2.96776E-16
** [instance C402 of CAPACITOR, params={'capacitance': 7.83587e-05 prefix:SIUnitPrefix.PICO} connections=['A: [connection C402/A =>[signal: _49_:A0 w=1]]', 'B: [connection C402/B =>[signal: hold18:A w=1]]']]
C402 _49_:A0 hold18:A  C=7.83587E-17
** [instance C403 of CAPACITOR, params={'capacitance': 0.000450383 prefix:SIUnitPrefix.PICO} connections=['A: [connection C403/A =>[signal: _49_:A0 w=1]]', 'B: [connection C403/B =>[signal: VSS w=1]]']]
C403 _49_:A0 VSS  C=4.50383E-16
** [instance C404 of CAPACITOR, params={'capacitance': 0.0 prefix:SIUnitPrefix.PICO} connections=['A: [connection C404/A =>[signal: hold34:A w=1]]', 'B: [connection C404/B =>[signal: VSS w=1]]']]
** C404 hold34:A VSS  C=0.0 [skipped because C=0]
** [instance C405 of CAPACITOR, params={'capacitance': 0.00123804 prefix:SIUnitPrefix.PICO} connections=['A: [connection C405/A =>[signal: _52_:X w=1]]', 'B: [connection C405/B =>[signal: VSS w=1]]']]
C405 _52_:X VSS  C=1.2380399999999999E-15
** [instance C406 of CAPACITOR, params={'capacitance': 0.00123804 prefix:SIUnitPrefix.PICO} connections=['A: [connection C406/A =>[signal: _12_:26 w=1]]', 'B: [connection C406/B =>[signal: VSS w=1]]']]
C406 _12_:26 VSS  C=1.2380399999999999E-15
** [instance C407 of CAPACITOR, params={'capacitance': 0.00028834 prefix:SIUnitPrefix.PICO} connections=['A: [connection C407/A =>[signal: _12_:26 w=1]]', 'B: [connection C407/B =>[signal: clknet_1_0__leaf_scan_clk:20 w=1]]']]
C407 _12_:26 clknet_1_0__leaf_scan_clk:20  C=2.8833999999999997E-16
** [instance C408 of CAPACITOR, params={'capacitance': 5.62995e-05 prefix:SIUnitPrefix.PICO} connections=['A: [connection C408/A =>[signal: _12_:26 w=1]]', 'B: [connection C408/B =>[signal: net12:103 w=1]]']]
C408 _12_:26 net12:103  C=5.62995E-17
** [instance C409 of CAPACITOR, params={'capacitance': 8.99422e-05 prefix:SIUnitPrefix.PICO} connections=['A: [connection C409/A =>[signal: _52_:A1 w=1]]', 'B: [connection C409/B =>[signal: _12_:26 w=1]]']]
C409 _52_:A1 _12_:26  C=8.99422E-17
** [instance C410 of CAPACITOR, params={'capacitance': 8.95121e-05 prefix:SIUnitPrefix.PICO} connections=['A: [connection C410/A =>[signal: _52_:A1 w=1]]', 'B: [connection C410/B =>[signal: _72_:D w=1]]']]
C410 _52_:A1 _72_:D  C=8.95121E-17
** [instance C411 of CAPACITOR, params={'capacitance': 0.000335951 prefix:SIUnitPrefix.PICO} connections=['A: [connection C411/A =>[signal: _52_:A1 w=1]]', 'B: [connection C411/B =>[signal: VSS w=1]]']]
C411 _52_:A1 VSS  C=3.3595100000000003E-16
** [instance C412 of CAPACITOR, params={'capacitance': 0.000170964 prefix:SIUnitPrefix.PICO} connections=['A: [connection C412/A =>[signal: _52_:A1 w=1]]', 'B: [connection C412/B =>[signal: net12:103 w=1]]']]
C412 _52_:A1 net12:103  C=1.7096400000000002E-16
** [instance C413 of CAPACITOR, params={'capacitance': 0.000698557 prefix:SIUnitPrefix.PICO} connections=['A: [connection C413/A =>[signal: _71_:D w=1]]', 'B: [connection C413/B =>[signal: _12_:26 w=1]]']]
C413 _71_:D _12_:26  C=6.98557E-16
** [instance C414 of CAPACITOR, params={'capacitance': 0.000940036 prefix:SIUnitPrefix.PICO} connections=['A: [connection C414/A =>[signal: _71_:D w=1]]', 'B: [connection C414/B =>[signal: VSS w=1]]']]
C414 _71_:D VSS  C=9.40036E-16
** [instance C415 of CAPACITOR, params={'capacitance': 0.000103715 prefix:SIUnitPrefix.PICO} connections=['A: [connection C415/A =>[signal: _71_:D w=1]]', 'B: [connection C415/B =>[signal: _22_:12 w=1]]']]
C415 _71_:D _22_:12  C=1.03715E-16
** [instance C416 of CAPACITOR, params={'capacitance': 0.0 prefix:SIUnitPrefix.PICO} connections=['A: [connection C416/A =>[signal: _71_:D w=1]]', 'B: [connection C416/B =>[signal: mem[5]:10 w=1]]']]
** C416 _71_:D mem[5]:10  C=0.0 [skipped because C=0]
** [instance C417 of CAPACITOR, params={'capacitance': 0.000266547 prefix:SIUnitPrefix.PICO} connections=['A: [connection C417/A =>[signal: _71_:D w=1]]', 'B: [connection C417/B =>[signal: mem[5]:26 w=1]]']]
C417 _71_:D mem[5]:26  C=2.66547E-16
** [instance C418 of CAPACITOR, params={'capacitance': 5.01193e-05 prefix:SIUnitPrefix.PICO} connections=['A: [connection C418/A =>[signal: _71_:D w=1]]', 'B: [connection C418/B =>[signal: mem[6]:14 w=1]]']]
C418 _71_:D mem[6]:14  C=5.01193E-17
** [instance C419 of CAPACITOR, params={'capacitance': 9.91086e-05 prefix:SIUnitPrefix.PICO} connections=['A: [connection C419/A =>[signal: _71_:D w=1]]', 'B: [connection C419/B =>[signal: net12:46 w=1]]']]
C419 _71_:D net12:46  C=9.91086E-17
** [instance C420 of CAPACITOR, params={'capacitance': 0.000940036 prefix:SIUnitPrefix.PICO} connections=['A: [connection C420/A =>[signal: _53_:X w=1]]', 'B: [connection C420/B =>[signal: VSS w=1]]']]
C420 _53_:X VSS  C=9.40036E-16
** [instance C421 of CAPACITOR, params={'capacitance': 0.00011817 prefix:SIUnitPrefix.PICO} connections=['A: [connection C421/A =>[signal: _36_:S0 w=1]]', 'B: [connection C421/B =>[signal: _71_:D w=1]]']]
C421 _36_:S0 _71_:D  C=1.1817E-16
** [instance C422 of CAPACITOR, params={'capacitance': 0.0005266 prefix:SIUnitPrefix.PICO} connections=['A: [connection C422/A =>[signal: _36_:S0 w=1]]', 'B: [connection C422/B =>[signal: _22_:12 w=1]]']]
C422 _36_:S0 _22_:12  C=5.266E-16
** [instance C423 of CAPACITOR, params={'capacitance': 0.000162444 prefix:SIUnitPrefix.PICO} connections=['A: [connection C423/A =>[signal: _36_:S0 w=1]]', 'B: [connection C423/B =>[signal: hold37:A w=1]]']]
C423 _36_:S0 hold37:A  C=1.62444E-16
** [instance C424 of CAPACITOR, params={'capacitance': 0.000436241 prefix:SIUnitPrefix.PICO} connections=['A: [connection C424/A =>[signal: _36_:S0 w=1]]', 'B: [connection C424/B =>[signal: VSS w=1]]']]
C424 _36_:S0 VSS  C=4.3624100000000003E-16
** [instance C425 of CAPACITOR, params={'capacitance': 0.000409399 prefix:SIUnitPrefix.PICO} connections=['A: [connection C425/A =>[signal: _36_:S0 w=1]]', 'B: [connection C425/B =>[signal: _53_:A1 w=1]]']]
C425 _36_:S0 _53_:A1  C=4.09399E-16
** [instance C426 of CAPACITOR, params={'capacitance': 0.0 prefix:SIUnitPrefix.PICO} connections=['A: [connection C426/A =>[signal: _53_:A1 w=1]]', 'B: [connection C426/B =>[signal: _71_:D w=1]]']]
** C426 _53_:A1 _71_:D  C=0.0 [skipped because C=0]
** [instance C427 of CAPACITOR, params={'capacitance': 0.000199333 prefix:SIUnitPrefix.PICO} connections=['A: [connection C427/A =>[signal: _53_:A1 w=1]]', 'B: [connection C427/B =>[signal: hold37:A w=1]]']]
C427 _53_:A1 hold37:A  C=1.99333E-16
** [instance C428 of CAPACITOR, params={'capacitance': 0.00016833 prefix:SIUnitPrefix.PICO} connections=['A: [connection C428/A =>[signal: _53_:A1 w=1]]', 'B: [connection C428/B =>[signal: mem[6]:14 w=1]]']]
C428 _53_:A1 mem[6]:14  C=1.6833000000000002E-16
** [instance C429 of CAPACITOR, params={'capacitance': 1.07719e-05 prefix:SIUnitPrefix.PICO} connections=['A: [connection C429/A =>[signal: _53_:A1 w=1]]', 'B: [connection C429/B =>[signal: mem[8]:10 w=1]]']]
C429 _53_:A1 mem[8]:10  C=1.0771899999999999E-17
** [instance C430 of CAPACITOR, params={'capacitance': 0.000448039 prefix:SIUnitPrefix.PICO} connections=['A: [connection C430/A =>[signal: _53_:A1 w=1]]', 'B: [connection C430/B =>[signal: VSS w=1]]']]
C430 _53_:A1 VSS  C=4.48039E-16
** [instance C431 of CAPACITOR, params={'capacitance': 0.000302793 prefix:SIUnitPrefix.PICO} connections=['A: [connection C431/A =>[signal: _53_:A1 w=1]]', 'B: [connection C431/B =>[signal: net36:14 w=1]]']]
C431 _53_:A1 net36:14  C=3.02793E-16
** [instance C432 of CAPACITOR, params={'capacitance': 0.000263695 prefix:SIUnitPrefix.PICO} connections=['A: [connection C432/A =>[signal: _54_:X w=1]]', 'B: [connection C432/B =>[signal: VSS w=1]]']]
C432 _54_:X VSS  C=2.63695E-16
** [instance C433 of CAPACITOR, params={'capacitance': 9.25014e-06 prefix:SIUnitPrefix.PICO} connections=['A: [connection C433/A =>[signal: _72_:CLK w=1]]', 'B: [connection C433/B =>[signal: _72_:D w=1]]']]
C433 _72_:CLK _72_:D  C=9.250139999999999E-18
** [instance C434 of CAPACITOR, params={'capacitance': 0.0 prefix:SIUnitPrefix.PICO} connections=['A: [connection C434/A =>[signal: _72_:CLK w=1]]', 'B: [connection C434/B =>[signal: _73_:D w=1]]']]
** C434 _72_:CLK _73_:D  C=0.0 [skipped because C=0]
** [instance C435 of CAPACITOR, params={'capacitance': 0.000106736 prefix:SIUnitPrefix.PICO} connections=['A: [connection C435/A =>[signal: _72_:CLK w=1]]', 'B: [connection C435/B =>[signal: VSS w=1]]']]
C435 _72_:CLK VSS  C=1.06736E-16
** [instance C436 of CAPACITOR, params={'capacitance': 0.000170241 prefix:SIUnitPrefix.PICO} connections=['A: [connection C436/A =>[signal: _72_:CLK w=1]]', 'B: [connection C436/B =>[signal: net13:35 w=1]]']]
C436 _72_:CLK net13:35  C=1.70241E-16
** [instance C437 of CAPACITOR, params={'capacitance': 0.000278879 prefix:SIUnitPrefix.PICO} connections=['A: [connection C437/A =>[signal: _55_:X w=1]]', 'B: [connection C437/B =>[signal: VSS w=1]]']]
C437 _55_:X VSS  C=2.78879E-16
** [instance C438 of CAPACITOR, params={'capacitance': 3.47641e-06 prefix:SIUnitPrefix.PICO} connections=['A: [connection C438/A =>[signal: _34_:B1 w=1]]', 'B: [connection C438/B =>[signal: _73_:D w=1]]']]
C438 _34_:B1 _73_:D  C=3.47641E-18
** [instance C439 of CAPACITOR, params={'capacitance': 3.67252e-05 prefix:SIUnitPrefix.PICO} connections=['A: [connection C439/A =>[signal: _34_:B1 w=1]]', 'B: [connection C439/B =>[signal: _23_:24 w=1]]']]
C439 _34_:B1 _23_:24  C=3.6725199999999996E-17
** [instance C440 of CAPACITOR, params={'capacitance': 0.000170654 prefix:SIUnitPrefix.PICO} connections=['A: [connection C440/A =>[signal: _34_:B1 w=1]]', 'B: [connection C440/B =>[signal: _37_:A0 w=1]]']]
C440 _34_:B1 _37_:A0  C=1.7065400000000002E-16
** [instance C441 of CAPACITOR, params={'capacitance': 9.95963e-05 prefix:SIUnitPrefix.PICO} connections=['A: [connection C441/A =>[signal: _34_:B1 w=1]]', 'B: [connection C441/B =>[signal: clknet_0_scan_clk:49 w=1]]']]
C441 _34_:B1 clknet_0_scan_clk:49  C=9.95963E-17
** [instance C442 of CAPACITOR, params={'capacitance': 5.33005e-05 prefix:SIUnitPrefix.PICO} connections=['A: [connection C442/A =>[signal: _34_:B1 w=1]]', 'B: [connection C442/B =>[signal: _73_:CLK w=1]]']]
C442 _34_:B1 _73_:CLK  C=5.33005E-17
** [instance C443 of CAPACITOR, params={'capacitance': 6.28121e-05 prefix:SIUnitPrefix.PICO} connections=['A: [connection C443/A =>[signal: _34_:B1 w=1]]', 'B: [connection C443/B =>[signal: mem[3]:23 w=1]]']]
C443 _34_:B1 mem[3]:23  C=6.28121E-17
** [instance C444 of CAPACITOR, params={'capacitance': 0.000300227 prefix:SIUnitPrefix.PICO} connections=['A: [connection C444/A =>[signal: _34_:B1 w=1]]', 'B: [connection C444/B =>[signal: mem[3]:40 w=1]]']]
C444 _34_:B1 mem[3]:40  C=3.00227E-16
** [instance C445 of CAPACITOR, params={'capacitance': 0.000175251 prefix:SIUnitPrefix.PICO} connections=['A: [connection C445/A =>[signal: _34_:B1 w=1]]', 'B: [connection C445/B =>[signal: net12:57 w=1]]']]
C445 _34_:B1 net12:57  C=1.7525099999999998E-16
** [instance C446 of CAPACITOR, params={'capacitance': 0.0 prefix:SIUnitPrefix.PICO} connections=['A: [connection C446/A =>[signal: _34_:B1 w=1]]', 'B: [connection C446/B =>[signal: net12:65 w=1]]']]
** C446 _34_:B1 net12:65  C=0.0 [skipped because C=0]
** [instance C447 of CAPACITOR, params={'capacitance': 9.60939e-05 prefix:SIUnitPrefix.PICO} connections=['A: [connection C447/A =>[signal: _34_:B1 w=1]]', 'B: [connection C447/B =>[signal: net12:103 w=1]]']]
C447 _34_:B1 net12:103  C=9.60939E-17
** [instance C448 of CAPACITOR, params={'capacitance': 5.33005e-05 prefix:SIUnitPrefix.PICO} connections=['A: [connection C448/A =>[signal: _34_:B1 w=1]]', 'B: [connection C448/B =>[signal: _43_:S w=1]]']]
C448 _34_:B1 _43_:S  C=5.33005E-17
** [instance C449 of CAPACITOR, params={'capacitance': 3.14003e-05 prefix:SIUnitPrefix.PICO} connections=['A: [connection C449/A =>[signal: _34_:B1 w=1]]', 'B: [connection C449/B =>[signal: net13:14 w=1]]']]
C449 _34_:B1 net13:14  C=3.14003E-17
** [instance C450 of CAPACITOR, params={'capacitance': 0.000137639 prefix:SIUnitPrefix.PICO} connections=['A: [connection C450/A =>[signal: _34_:B1 w=1]]', 'B: [connection C450/B =>[signal: net13:23 w=1]]']]
C450 _34_:B1 net13:23  C=1.3763899999999999E-16
** [instance C451 of CAPACITOR, params={'capacitance': 0.0 prefix:SIUnitPrefix.PICO} connections=['A: [connection C451/A =>[signal: _34_:B1 w=1]]', 'B: [connection C451/B =>[signal: net13:35 w=1]]']]
** C451 _34_:B1 net13:35  C=0.0 [skipped because C=0]
** [instance C452 of CAPACITOR, params={'capacitance': 0.000388036 prefix:SIUnitPrefix.PICO} connections=['A: [connection C452/A =>[signal: _34_:B1 w=1]]', 'B: [connection C452/B =>[signal: _42_:A0 w=1]]']]
C452 _34_:B1 _42_:A0  C=3.88036E-16
** [instance C453 of CAPACITOR, params={'capacitance': 0.000885584 prefix:SIUnitPrefix.PICO} connections=['A: [connection C453/A =>[signal: _34_:B1 w=1]]', 'B: [connection C453/B =>[signal: VSS w=1]]']]
C453 _34_:B1 VSS  C=8.855840000000001E-16
** [instance C454 of CAPACITOR, params={'capacitance': 1.64343e-05 prefix:SIUnitPrefix.PICO} connections=['A: [connection C454/A =>[signal: _73_:CLK w=1]]', 'B: [connection C454/B =>[signal: _73_:D w=1]]']]
C454 _73_:CLK _73_:D  C=1.64343E-17
** [instance C455 of CAPACITOR, params={'capacitance': 9.58251e-05 prefix:SIUnitPrefix.PICO} connections=['A: [connection C455/A =>[signal: _73_:CLK w=1]]', 'B: [connection C455/B =>[signal: VSS w=1]]']]
C455 _73_:CLK VSS  C=9.58251E-17
** [instance C456 of CAPACITOR, params={'capacitance': 0.000155522 prefix:SIUnitPrefix.PICO} connections=['A: [connection C456/A =>[signal: _73_:CLK w=1]]', 'B: [connection C456/B =>[signal: net12:103 w=1]]']]
C456 _73_:CLK net12:103  C=1.55522E-16
** [instance C457 of CAPACITOR, params={'capacitance': 0.000600984 prefix:SIUnitPrefix.PICO} connections=['A: [connection C457/A =>[signal: _56_:X w=1]]', 'B: [connection C457/B =>[signal: VSS w=1]]']]
C457 _56_:X VSS  C=6.00984E-16
** [instance C458 of CAPACITOR, params={'capacitance': 6.43196e-05 prefix:SIUnitPrefix.PICO} connections=['A: [connection C458/A =>[signal: _39_:S w=1]]', 'B: [connection C458/B =>[signal: _74_:D w=1]]']]
C458 _39_:S _74_:D  C=6.43196E-17
** [instance C459 of CAPACITOR, params={'capacitance': 8.22661e-06 prefix:SIUnitPrefix.PICO} connections=['A: [connection C459/A =>[signal: _39_:S w=1]]', 'B: [connection C459/B =>[signal: net3:12 w=1]]']]
C459 _39_:S net3:12  C=8.22661E-18
** [instance C460 of CAPACITOR, params={'capacitance': 0.00022266 prefix:SIUnitPrefix.PICO} connections=['A: [connection C460/A =>[signal: _39_:S w=1]]', 'B: [connection C460/B =>[signal: net3:33 w=1]]']]
C460 _39_:S net3:33  C=2.2266E-16
** [instance C461 of CAPACITOR, params={'capacitance': 2.14757e-05 prefix:SIUnitPrefix.PICO} connections=['A: [connection C461/A =>[signal: _39_:S w=1]]', 'B: [connection C461/B =>[signal: _56_:A0 w=1]]']]
C461 _39_:S _56_:A0  C=2.1475699999999997E-17
** [instance C462 of CAPACITOR, params={'capacitance': 1.99271e-05 prefix:SIUnitPrefix.PICO} connections=['A: [connection C462/A =>[signal: _39_:S w=1]]', 'B: [connection C462/B =>[signal: _50_:A1 w=1]]']]
C462 _39_:S _50_:A1  C=1.99271E-17
** [instance C463 of CAPACITOR, params={'capacitance': 0.000122284 prefix:SIUnitPrefix.PICO} connections=['A: [connection C463/A =>[signal: _39_:S w=1]]', 'B: [connection C463/B =>[signal: net37:14 w=1]]']]
C463 _39_:S net37:14  C=1.22284E-16
** [instance C464 of CAPACITOR, params={'capacitance': 0.000513594 prefix:SIUnitPrefix.PICO} connections=['A: [connection C464/A =>[signal: _39_:S w=1]]', 'B: [connection C464/B =>[signal: VSS w=1]]']]
C464 _39_:S VSS  C=5.13594E-16
** [instance C465 of CAPACITOR, params={'capacitance': 0.000165664 prefix:SIUnitPrefix.PICO} connections=['A: [connection C465/A =>[signal: hold25:A w=1]]', 'B: [connection C465/B =>[signal: VSS w=1]]']]
C465 hold25:A VSS  C=1.6566399999999998E-16
** [instance C466 of CAPACITOR, params={'capacitance': 6.34085e-05 prefix:SIUnitPrefix.PICO} connections=['A: [connection C466/A =>[signal: hold25:A w=1]]', 'B: [connection C466/B =>[signal: net37:14 w=1]]']]
C466 hold25:A net37:14  C=6.340849999999999E-17
** [instance C467 of CAPACITOR, params={'capacitance': 0.000165664 prefix:SIUnitPrefix.PICO} connections=['A: [connection C467/A =>[signal: _57_:X w=1]]', 'B: [connection C467/B =>[signal: VSS w=1]]']]
C467 _57_:X VSS  C=1.6566399999999998E-16
** [instance C468 of CAPACITOR, params={'capacitance': 4.53889e-05 prefix:SIUnitPrefix.PICO} connections=['A: [connection C468/A =>[signal: _57_:S w=1]]', 'B: [connection C468/B =>[signal: hold25:A w=1]]']]
C468 _57_:S hold25:A  C=4.5388900000000004E-17
** [instance C469 of CAPACITOR, params={'capacitance': 3.23658e-05 prefix:SIUnitPrefix.PICO} connections=['A: [connection C469/A =>[signal: _57_:S w=1]]', 'B: [connection C469/B =>[signal: clknet_1_1__leaf_scan_clk:29 w=1]]']]
C469 _57_:S clknet_1_1__leaf_scan_clk:29  C=3.23658E-17
** [instance C470 of CAPACITOR, params={'capacitance': 0.0 prefix:SIUnitPrefix.PICO} connections=['A: [connection C470/A =>[signal: _57_:S w=1]]', 'B: [connection C470/B =>[signal: hold24:A w=1]]']]
** C470 _57_:S hold24:A  C=0.0 [skipped because C=0]
** [instance C471 of CAPACITOR, params={'capacitance': 5.7903e-06 prefix:SIUnitPrefix.PICO} connections=['A: [connection C471/A =>[signal: _57_:S w=1]]', 'B: [connection C471/B =>[signal: mem[1]:8 w=1]]']]
C471 _57_:S mem[1]:8  C=5.7903E-18
** [instance C472 of CAPACITOR, params={'capacitance': 0.000294969 prefix:SIUnitPrefix.PICO} connections=['A: [connection C472/A =>[signal: _57_:S w=1]]', 'B: [connection C472/B =>[signal: VSS w=1]]']]
C472 _57_:S VSS  C=2.94969E-16
** [instance C473 of CAPACITOR, params={'capacitance': 0.000268403 prefix:SIUnitPrefix.PICO} connections=['A: [connection C473/A =>[signal: _57_:S w=1]]', 'B: [connection C473/B =>[signal: net33:8 w=1]]']]
C473 _57_:S net33:8  C=2.68403E-16
** [instance C474 of CAPACITOR, params={'capacitance': 0.000379195 prefix:SIUnitPrefix.PICO} connections=['A: [connection C474/A =>[signal: _57_:S w=1]]', 'B: [connection C474/B =>[signal: net37:14 w=1]]']]
C474 _57_:S net37:14  C=3.79195E-16
** [instance C475 of CAPACITOR, params={'capacitance': 0.000111463 prefix:SIUnitPrefix.PICO} connections=['A: [connection C475/A =>[signal: _76_:D w=1]]', 'B: [connection C475/B =>[signal: VSS w=1]]']]
C475 _76_:D VSS  C=1.11463E-16
** [instance C476 of CAPACITOR, params={'capacitance': 0.000288471 prefix:SIUnitPrefix.PICO} connections=['A: [connection C476/A =>[signal: _76_:D w=1]]', 'B: [connection C476/B =>[signal: _77_:CLK w=1]]']]
C476 _76_:D _77_:CLK  C=2.88471E-16
** [instance C477 of CAPACITOR, params={'capacitance': 8.74024e-05 prefix:SIUnitPrefix.PICO} connections=['A: [connection C477/A =>[signal: _76_:D w=1]]', 'B: [connection C477/B =>[signal: net4:18 w=1]]']]
C477 _76_:D net4:18  C=8.74024E-17
** [instance C478 of CAPACITOR, params={'capacitance': 0.000111463 prefix:SIUnitPrefix.PICO} connections=['A: [connection C478/A =>[signal: _58_:X w=1]]', 'B: [connection C478/B =>[signal: VSS w=1]]']]
C478 _58_:X VSS  C=1.11463E-16
** [instance C479 of CAPACITOR, params={'capacitance': 0.000757964 prefix:SIUnitPrefix.PICO} connections=['A: [connection C479/A =>[signal: _34_:A1 w=1]]', 'B: [connection C479/B =>[signal: VSS w=1]]']]
C479 _34_:A1 VSS  C=7.57964E-16
** [instance C480 of CAPACITOR, params={'capacitance': 6.45791e-05 prefix:SIUnitPrefix.PICO} connections=['A: [connection C480/A =>[signal: _34_:A1 w=1]]', 'B: [connection C480/B =>[signal: _34_:B1 w=1]]']]
C480 _34_:A1 _34_:B1  C=6.45791E-17
** [instance C481 of CAPACITOR, params={'capacitance': 1.08359e-05 prefix:SIUnitPrefix.PICO} connections=['A: [connection C481/A =>[signal: _34_:A1 w=1]]', 'B: [connection C481/B =>[signal: _37_:A0 w=1]]']]
C481 _34_:A1 _37_:A0  C=1.0835900000000001E-17
** [instance C482 of CAPACITOR, params={'capacitance': 5.23735e-05 prefix:SIUnitPrefix.PICO} connections=['A: [connection C482/A =>[signal: _34_:A1 w=1]]', 'B: [connection C482/B =>[signal: _50_:A1 w=1]]']]
C482 _34_:A1 _50_:A1  C=5.23735E-17
** [instance C483 of CAPACITOR, params={'capacitance': 1.39867e-05 prefix:SIUnitPrefix.PICO} connections=['A: [connection C483/A =>[signal: _34_:A1 w=1]]', 'B: [connection C483/B =>[signal: _51_:A0 w=1]]']]
C483 _34_:A1 _51_:A0  C=1.39867E-17
** [instance C484 of CAPACITOR, params={'capacitance': 0.000127339 prefix:SIUnitPrefix.PICO} connections=['A: [connection C484/A =>[signal: _34_:A1 w=1]]', 'B: [connection C484/B =>[signal: _73_:CLK w=1]]']]
C484 _34_:A1 _73_:CLK  C=1.27339E-16
** [instance C485 of CAPACITOR, params={'capacitance': 0.000304438 prefix:SIUnitPrefix.PICO} connections=['A: [connection C485/A =>[signal: _34_:A1 w=1]]', 'B: [connection C485/B =>[signal: mem[3]:40 w=1]]']]
C485 _34_:A1 mem[3]:40  C=3.04438E-16
** [instance C486 of CAPACITOR, params={'capacitance': 0.0 prefix:SIUnitPrefix.PICO} connections=['A: [connection C486/A =>[signal: _34_:A1 w=1]]', 'B: [connection C486/B =>[signal: net12:57 w=1]]']]
** C486 _34_:A1 net12:57  C=0.0 [skipped because C=0]
** [instance C487 of CAPACITOR, params={'capacitance': 6.33743e-05 prefix:SIUnitPrefix.PICO} connections=['A: [connection C487/A =>[signal: _34_:A1 w=1]]', 'B: [connection C487/B =>[signal: net13:31 w=1]]']]
C487 _34_:A1 net13:31  C=6.33743E-17
** [instance C488 of CAPACITOR, params={'capacitance': 0.000155149 prefix:SIUnitPrefix.PICO} connections=['A: [connection C488/A =>[signal: _34_:A1 w=1]]', 'B: [connection C488/B =>[signal: net13:35 w=1]]']]
C488 _34_:A1 net13:35  C=1.5514899999999997E-16
** [instance C489 of CAPACITOR, params={'capacitance': 0.000757964 prefix:SIUnitPrefix.PICO} connections=['A: [connection C489/A =>[signal: _29_:Y w=1]]', 'B: [connection C489/B =>[signal: VSS w=1]]']]
C489 _29_:Y VSS  C=7.57964E-16
** [instance C490 of CAPACITOR, params={'capacitance': 0.000350455 prefix:SIUnitPrefix.PICO} connections=['A: [connection C490/A =>[signal: _38_:B2 w=1]]', 'B: [connection C490/B =>[signal: VSS w=1]]']]
C490 _38_:B2 VSS  C=3.50455E-16
** [instance C491 of CAPACITOR, params={'capacitance': 0.000221065 prefix:SIUnitPrefix.PICO} connections=['A: [connection C491/A =>[signal: _38_:B2 w=1]]', 'B: [connection C491/B =>[signal: _42_:A0 w=1]]']]
C491 _38_:B2 _42_:A0  C=2.21065E-16
** [instance C492 of CAPACITOR, params={'capacitance': 0.000107686 prefix:SIUnitPrefix.PICO} connections=['A: [connection C492/A =>[signal: _38_:B2 w=1]]', 'B: [connection C492/B =>[signal: _42_:A1 w=1]]']]
C492 _38_:B2 _42_:A1  C=1.07686E-16
** [instance C493 of CAPACITOR, params={'capacitance': 0.000402788 prefix:SIUnitPrefix.PICO} connections=['A: [connection C493/A =>[signal: _38_:B2 w=1]]', 'B: [connection C493/B =>[signal: hold16:A w=1]]']]
C493 _38_:B2 hold16:A  C=4.02788E-16
** [instance C494 of CAPACITOR, params={'capacitance': 0.00012501 prefix:SIUnitPrefix.PICO} connections=['A: [connection C494/A =>[signal: _38_:B2 w=1]]', 'B: [connection C494/B =>[signal: hold20:A w=1]]']]
C494 _38_:B2 hold20:A  C=1.2500999999999998E-16
** [instance C495 of CAPACITOR, params={'capacitance': 0.000284501 prefix:SIUnitPrefix.PICO} connections=['A: [connection C495/A =>[signal: _38_:B2 w=1]]', 'B: [connection C495/B =>[signal: mem[13]:8 w=1]]']]
C495 _38_:B2 mem[13]:8  C=2.84501E-16
** [instance C496 of CAPACITOR, params={'capacitance': 9.8126e-05 prefix:SIUnitPrefix.PICO} connections=['A: [connection C496/A =>[signal: _38_:B2 w=1]]', 'B: [connection C496/B =>[signal: mem[14]:10 w=1]]']]
C496 _38_:B2 mem[14]:10  C=9.8126E-17
** [instance C497 of CAPACITOR, params={'capacitance': 0.000350455 prefix:SIUnitPrefix.PICO} connections=['A: [connection C497/A =>[signal: _30_:Y w=1]]', 'B: [connection C497/B =>[signal: VSS w=1]]']]
C497 _30_:Y VSS  C=3.50455E-16
** [instance C498 of CAPACITOR, params={'capacitance': 0.000587672 prefix:SIUnitPrefix.PICO} connections=['A: [connection C498/A =>[signal: _31_:X w=1]]', 'B: [connection C498/B =>[signal: VSS w=1]]']]
C498 _31_:X VSS  C=5.87672E-16
** [instance C499 of CAPACITOR, params={'capacitance': 0.000479522 prefix:SIUnitPrefix.PICO} connections=['A: [connection C499/A =>[signal: _32_:X w=1]]', 'B: [connection C499/B =>[signal: VSS w=1]]']]
C499 _32_:X VSS  C=4.79522E-16
** [instance C500 of CAPACITOR, params={'capacitance': 0.00181401 prefix:SIUnitPrefix.PICO} connections=['A: [connection C500/A =>[signal: _22_:12 w=1]]', 'B: [connection C500/B =>[signal: VSS w=1]]']]
C500 _22_:12 VSS  C=1.81401E-15
** [instance C501 of CAPACITOR, params={'capacitance': 0.00104951 prefix:SIUnitPrefix.PICO} connections=['A: [connection C501/A =>[signal: _22_:12 w=1]]', 'B: [connection C501/B =>[signal: mem[5]:26 w=1]]']]
C501 _22_:12 mem[5]:26  C=1.04951E-15
** [instance C502 of CAPACITOR, params={'capacitance': 0.000139907 prefix:SIUnitPrefix.PICO} connections=['A: [connection C502/A =>[signal: _22_:12 w=1]]', 'B: [connection C502/B =>[signal: mem[9]:10 w=1]]']]
C502 _22_:12 mem[9]:10  C=1.3990699999999999E-16
** [instance C503 of CAPACITOR, params={'capacitance': 0.00033777 prefix:SIUnitPrefix.PICO} connections=['A: [connection C503/A =>[signal: _22_:12 w=1]]', 'B: [connection C503/B =>[signal: net1:10 w=1]]']]
C503 _22_:12 net1:10  C=3.3776999999999996E-16
** [instance C504 of CAPACITOR, params={'capacitance': 0.0 prefix:SIUnitPrefix.PICO} connections=['A: [connection C504/A =>[signal: _34_:A2 w=1]]', 'B: [connection C504/B =>[signal: VSS w=1]]']]
** C504 _34_:A2 VSS  C=0.0 [skipped because C=0]
** [instance C505 of CAPACITOR, params={'capacitance': 0.000790061 prefix:SIUnitPrefix.PICO} connections=['A: [connection C505/A =>[signal: _33_:X w=1]]', 'B: [connection C505/B =>[signal: VSS w=1]]']]
C505 _33_:X VSS  C=7.90061E-16
** [instance C506 of CAPACITOR, params={'capacitance': 0.000790061 prefix:SIUnitPrefix.PICO} connections=['A: [connection C506/A =>[signal: _23_:24 w=1]]', 'B: [connection C506/B =>[signal: VSS w=1]]']]
C506 _23_:24 VSS  C=7.90061E-16
** [instance C507 of CAPACITOR, params={'capacitance': 2.06112e-05 prefix:SIUnitPrefix.PICO} connections=['A: [connection C507/A =>[signal: _23_:24 w=1]]', 'B: [connection C507/B =>[signal: _24_:36 w=1]]']]
C507 _23_:24 _24_:36  C=2.06112E-17
** [instance C508 of CAPACITOR, params={'capacitance': 1.24368e-05 prefix:SIUnitPrefix.PICO} connections=['A: [connection C508/A =>[signal: _23_:24 w=1]]', 'B: [connection C508/B =>[signal: clknet_1_1__leaf_scan_clk:79 w=1]]']]
C508 _23_:24 clknet_1_1__leaf_scan_clk:79  C=1.2436799999999998E-17
** [instance C509 of CAPACITOR, params={'capacitance': 2.07809e-05 prefix:SIUnitPrefix.PICO} connections=['A: [connection C509/A =>[signal: _23_:24 w=1]]', 'B: [connection C509/B =>[signal: clknet_1_1__leaf_scan_clk:81 w=1]]']]
C509 _23_:24 clknet_1_1__leaf_scan_clk:81  C=2.07809E-17
** [instance C510 of CAPACITOR, params={'capacitance': 2.05595e-05 prefix:SIUnitPrefix.PICO} connections=['A: [connection C510/A =>[signal: _23_:24 w=1]]', 'B: [connection C510/B =>[signal: net12:57 w=1]]']]
C510 _23_:24 net12:57  C=2.05595E-17
** [instance C511 of CAPACITOR, params={'capacitance': 9.71756e-05 prefix:SIUnitPrefix.PICO} connections=['A: [connection C511/A =>[signal: _35_:A2 w=1]]', 'B: [connection C511/B =>[signal: _23_:24 w=1]]']]
C511 _35_:A2 _23_:24  C=9.71756E-17
** [instance C512 of CAPACITOR, params={'capacitance': 2.06112e-05 prefix:SIUnitPrefix.PICO} connections=['A: [connection C512/A =>[signal: _35_:A2 w=1]]', 'B: [connection C512/B =>[signal: _24_:36 w=1]]']]
C512 _35_:A2 _24_:36  C=2.06112E-17
** [instance C513 of CAPACITOR, params={'capacitance': 0.000172925 prefix:SIUnitPrefix.PICO} connections=['A: [connection C513/A =>[signal: _35_:A2 w=1]]', 'B: [connection C513/B =>[signal: VSS w=1]]']]
C513 _35_:A2 VSS  C=1.72925E-16
** [instance C514 of CAPACITOR, params={'capacitance': 0.0 prefix:SIUnitPrefix.PICO} connections=['A: [connection C514/A =>[signal: _35_:A2 w=1]]', 'B: [connection C514/B =>[signal: net12:65 w=1]]']]
** C514 _35_:A2 net12:65  C=0.0 [skipped because C=0]
** [instance C515 of CAPACITOR, params={'capacitance': 0.000154545 prefix:SIUnitPrefix.PICO} connections=['A: [connection C515/A =>[signal: _44_:S w=1]]', 'B: [connection C515/B =>[signal: _23_:24 w=1]]']]
C515 _44_:S _23_:24  C=1.5454499999999998E-16
** [instance C516 of CAPACITOR, params={'capacitance': 0.000139472 prefix:SIUnitPrefix.PICO} connections=['A: [connection C516/A =>[signal: _44_:S w=1]]', 'B: [connection C516/B =>[signal: clknet_0_scan_clk:33 w=1]]']]
C516 _44_:S clknet_0_scan_clk:33  C=1.3947199999999999E-16
** [instance C517 of CAPACITOR, params={'capacitance': 7.24888e-05 prefix:SIUnitPrefix.PICO} connections=['A: [connection C517/A =>[signal: _44_:S w=1]]', 'B: [connection C517/B =>[signal: _66_:CLK w=1]]']]
C517 _44_:S _66_:CLK  C=7.24888E-17
** [instance C518 of CAPACITOR, params={'capacitance': 0.000548057 prefix:SIUnitPrefix.PICO} connections=['A: [connection C518/A =>[signal: _44_:S w=1]]', 'B: [connection C518/B =>[signal: VSS w=1]]']]
C518 _44_:S VSS  C=5.48057E-16
** [instance C519 of CAPACITOR, params={'capacitance': 0.000264032 prefix:SIUnitPrefix.PICO} connections=['A: [connection C519/A =>[signal: _44_:S w=1]]', 'B: [connection C519/B =>[signal: _51_:A0 w=1]]']]
C519 _44_:S _51_:A0  C=2.6403199999999996E-16
** [instance C520 of CAPACITOR, params={'capacitance': 0.0 prefix:SIUnitPrefix.PICO} connections=['A: [connection C520/A =>[signal: _38_:A2 w=1]]', 'B: [connection C520/B =>[signal: VSS w=1]]']]
** C520 _38_:A2 VSS  C=0.0 [skipped because C=0]
** [instance C521 of CAPACITOR, params={'capacitance': 0.00249792 prefix:SIUnitPrefix.PICO} connections=['A: [connection C521/A =>[signal: _34_:X w=1]]', 'B: [connection C521/B =>[signal: VSS w=1]]']]
C521 _34_:X VSS  C=2.4979199999999998E-15
** [instance C522 of CAPACITOR, params={'capacitance': 0.00249792 prefix:SIUnitPrefix.PICO} connections=['A: [connection C522/A =>[signal: _24_:36 w=1]]', 'B: [connection C522/B =>[signal: VSS w=1]]']]
C522 _24_:36 VSS  C=2.4979199999999998E-15
** [instance C523 of CAPACITOR, params={'capacitance': 9.41642e-05 prefix:SIUnitPrefix.PICO} connections=['A: [connection C523/A =>[signal: _24_:36 w=1]]', 'B: [connection C523/B =>[signal: net13:10 w=1]]']]
C523 _24_:36 net13:10  C=9.416420000000001E-17
** [instance C524 of CAPACITOR, params={'capacitance': 5.22522e-05 prefix:SIUnitPrefix.PICO} connections=['A: [connection C524/A =>[signal: _33_:A1 w=1]]', 'B: [connection C524/B =>[signal: _24_:36 w=1]]']]
C524 _33_:A1 _24_:36  C=5.2252199999999997E-17
** [instance C525 of CAPACITOR, params={'capacitance': 1.12456e-05 prefix:SIUnitPrefix.PICO} connections=['A: [connection C525/A =>[signal: _33_:A1 w=1]]', 'B: [connection C525/B =>[signal: mem[12]:27 w=1]]']]
C525 _33_:A1 mem[12]:27  C=1.12456E-17
** [instance C526 of CAPACITOR, params={'capacitance': 0.000305281 prefix:SIUnitPrefix.PICO} connections=['A: [connection C526/A =>[signal: _33_:A1 w=1]]', 'B: [connection C526/B =>[signal: VSS w=1]]']]
C526 _33_:A1 VSS  C=3.05281E-16
** [instance C527 of CAPACITOR, params={'capacitance': 2.06112e-05 prefix:SIUnitPrefix.PICO} connections=['A: [connection C527/A =>[signal: _33_:A1 w=1]]', 'B: [connection C527/B =>[signal: _44_:A0 w=1]]']]
C527 _33_:A1 _44_:A0  C=2.06112E-17
** [instance C528 of CAPACITOR, params={'capacitance': 0.000283181 prefix:SIUnitPrefix.PICO} connections=['A: [connection C528/A =>[signal: _43_:A0 w=1]]', 'B: [connection C528/B =>[signal: _24_:36 w=1]]']]
C528 _43_:A0 _24_:36  C=2.83181E-16
** [instance C529 of CAPACITOR, params={'capacitance': 0.000162992 prefix:SIUnitPrefix.PICO} connections=['A: [connection C529/A =>[signal: _43_:A0 w=1]]', 'B: [connection C529/B =>[signal: _43_:A1 w=1]]']]
C529 _43_:A0 _43_:A1  C=1.6299199999999997E-16
** [instance C530 of CAPACITOR, params={'capacitance': 0.0 prefix:SIUnitPrefix.PICO} connections=['A: [connection C530/A =>[signal: _43_:A0 w=1]]', 'B: [connection C530/B =>[signal: mem[3]:40 w=1]]']]
** C530 _43_:A0 mem[3]:40  C=0.0 [skipped because C=0]
** [instance C531 of CAPACITOR, params={'capacitance': 1.62025e-05 prefix:SIUnitPrefix.PICO} connections=['A: [connection C531/A =>[signal: _43_:A0 w=1]]', 'B: [connection C531/B =>[signal: _43_:S w=1]]']]
C531 _43_:A0 _43_:S  C=1.62025E-17
** [instance C532 of CAPACITOR, params={'capacitance': 5.38886e-05 prefix:SIUnitPrefix.PICO} connections=['A: [connection C532/A =>[signal: _43_:A0 w=1]]', 'B: [connection C532/B =>[signal: net13:10 w=1]]']]
C532 _43_:A0 net13:10  C=5.38886E-17
** [instance C533 of CAPACITOR, params={'capacitance': 7.7633e-05 prefix:SIUnitPrefix.PICO} connections=['A: [connection C533/A =>[signal: _43_:A0 w=1]]', 'B: [connection C533/B =>[signal: net13:14 w=1]]']]
C533 _43_:A0 net13:14  C=7.763299999999999E-17
** [instance C534 of CAPACITOR, params={'capacitance': 5.49489e-05 prefix:SIUnitPrefix.PICO} connections=['A: [connection C534/A =>[signal: _43_:A0 w=1]]', 'B: [connection C534/B =>[signal: _60_:D w=1]]']]
C534 _43_:A0 _60_:D  C=5.49489E-17
** [instance C535 of CAPACITOR, params={'capacitance': 0.000495322 prefix:SIUnitPrefix.PICO} connections=['A: [connection C535/A =>[signal: _43_:A0 w=1]]', 'B: [connection C535/B =>[signal: VSS w=1]]']]
C535 _43_:A0 VSS  C=4.95322E-16
** [instance C536 of CAPACITOR, params={'capacitance': 0.000147624 prefix:SIUnitPrefix.PICO} connections=['A: [connection C536/A =>[signal: _43_:A0 w=1]]', 'B: [connection C536/B =>[signal: _44_:A0 w=1]]']]
C536 _43_:A0 _44_:A0  C=1.4762400000000002E-16
** [instance C537 of CAPACITOR, params={'capacitance': 2.98296e-05 prefix:SIUnitPrefix.PICO} connections=['A: [connection C537/A =>[signal: hold33:A w=1]]', 'B: [connection C537/B =>[signal: _24_:36 w=1]]']]
C537 hold33:A _24_:36  C=2.98296E-17
** [instance C538 of CAPACITOR, params={'capacitance': 0.00148711 prefix:SIUnitPrefix.PICO} connections=['A: [connection C538/A =>[signal: hold33:A w=1]]', 'B: [connection C538/B =>[signal: VSS w=1]]']]
C538 hold33:A VSS  C=1.48711E-15
** [instance C539 of CAPACITOR, params={'capacitance': 0.000413769 prefix:SIUnitPrefix.PICO} connections=['A: [connection C539/A =>[signal: _37_:A0 w=1]]', 'B: [connection C539/B =>[signal: VSS w=1]]']]
C539 _37_:A0 VSS  C=4.1376899999999995E-16
** [instance C540 of CAPACITOR, params={'capacitance': 0.000267973 prefix:SIUnitPrefix.PICO} connections=['A: [connection C540/A =>[signal: _37_:A0 w=1]]', 'B: [connection C540/B =>[signal: _51_:A1 w=1]]']]
C540 _37_:A0 _51_:A1  C=2.67973E-16
** [instance C541 of CAPACITOR, params={'capacitance': 1.24368e-05 prefix:SIUnitPrefix.PICO} connections=['A: [connection C541/A =>[signal: _37_:A0 w=1]]', 'B: [connection C541/B =>[signal: _56_:S w=1]]']]
C541 _37_:A0 _56_:S  C=1.2436799999999998E-17
** [instance C542 of CAPACITOR, params={'capacitance': 0.000199268 prefix:SIUnitPrefix.PICO} connections=['A: [connection C542/A =>[signal: _37_:A0 w=1]]', 'B: [connection C542/B =>[signal: mem[3]:40 w=1]]']]
C542 _37_:A0 mem[3]:40  C=1.99268E-16
** [instance C543 of CAPACITOR, params={'capacitance': 0.000197117 prefix:SIUnitPrefix.PICO} connections=['A: [connection C543/A =>[signal: _37_:A0 w=1]]', 'B: [connection C543/B =>[signal: net3:33 w=1]]']]
C543 _37_:A0 net3:33  C=1.9711699999999998E-16
** [instance C544 of CAPACITOR, params={'capacitance': 0.000413769 prefix:SIUnitPrefix.PICO} connections=['A: [connection C544/A =>[signal: _35_:X w=1]]', 'B: [connection C544/B =>[signal: VSS w=1]]']]
C544 _35_:X VSS  C=4.1376899999999995E-16
** [instance C545 of CAPACITOR, params={'capacitance': 2.14658e-05 prefix:SIUnitPrefix.PICO} connections=['A: [connection C545/A =>[signal: _35_:A1 w=1]]', 'B: [connection C545/B =>[signal: _37_:A0 w=1]]']]
C545 _35_:A1 _37_:A0  C=2.14658E-17
** [instance C546 of CAPACITOR, params={'capacitance': 3.79104e-05 prefix:SIUnitPrefix.PICO} connections=['A: [connection C546/A =>[signal: _35_:A1 w=1]]', 'B: [connection C546/B =>[signal: clknet_1_1__leaf_scan_clk:23 w=1]]']]
C546 _35_:A1 clknet_1_1__leaf_scan_clk:23  C=3.7910400000000004E-17
** [instance C547 of CAPACITOR, params={'capacitance': 5.10375e-05 prefix:SIUnitPrefix.PICO} connections=['A: [connection C547/A =>[signal: _35_:A1 w=1]]', 'B: [connection C547/B =>[signal: clknet_1_1__leaf_scan_clk:29 w=1]]']]
C547 _35_:A1 clknet_1_1__leaf_scan_clk:29  C=5.10375E-17
** [instance C548 of CAPACITOR, params={'capacitance': 0.000208367 prefix:SIUnitPrefix.PICO} connections=['A: [connection C548/A =>[signal: _35_:A1 w=1]]', 'B: [connection C548/B =>[signal: hold24:A w=1]]']]
C548 _35_:A1 hold24:A  C=2.08367E-16
** [instance C549 of CAPACITOR, params={'capacitance': 0.00041352 prefix:SIUnitPrefix.PICO} connections=['A: [connection C549/A =>[signal: _35_:A1 w=1]]', 'B: [connection C549/B =>[signal: VSS w=1]]']]
C549 _35_:A1 VSS  C=4.1352E-16
** [instance C550 of CAPACITOR, params={'capacitance': 5.41054e-05 prefix:SIUnitPrefix.PICO} connections=['A: [connection C550/A =>[signal: _35_:A1 w=1]]', 'B: [connection C550/B =>[signal: _51_:A1 w=1]]']]
C550 _35_:A1 _51_:A1  C=5.4105399999999996E-17
** [instance C551 of CAPACITOR, params={'capacitance': 0.0 prefix:SIUnitPrefix.PICO} connections=['A: [connection C551/A =>[signal: _35_:A1 w=1]]', 'B: [connection C551/B =>[signal: _57_:S w=1]]']]
** C551 _35_:A1 _57_:S  C=0.0 [skipped because C=0]
** [instance C552 of CAPACITOR, params={'capacitance': 0.000224577 prefix:SIUnitPrefix.PICO} connections=['A: [connection C552/A =>[signal: _35_:A1 w=1]]', 'B: [connection C552/B =>[signal: mem[3]:40 w=1]]']]
C552 _35_:A1 mem[3]:40  C=2.24577E-16
** [instance C553 of CAPACITOR, params={'capacitance': 4.64259e-05 prefix:SIUnitPrefix.PICO} connections=['A: [connection C553/A =>[signal: _36_:X w=1]]', 'B: [connection C553/B =>[signal: VSS w=1]]']]
C553 _36_:X VSS  C=4.6425899999999996E-17
** [instance C554 of CAPACITOR, params={'capacitance': 0.000861278 prefix:SIUnitPrefix.PICO} connections=['A: [connection C554/A =>[signal: _37_:X w=1]]', 'B: [connection C554/B =>[signal: VSS w=1]]']]
C554 _37_:X VSS  C=8.61278E-16
** [instance C555 of CAPACITOR, params={'capacitance': 0.000341323 prefix:SIUnitPrefix.PICO} connections=['A: [connection C555/A =>[signal: _40_:A0 w=1]]', 'B: [connection C555/B =>[signal: VSS w=1]]']]
C555 _40_:A0 VSS  C=3.41323E-16
** [instance C556 of CAPACITOR, params={'capacitance': 5.50052e-05 prefix:SIUnitPrefix.PICO} connections=['A: [connection C556/A =>[signal: _40_:A0 w=1]]', 'B: [connection C556/B =>[signal: _40_:A1 w=1]]']]
C556 _40_:A0 _40_:A1  C=5.50052E-17
** [instance C557 of CAPACITOR, params={'capacitance': 2.11336e-05 prefix:SIUnitPrefix.PICO} connections=['A: [connection C557/A =>[signal: _40_:A0 w=1]]', 'B: [connection C557/B =>[signal: hold22:A w=1]]']]
C557 _40_:A0 hold22:A  C=2.11336E-17
** [instance C558 of CAPACITOR, params={'capacitance': 3.4689e-05 prefix:SIUnitPrefix.PICO} connections=['A: [connection C558/A =>[signal: _40_:A0 w=1]]', 'B: [connection C558/B =>[signal: output9:A w=1]]']]
C558 _40_:A0 output9:A  C=3.4689E-17
** [instance C559 of CAPACITOR, params={'capacitance': 9.58632e-05 prefix:SIUnitPrefix.PICO} connections=['A: [connection C559/A =>[signal: _40_:A0 w=1]]', 'B: [connection C559/B =>[signal: clknet_1_1__leaf_scan_clk:75 w=1]]']]
C559 _40_:A0 clknet_1_1__leaf_scan_clk:75  C=9.58632E-17
** [instance C560 of CAPACITOR, params={'capacitance': 0.000452137 prefix:SIUnitPrefix.PICO} connections=['A: [connection C560/A =>[signal: _39_:A0 w=1]]', 'B: [connection C560/B =>[signal: VSS w=1]]']]
C560 _39_:A0 VSS  C=4.52137E-16
** [instance C561 of CAPACITOR, params={'capacitance': 5.92441e-05 prefix:SIUnitPrefix.PICO} connections=['A: [connection C561/A =>[signal: _39_:A0 w=1]]', 'B: [connection C561/B =>[signal: _42_:A0 w=1]]']]
C561 _39_:A0 _42_:A0  C=5.924409999999999E-17
** [instance C562 of CAPACITOR, params={'capacitance': 4.46186e-06 prefix:SIUnitPrefix.PICO} connections=['A: [connection C562/A =>[signal: _39_:A0 w=1]]', 'B: [connection C562/B =>[signal: _51_:A1 w=1]]']]
C562 _39_:A0 _51_:A1  C=4.46186E-18
** [instance C563 of CAPACITOR, params={'capacitance': 9.90431e-05 prefix:SIUnitPrefix.PICO} connections=['A: [connection C563/A =>[signal: _39_:A0 w=1]]', 'B: [connection C563/B =>[signal: _56_:A0 w=1]]']]
C563 _39_:A0 _56_:A0  C=9.90431E-17
** [instance C564 of CAPACITOR, params={'capacitance': 0.000703226 prefix:SIUnitPrefix.PICO} connections=['A: [connection C564/A =>[signal: _39_:A0 w=1]]', 'B: [connection C564/B =>[signal: _56_:A1 w=1]]']]
C564 _39_:A0 _56_:A1  C=7.03226E-16
** [instance C565 of CAPACITOR, params={'capacitance': 5.74242e-05 prefix:SIUnitPrefix.PICO} connections=['A: [connection C565/A =>[signal: _39_:A0 w=1]]', 'B: [connection C565/B =>[signal: _74_:CLK w=1]]']]
C565 _39_:A0 _74_:CLK  C=5.74242E-17
** [instance C566 of CAPACITOR, params={'capacitance': 2.03801e-05 prefix:SIUnitPrefix.PICO} connections=['A: [connection C566/A =>[signal: _39_:A0 w=1]]', 'B: [connection C566/B =>[signal: clknet_1_1__leaf_scan_clk:10 w=1]]']]
C566 _39_:A0 clknet_1_1__leaf_scan_clk:10  C=2.03801E-17
** [instance C567 of CAPACITOR, params={'capacitance': 8.04839e-05 prefix:SIUnitPrefix.PICO} connections=['A: [connection C567/A =>[signal: _39_:A0 w=1]]', 'B: [connection C567/B =>[signal: clknet_1_1__leaf_scan_clk:23 w=1]]']]
C567 _39_:A0 clknet_1_1__leaf_scan_clk:23  C=8.04839E-17
** [instance C568 of CAPACITOR, params={'capacitance': 8.77704e-05 prefix:SIUnitPrefix.PICO} connections=['A: [connection C568/A =>[signal: _39_:A0 w=1]]', 'B: [connection C568/B =>[signal: clknet_1_1__leaf_scan_clk:60 w=1]]']]
C568 _39_:A0 clknet_1_1__leaf_scan_clk:60  C=8.77704E-17
** [instance C569 of CAPACITOR, params={'capacitance': 3.61589e-06 prefix:SIUnitPrefix.PICO} connections=['A: [connection C569/A =>[signal: _39_:A0 w=1]]', 'B: [connection C569/B =>[signal: clknet_1_1__leaf_scan_clk:75 w=1]]']]
C569 _39_:A0 clknet_1_1__leaf_scan_clk:75  C=3.6158900000000004E-18
** [instance C570 of CAPACITOR, params={'capacitance': 0.000134849 prefix:SIUnitPrefix.PICO} connections=['A: [connection C570/A =>[signal: _38_:X w=1]]', 'B: [connection C570/B =>[signal: VSS w=1]]']]
C570 _38_:X VSS  C=1.34849E-16
** [instance C571 of CAPACITOR, params={'capacitance': 0.000928309 prefix:SIUnitPrefix.PICO} connections=['A: [connection C571/A =>[signal: _28_:8 w=1]]', 'B: [connection C571/B =>[signal: VSS w=1]]']]
C571 _28_:8 VSS  C=9.283089999999999E-16
** [instance C572 of CAPACITOR, params={'capacitance': 7.39637e-05 prefix:SIUnitPrefix.PICO} connections=['A: [connection C572/A =>[signal: _28_:8 w=1]]', 'B: [connection C572/B =>[signal: net16:10 w=1]]']]
C572 _28_:8 net16:10  C=7.39637E-17
** [instance C573 of CAPACITOR, params={'capacitance': 0.000144835 prefix:SIUnitPrefix.PICO} connections=['A: [connection C573/A =>[signal: _42_:A0 w=1]]', 'B: [connection C573/B =>[signal: _28_:8 w=1]]']]
C573 _42_:A0 _28_:8  C=1.44835E-16
** [instance C574 of CAPACITOR, params={'capacitance': 0.000144732 prefix:SIUnitPrefix.PICO} connections=['A: [connection C574/A =>[signal: _42_:A0 w=1]]', 'B: [connection C574/B =>[signal: clknet_1_1__leaf_scan_clk:75 w=1]]']]
C574 _42_:A0 clknet_1_1__leaf_scan_clk:75  C=1.44732E-16
** [instance C575 of CAPACITOR, params={'capacitance': 5.50052e-05 prefix:SIUnitPrefix.PICO} connections=['A: [connection C575/A =>[signal: _42_:A0 w=1]]', 'B: [connection C575/B =>[signal: _42_:A1 w=1]]']]
C575 _42_:A0 _42_:A1  C=5.50052E-17
** [instance C576 of CAPACITOR, params={'capacitance': 0.000348783 prefix:SIUnitPrefix.PICO} connections=['A: [connection C576/A =>[signal: _42_:A0 w=1]]', 'B: [connection C576/B =>[signal: VSS w=1]]']]
C576 _42_:A0 VSS  C=3.48783E-16
** [instance C577 of CAPACITOR, params={'capacitance': 0.000124359 prefix:SIUnitPrefix.PICO} connections=['A: [connection C577/A =>[signal: _42_:A0 w=1]]', 'B: [connection C577/B =>[signal: net37:14 w=1]]']]
C577 _42_:A0 net37:14  C=1.24359E-16
** [instance C578 of CAPACITOR, params={'capacitance': 4.63305e-05 prefix:SIUnitPrefix.PICO} connections=['A: [connection C578/A =>[signal: _42_:A0 w=1]]', 'B: [connection C578/B =>[signal: net4:18 w=1]]']]
C578 _42_:A0 net4:18  C=4.63305E-17
** [instance C579 of CAPACITOR, params={'capacitance': 0.000339171 prefix:SIUnitPrefix.PICO} connections=['A: [connection C579/A =>[signal: clkbuf_1_1__f_scan_clk:A w=1]]', 'B: [connection C579/B =>[signal: VSS w=1]]']]
C579 clkbuf_1_1__f_scan_clk:A VSS  C=3.3917099999999997E-16
** [instance C580 of CAPACITOR, params={'capacitance': 1.90303e-05 prefix:SIUnitPrefix.PICO} connections=['A: [connection C580/A =>[signal: clkbuf_1_1__f_scan_clk:A w=1]]', 'B: [connection C580/B =>[signal: mem[14]:10 w=1]]']]
C580 clkbuf_1_1__f_scan_clk:A mem[14]:10  C=1.90303E-17
** [instance C581 of CAPACITOR, params={'capacitance': 8.88548e-05 prefix:SIUnitPrefix.PICO} connections=['A: [connection C581/A =>[signal: clkbuf_1_0__f_scan_clk:A w=1]]', 'B: [connection C581/B =>[signal: VSS w=1]]']]
C581 clkbuf_1_0__f_scan_clk:A VSS  C=8.88548E-17
** [instance C582 of CAPACITOR, params={'capacitance': 2.67043e-05 prefix:SIUnitPrefix.PICO} connections=['A: [connection C582/A =>[signal: clkbuf_0_scan_clk:X w=1]]', 'B: [connection C582/B =>[signal: VSS w=1]]']]
C582 clkbuf_0_scan_clk:X VSS  C=2.67043E-17
** [instance C583 of CAPACITOR, params={'capacitance': 0.000455964 prefix:SIUnitPrefix.PICO} connections=['A: [connection C583/A =>[signal: clknet_0_scan_clk:49 w=1]]', 'B: [connection C583/B =>[signal: VSS w=1]]']]
C583 clknet_0_scan_clk:49 VSS  C=4.55964E-16
** [instance C584 of CAPACITOR, params={'capacitance': 0.000116793 prefix:SIUnitPrefix.PICO} connections=['A: [connection C584/A =>[signal: clknet_0_scan_clk:44 w=1]]', 'B: [connection C584/B =>[signal: VSS w=1]]']]
C584 clknet_0_scan_clk:44 VSS  C=1.16793E-16
** [instance C585 of CAPACITOR, params={'capacitance': 0.000619225 prefix:SIUnitPrefix.PICO} connections=['A: [connection C585/A =>[signal: clknet_0_scan_clk:33 w=1]]', 'B: [connection C585/B =>[signal: VSS w=1]]']]
C585 clknet_0_scan_clk:33 VSS  C=6.19225E-16
** [instance C586 of CAPACITOR, params={'capacitance': 1.00689e-05 prefix:SIUnitPrefix.PICO} connections=['A: [connection C586/A =>[signal: clknet_0_scan_clk:33 w=1]]', 'B: [connection C586/B =>[signal: mem[8]:10 w=1]]']]
C586 clknet_0_scan_clk:33 mem[8]:10  C=1.0068899999999999E-17
** [instance C587 of CAPACITOR, params={'capacitance': 0.000581012 prefix:SIUnitPrefix.PICO} connections=['A: [connection C587/A =>[signal: clknet_0_scan_clk:8 w=1]]', 'B: [connection C587/B =>[signal: VSS w=1]]']]
C587 clknet_0_scan_clk:8 VSS  C=5.81012E-16
** [instance C588 of CAPACITOR, params={'capacitance': 7.73455e-05 prefix:SIUnitPrefix.PICO} connections=['A: [connection C588/A =>[signal: clknet_0_scan_clk:6 w=1]]', 'B: [connection C588/B =>[signal: VSS w=1]]']]
C588 clknet_0_scan_clk:6 VSS  C=7.734549999999999E-17
** [instance C589 of CAPACITOR, params={'capacitance': 9.73049e-05 prefix:SIUnitPrefix.PICO} connections=['A: [connection C589/A =>[signal: _33_:S1 w=1]]', 'B: [connection C589/B =>[signal: clkbuf_1_0__f_scan_clk:A w=1]]']]
C589 _33_:S1 clkbuf_1_0__f_scan_clk:A  C=9.730489999999999E-17
** [instance C590 of CAPACITOR, params={'capacitance': 1.29975e-05 prefix:SIUnitPrefix.PICO} connections=['A: [connection C590/A =>[signal: _33_:S1 w=1]]', 'B: [connection C590/B =>[signal: clkbuf_1_1__f_scan_clk:A w=1]]']]
C590 _33_:S1 clkbuf_1_1__f_scan_clk:A  C=1.29975E-17
** [instance C591 of CAPACITOR, params={'capacitance': 1.23691e-05 prefix:SIUnitPrefix.PICO} connections=['A: [connection C591/A =>[signal: _33_:S1 w=1]]', 'B: [connection C591/B =>[signal: clknet_0_scan_clk:33 w=1]]']]
C591 _33_:S1 clknet_0_scan_clk:33  C=1.23691E-17
** [instance C592 of CAPACITOR, params={'capacitance': 6.81786e-05 prefix:SIUnitPrefix.PICO} connections=['A: [connection C592/A =>[signal: _33_:S1 w=1]]', 'B: [connection C592/B =>[signal: _60_:CLK w=1]]']]
C592 _33_:S1 _60_:CLK  C=6.81786E-17
** [instance C593 of CAPACITOR, params={'capacitance': 2.37944e-05 prefix:SIUnitPrefix.PICO} connections=['A: [connection C593/A =>[signal: _33_:S1 w=1]]', 'B: [connection C593/B =>[signal: _43_:A1 w=1]]']]
C593 _33_:S1 _43_:A1  C=2.37944E-17
** [instance C594 of CAPACITOR, params={'capacitance': 7.29879e-05 prefix:SIUnitPrefix.PICO} connections=['A: [connection C594/A =>[signal: _33_:S1 w=1]]', 'B: [connection C594/B =>[signal: net13:14 w=1]]']]
C594 _33_:S1 net13:14  C=7.29879E-17
** [instance C595 of CAPACITOR, params={'capacitance': 3.07863e-05 prefix:SIUnitPrefix.PICO} connections=['A: [connection C595/A =>[signal: _33_:S1 w=1]]', 'B: [connection C595/B =>[signal: _60_:D w=1]]']]
C595 _33_:S1 _60_:D  C=3.07863E-17
** [instance C596 of CAPACITOR, params={'capacitance': 0.000952398 prefix:SIUnitPrefix.PICO} connections=['A: [connection C596/A =>[signal: _33_:S1 w=1]]', 'B: [connection C596/B =>[signal: VSS w=1]]']]
C596 _33_:S1 VSS  C=9.52398E-16
** [instance C597 of CAPACITOR, params={'capacitance': 0.00014852 prefix:SIUnitPrefix.PICO} connections=['A: [connection C597/A =>[signal: _33_:S1 w=1]]', 'B: [connection C597/B =>[signal: _34_:B1 w=1]]']]
C597 _33_:S1 _34_:B1  C=1.4852E-16
** [instance C598 of CAPACITOR, params={'capacitance': 0.000100989 prefix:SIUnitPrefix.PICO} connections=['A: [connection C598/A =>[signal: _33_:S1 w=1]]', 'B: [connection C598/B =>[signal: _43_:A0 w=1]]']]
C598 _33_:S1 _43_:A0  C=1.00989E-16
** [instance C599 of CAPACITOR, params={'capacitance': 5.80001e-05 prefix:SIUnitPrefix.PICO} connections=['A: [connection C599/A =>[signal: _33_:S1 w=1]]', 'B: [connection C599/B =>[signal: _44_:A0 w=1]]']]
C599 _33_:S1 _44_:A0  C=5.80001E-17
** [instance C600 of CAPACITOR, params={'capacitance': 0.000141734 prefix:SIUnitPrefix.PICO} connections=['A: [connection C600/A =>[signal: _33_:S1 w=1]]', 'B: [connection C600/B =>[signal: _44_:A1 w=1]]']]
C600 _33_:S1 _44_:A1  C=1.4173399999999998E-16
** [instance C601 of CAPACITOR, params={'capacitance': 1.29975e-05 prefix:SIUnitPrefix.PICO} connections=['A: [connection C601/A =>[signal: _51_:A0 w=1]]', 'B: [connection C601/B =>[signal: clknet_0_scan_clk:6 w=1]]']]
C601 _51_:A0 clknet_0_scan_clk:6  C=1.29975E-17
** [instance C602 of CAPACITOR, params={'capacitance': 2.58366e-05 prefix:SIUnitPrefix.PICO} connections=['A: [connection C602/A =>[signal: _51_:A0 w=1]]', 'B: [connection C602/B =>[signal: clknet_0_scan_clk:8 w=1]]']]
C602 _51_:A0 clknet_0_scan_clk:8  C=2.58366E-17
** [instance C603 of CAPACITOR, params={'capacitance': 2.83403e-05 prefix:SIUnitPrefix.PICO} connections=['A: [connection C603/A =>[signal: _51_:A0 w=1]]', 'B: [connection C603/B =>[signal: clknet_0_scan_clk:33 w=1]]']]
C603 _51_:A0 clknet_0_scan_clk:33  C=2.83403E-17
** [instance C604 of CAPACITOR, params={'capacitance': 0.0 prefix:SIUnitPrefix.PICO} connections=['A: [connection C604/A =>[signal: _51_:A0 w=1]]', 'B: [connection C604/B =>[signal: clknet_0_scan_clk:49 w=1]]']]
** C604 _51_:A0 clknet_0_scan_clk:49  C=0.0 [skipped because C=0]
** [instance C605 of CAPACITOR, params={'capacitance': 1.62621e-05 prefix:SIUnitPrefix.PICO} connections=['A: [connection C605/A =>[signal: _51_:A0 w=1]]', 'B: [connection C605/B =>[signal: _51_:S w=1]]']]
C605 _51_:A0 _51_:S  C=1.6262100000000002E-17
** [instance C606 of CAPACITOR, params={'capacitance': 0.000658352 prefix:SIUnitPrefix.PICO} connections=['A: [connection C606/A =>[signal: _51_:A0 w=1]]', 'B: [connection C606/B =>[signal: VSS w=1]]']]
C606 _51_:A0 VSS  C=6.58352E-16
** [instance C607 of CAPACITOR, params={'capacitance': 0.000363477 prefix:SIUnitPrefix.PICO} connections=['A: [connection C607/A =>[signal: _64_:CLK w=1]]', 'B: [connection C607/B =>[signal: VSS w=1]]']]
C607 _64_:CLK VSS  C=3.63477E-16
** [instance C608 of CAPACITOR, params={'capacitance': 3.32132e-06 prefix:SIUnitPrefix.PICO} connections=['A: [connection C608/A =>[signal: _64_:CLK w=1]]', 'B: [connection C608/B =>[signal: _64_:D w=1]]']]
C608 _64_:CLK _64_:D  C=3.32132E-18
** [instance C609 of CAPACITOR, params={'capacitance': 0.0 prefix:SIUnitPrefix.PICO} connections=['A: [connection C609/A =>[signal: _63_:CLK w=1]]', 'B: [connection C609/B =>[signal: VSS w=1]]']]
** C609 _63_:CLK VSS  C=0.0 [skipped because C=0]
** [instance C610 of CAPACITOR, params={'capacitance': 3.72704e-05 prefix:SIUnitPrefix.PICO} connections=['A: [connection C610/A =>[signal: _65_:CLK w=1]]', 'B: [connection C610/B =>[signal: VSS w=1]]']]
C610 _65_:CLK VSS  C=3.72704E-17
** [instance C611 of CAPACITOR, params={'capacitance': 3.72884e-05 prefix:SIUnitPrefix.PICO} connections=['A: [connection C611/A =>[signal: _67_:CLK w=1]]', 'B: [connection C611/B =>[signal: VSS w=1]]']]
C611 _67_:CLK VSS  C=3.72884E-17
** [instance C612 of CAPACITOR, params={'capacitance': 0.0 prefix:SIUnitPrefix.PICO} connections=['A: [connection C612/A =>[signal: _68_:CLK w=1]]', 'B: [connection C612/B =>[signal: VSS w=1]]']]
** C612 _68_:CLK VSS  C=0.0 [skipped because C=0]
** [instance C613 of CAPACITOR, params={'capacitance': 0.0 prefix:SIUnitPrefix.PICO} connections=['A: [connection C613/A =>[signal: _69_:CLK w=1]]', 'B: [connection C613/B =>[signal: VSS w=1]]']]
** C613 _69_:CLK VSS  C=0.0 [skipped because C=0]
** [instance C614 of CAPACITOR, params={'capacitance': 0.000484422 prefix:SIUnitPrefix.PICO} connections=['A: [connection C614/A =>[signal: clkbuf_1_0__f_scan_clk:X w=1]]', 'B: [connection C614/B =>[signal: VSS w=1]]']]
C614 clkbuf_1_0__f_scan_clk:X VSS  C=4.844219999999999E-16
** [instance C615 of CAPACITOR, params={'capacitance': 0.000739012 prefix:SIUnitPrefix.PICO} connections=['A: [connection C615/A =>[signal: clknet_1_0__leaf_scan_clk:90 w=1]]', 'B: [connection C615/B =>[signal: VSS w=1]]']]
C615 clknet_1_0__leaf_scan_clk:90 VSS  C=7.39012E-16
** [instance C616 of CAPACITOR, params={'capacitance': 0.000225969 prefix:SIUnitPrefix.PICO} connections=['A: [connection C616/A =>[signal: clknet_1_0__leaf_scan_clk:81 w=1]]', 'B: [connection C616/B =>[signal: VSS w=1]]']]
C616 clknet_1_0__leaf_scan_clk:81 VSS  C=2.25969E-16
** [instance C617 of CAPACITOR, params={'capacitance': 0.000379386 prefix:SIUnitPrefix.PICO} connections=['A: [connection C617/A =>[signal: clknet_1_0__leaf_scan_clk:40 w=1]]', 'B: [connection C617/B =>[signal: VSS w=1]]']]
C617 clknet_1_0__leaf_scan_clk:40 VSS  C=3.79386E-16
** [instance C618 of CAPACITOR, params={'capacitance': 0.000150886 prefix:SIUnitPrefix.PICO} connections=['A: [connection C618/A =>[signal: clknet_1_0__leaf_scan_clk:40 w=1]]', 'B: [connection C618/B =>[signal: mem[6]:14 w=1]]']]
C618 clknet_1_0__leaf_scan_clk:40 mem[6]:14  C=1.50886E-16
** [instance C619 of CAPACITOR, params={'capacitance': 0.000439636 prefix:SIUnitPrefix.PICO} connections=['A: [connection C619/A =>[signal: clknet_1_0__leaf_scan_clk:20 w=1]]', 'B: [connection C619/B =>[signal: VSS w=1]]']]
C619 clknet_1_0__leaf_scan_clk:20 VSS  C=4.3963599999999996E-16
** [instance C620 of CAPACITOR, params={'capacitance': 0.000744859 prefix:SIUnitPrefix.PICO} connections=['A: [connection C620/A =>[signal: clknet_1_0__leaf_scan_clk:14 w=1]]', 'B: [connection C620/B =>[signal: VSS w=1]]']]
C620 clknet_1_0__leaf_scan_clk:14 VSS  C=7.448589999999999E-16
** [instance C621 of CAPACITOR, params={'capacitance': 0.000354977 prefix:SIUnitPrefix.PICO} connections=['A: [connection C621/A =>[signal: clknet_1_0__leaf_scan_clk:12 w=1]]', 'B: [connection C621/B =>[signal: VSS w=1]]']]
C621 clknet_1_0__leaf_scan_clk:12 VSS  C=3.54977E-16
** [instance C622 of CAPACITOR, params={'capacitance': 0.000544387 prefix:SIUnitPrefix.PICO} connections=['A: [connection C622/A =>[signal: clknet_1_0__leaf_scan_clk:10 w=1]]', 'B: [connection C622/B =>[signal: VSS w=1]]']]
C622 clknet_1_0__leaf_scan_clk:10 VSS  C=5.44387E-16
** [instance C623 of CAPACITOR, params={'capacitance': 7.74068e-05 prefix:SIUnitPrefix.PICO} connections=['A: [connection C623/A =>[signal: _47_:A0 w=1]]', 'B: [connection C623/B =>[signal: clknet_1_0__leaf_scan_clk:81 w=1]]']]
C623 _47_:A0 clknet_1_0__leaf_scan_clk:81  C=7.74068E-17
** [instance C624 of CAPACITOR, params={'capacitance': 2.29031e-05 prefix:SIUnitPrefix.PICO} connections=['A: [connection C624/A =>[signal: _47_:A0 w=1]]', 'B: [connection C624/B =>[signal: hold18:A w=1]]']]
C624 _47_:A0 hold18:A  C=2.29031E-17
** [instance C625 of CAPACITOR, params={'capacitance': 9.41642e-05 prefix:SIUnitPrefix.PICO} connections=['A: [connection C625/A =>[signal: _47_:A0 w=1]]', 'B: [connection C625/B =>[signal: hold31:A w=1]]']]
C625 _47_:A0 hold31:A  C=9.416420000000001E-17
** [instance C626 of CAPACITOR, params={'capacitance': 0.000115319 prefix:SIUnitPrefix.PICO} connections=['A: [connection C626/A =>[signal: _47_:A0 w=1]]', 'B: [connection C626/B =>[signal: VSS w=1]]']]
C626 _47_:A0 VSS  C=1.15319E-16
** [instance C627 of CAPACITOR, params={'capacitance': 0.0 prefix:SIUnitPrefix.PICO} connections=['A: [connection C627/A =>[signal: _59_:CLK w=1]]', 'B: [connection C627/B =>[signal: VSS w=1]]']]
** C627 _59_:CLK VSS  C=0.0 [skipped because C=0]
** [instance C628 of CAPACITOR, params={'capacitance': 5.93939e-05 prefix:SIUnitPrefix.PICO} connections=['A: [connection C628/A =>[signal: _60_:CLK w=1]]', 'B: [connection C628/B =>[signal: VSS w=1]]']]
C628 _60_:CLK VSS  C=5.93939E-17
** [instance C629 of CAPACITOR, params={'capacitance': 3.04135e-05 prefix:SIUnitPrefix.PICO} connections=['A: [connection C629/A =>[signal: _76_:CLK w=1]]', 'B: [connection C629/B =>[signal: VSS w=1]]']]
C629 _76_:CLK VSS  C=3.0413499999999996E-17
** [instance C630 of CAPACITOR, params={'capacitance': 5.33005e-05 prefix:SIUnitPrefix.PICO} connections=['A: [connection C630/A =>[signal: _76_:CLK w=1]]', 'B: [connection C630/B =>[signal: net4:18 w=1]]']]
C630 _76_:CLK net4:18  C=5.33005E-17
** [instance C631 of CAPACITOR, params={'capacitance': 0.000442905 prefix:SIUnitPrefix.PICO} connections=['A: [connection C631/A =>[signal: _75_:CLK w=1]]', 'B: [connection C631/B =>[signal: VSS w=1]]']]
C631 _75_:CLK VSS  C=4.42905E-16
** [instance C632 of CAPACITOR, params={'capacitance': 2.76145e-05 prefix:SIUnitPrefix.PICO} connections=['A: [connection C632/A =>[signal: _75_:CLK w=1]]', 'B: [connection C632/B =>[signal: _75_:D w=1]]']]
C632 _75_:CLK _75_:D  C=2.76145E-17
** [instance C633 of CAPACITOR, params={'capacitance': 7.19542e-05 prefix:SIUnitPrefix.PICO} connections=['A: [connection C633/A =>[signal: _74_:CLK w=1]]', 'B: [connection C633/B =>[signal: VSS w=1]]']]
C633 _74_:CLK VSS  C=7.19542E-17
** [instance C634 of CAPACITOR, params={'capacitance': 0.000392654 prefix:SIUnitPrefix.PICO} connections=['A: [connection C634/A =>[signal: clkbuf_1_1__f_scan_clk:X w=1]]', 'B: [connection C634/B =>[signal: VSS w=1]]']]
C634 clkbuf_1_1__f_scan_clk:X VSS  C=3.92654E-16
** [instance C635 of CAPACITOR, params={'capacitance': 0.00059948 prefix:SIUnitPrefix.PICO} connections=['A: [connection C635/A =>[signal: clknet_1_1__leaf_scan_clk:81 w=1]]', 'B: [connection C635/B =>[signal: VSS w=1]]']]
C635 clknet_1_1__leaf_scan_clk:81 VSS  C=5.9948E-16
** [instance C636 of CAPACITOR, params={'capacitance': 0.000750974 prefix:SIUnitPrefix.PICO} connections=['A: [connection C636/A =>[signal: clknet_1_1__leaf_scan_clk:79 w=1]]', 'B: [connection C636/B =>[signal: VSS w=1]]']]
C636 clknet_1_1__leaf_scan_clk:79 VSS  C=7.509739999999999E-16
** [instance C637 of CAPACITOR, params={'capacitance': 0.000597575 prefix:SIUnitPrefix.PICO} connections=['A: [connection C637/A =>[signal: clknet_1_1__leaf_scan_clk:75 w=1]]', 'B: [connection C637/B =>[signal: VSS w=1]]']]
C637 clknet_1_1__leaf_scan_clk:75 VSS  C=5.975750000000001E-16
** [instance C638 of CAPACITOR, params={'capacitance': 0.000169233 prefix:SIUnitPrefix.PICO} connections=['A: [connection C638/A =>[signal: clknet_1_1__leaf_scan_clk:75 w=1]]', 'B: [connection C638/B =>[signal: net37:14 w=1]]']]
C638 clknet_1_1__leaf_scan_clk:75 net37:14  C=1.69233E-16
** [instance C639 of CAPACITOR, params={'capacitance': 0.000316948 prefix:SIUnitPrefix.PICO} connections=['A: [connection C639/A =>[signal: clknet_1_1__leaf_scan_clk:60 w=1]]', 'B: [connection C639/B =>[signal: VSS w=1]]']]
C639 clknet_1_1__leaf_scan_clk:60 VSS  C=3.16948E-16
** [instance C640 of CAPACITOR, params={'capacitance': 0.000269359 prefix:SIUnitPrefix.PICO} connections=['A: [connection C640/A =>[signal: clknet_1_1__leaf_scan_clk:60 w=1]]', 'B: [connection C640/B =>[signal: net37:14 w=1]]']]
C640 clknet_1_1__leaf_scan_clk:60 net37:14  C=2.69359E-16
** [instance C641 of CAPACITOR, params={'capacitance': 0.000484032 prefix:SIUnitPrefix.PICO} connections=['A: [connection C641/A =>[signal: clknet_1_1__leaf_scan_clk:29 w=1]]', 'B: [connection C641/B =>[signal: VSS w=1]]']]
C641 clknet_1_1__leaf_scan_clk:29 VSS  C=4.84032E-16
** [instance C642 of CAPACITOR, params={'capacitance': 3.97677e-05 prefix:SIUnitPrefix.PICO} connections=['A: [connection C642/A =>[signal: clknet_1_1__leaf_scan_clk:29 w=1]]', 'B: [connection C642/B =>[signal: net12:103 w=1]]']]
C642 clknet_1_1__leaf_scan_clk:29 net12:103  C=3.97677E-17
** [instance C643 of CAPACITOR, params={'capacitance': 0.000114577 prefix:SIUnitPrefix.PICO} connections=['A: [connection C643/A =>[signal: clknet_1_1__leaf_scan_clk:29 w=1]]', 'B: [connection C643/B =>[signal: net33:8 w=1]]']]
C643 clknet_1_1__leaf_scan_clk:29 net33:8  C=1.14577E-16
** [instance C644 of CAPACITOR, params={'capacitance': 5.84171e-05 prefix:SIUnitPrefix.PICO} connections=['A: [connection C644/A =>[signal: clknet_1_1__leaf_scan_clk:29 w=1]]', 'B: [connection C644/B =>[signal: net37:14 w=1]]']]
C644 clknet_1_1__leaf_scan_clk:29 net37:14  C=5.84171E-17
** [instance C645 of CAPACITOR, params={'capacitance': 0.000948557 prefix:SIUnitPrefix.PICO} connections=['A: [connection C645/A =>[signal: clknet_1_1__leaf_scan_clk:23 w=1]]', 'B: [connection C645/B =>[signal: VSS w=1]]']]
C645 clknet_1_1__leaf_scan_clk:23 VSS  C=9.485570000000001E-16
** [instance C646 of CAPACITOR, params={'capacitance': 0.000464207 prefix:SIUnitPrefix.PICO} connections=['A: [connection C646/A =>[signal: clknet_1_1__leaf_scan_clk:23 w=1]]', 'B: [connection C646/B =>[signal: net37:14 w=1]]']]
C646 clknet_1_1__leaf_scan_clk:23 net37:14  C=4.64207E-16
** [instance C647 of CAPACITOR, params={'capacitance': 0.000333301 prefix:SIUnitPrefix.PICO} connections=['A: [connection C647/A =>[signal: clknet_1_1__leaf_scan_clk:10 w=1]]', 'B: [connection C647/B =>[signal: VSS w=1]]']]
C647 clknet_1_1__leaf_scan_clk:10 VSS  C=3.33301E-16
** [instance C648 of CAPACITOR, params={'capacitance': 7.58841e-05 prefix:SIUnitPrefix.PICO} connections=['A: [connection C648/A =>[signal: clknet_1_1__leaf_scan_clk:10 w=1]]', 'B: [connection C648/B =>[signal: net37:14 w=1]]']]
C648 clknet_1_1__leaf_scan_clk:10 net37:14  C=7.58841E-17
** [instance C649 of CAPACITOR, params={'capacitance': 0.000519499 prefix:SIUnitPrefix.PICO} connections=['A: [connection C649/A =>[signal: clknet_1_1__leaf_scan_clk:8 w=1]]', 'B: [connection C649/B =>[signal: VSS w=1]]']]
C649 clknet_1_1__leaf_scan_clk:8 VSS  C=5.194989999999999E-16
** [instance C650 of CAPACITOR, params={'capacitance': 4.87649e-05 prefix:SIUnitPrefix.PICO} connections=['A: [connection C650/A =>[signal: _33_:A0 w=1]]', 'B: [connection C650/B =>[signal: clknet_1_1__leaf_scan_clk:79 w=1]]']]
C650 _33_:A0 clknet_1_1__leaf_scan_clk:79  C=4.8764899999999995E-17
** [instance C651 of CAPACITOR, params={'capacitance': 7.88479e-05 prefix:SIUnitPrefix.PICO} connections=['A: [connection C651/A =>[signal: _33_:A0 w=1]]', 'B: [connection C651/B =>[signal: VSS w=1]]']]
C651 _33_:A0 VSS  C=7.88479E-17
** [instance C652 of CAPACITOR, params={'capacitance': 9.41642e-05 prefix:SIUnitPrefix.PICO} connections=['A: [connection C652/A =>[signal: _33_:A2 w=1]]', 'B: [connection C652/B =>[signal: clknet_1_1__leaf_scan_clk:79 w=1]]']]
C652 _33_:A2 clknet_1_1__leaf_scan_clk:79  C=9.416420000000001E-17
** [instance C653 of CAPACITOR, params={'capacitance': 2.99504e-05 prefix:SIUnitPrefix.PICO} connections=['A: [connection C653/A =>[signal: _33_:A2 w=1]]', 'B: [connection C653/B =>[signal: VSS w=1]]']]
C653 _33_:A2 VSS  C=2.99504E-17
** [instance C654 of CAPACITOR, params={'capacitance': 9.41642e-05 prefix:SIUnitPrefix.PICO} connections=['A: [connection C654/A =>[signal: _33_:A2 w=1]]', 'B: [connection C654/B =>[signal: _33_:A3 w=1]]']]
C654 _33_:A2 _33_:A3  C=9.416420000000001E-17
** [instance C655 of CAPACITOR, params={'capacitance': 0.000253107 prefix:SIUnitPrefix.PICO} connections=['A: [connection C655/A =>[signal: _35_:A0 w=1]]', 'B: [connection C655/B =>[signal: VSS w=1]]']]
C655 _35_:A0 VSS  C=2.53107E-16
** [instance C656 of CAPACITOR, params={'capacitance': 0.000350136 prefix:SIUnitPrefix.PICO} connections=['A: [connection C656/A =>[signal: _35_:A0 w=1]]', 'B: [connection C656/B =>[signal: _35_:A1 w=1]]']]
C656 _35_:A0 _35_:A1  C=3.5013600000000004E-16
** [instance C657 of CAPACITOR, params={'capacitance': 0.00103056 prefix:SIUnitPrefix.PICO} connections=['A: [connection C657/A =>[signal: hold24:A w=1]]', 'B: [connection C657/B =>[signal: VSS w=1]]']]
C657 hold24:A VSS  C=1.03056E-15
** [instance C658 of CAPACITOR, params={'capacitance': 2.47186e-05 prefix:SIUnitPrefix.PICO} connections=['A: [connection C658/A =>[signal: hold24:A w=1]]', 'B: [connection C658/B =>[signal: net12:103 w=1]]']]
C658 hold24:A net12:103  C=2.47186E-17
** [instance C659 of CAPACITOR, params={'capacitance': 0.0 prefix:SIUnitPrefix.PICO} connections=['A: [connection C659/A =>[signal: hold24:A w=1]]', 'B: [connection C659/B =>[signal: net13:35 w=1]]']]
** C659 hold24:A net13:35  C=0.0 [skipped because C=0]
** [instance C660 of CAPACITOR, params={'capacitance': 3.97657e-05 prefix:SIUnitPrefix.PICO} connections=['A: [connection C660/A =>[signal: hold24:A w=1]]', 'B: [connection C660/B =>[signal: net24:10 w=1]]']]
C660 hold24:A net24:10  C=3.9765699999999995E-17
** [instance C661 of CAPACITOR, params={'capacitance': 0.00128367 prefix:SIUnitPrefix.PICO} connections=['A: [connection C661/A =>[signal: _75_:Q w=1]]', 'B: [connection C661/B =>[signal: VSS w=1]]']]
C661 _75_:Q VSS  C=1.28367E-15
** [instance C662 of CAPACITOR, params={'capacitance': 2.57487e-05 prefix:SIUnitPrefix.PICO} connections=['A: [connection C662/A =>[signal: _50_:A0 w=1]]', 'B: [connection C662/B =>[signal: hold24:A w=1]]']]
C662 _50_:A0 hold24:A  C=2.57487E-17
** [instance C663 of CAPACITOR, params={'capacitance': 5.71472e-05 prefix:SIUnitPrefix.PICO} connections=['A: [connection C663/A =>[signal: _50_:A0 w=1]]', 'B: [connection C663/B =>[signal: _50_:S w=1]]']]
C663 _50_:A0 _50_:S  C=5.71472E-17
** [instance C664 of CAPACITOR, params={'capacitance': 0.00014285 prefix:SIUnitPrefix.PICO} connections=['A: [connection C664/A =>[signal: _50_:A0 w=1]]', 'B: [connection C664/B =>[signal: _55_:A1 w=1]]']]
C664 _50_:A0 _55_:A1  C=1.4285E-16
** [instance C665 of CAPACITOR, params={'capacitance': 0.000136848 prefix:SIUnitPrefix.PICO} connections=['A: [connection C665/A =>[signal: _50_:A0 w=1]]', 'B: [connection C665/B =>[signal: net24:10 w=1]]']]
C665 _50_:A0 net24:10  C=1.3684799999999999E-16
** [instance C666 of CAPACITOR, params={'capacitance': 9.90431e-05 prefix:SIUnitPrefix.PICO} connections=['A: [connection C666/A =>[signal: _50_:A0 w=1]]', 'B: [connection C666/B =>[signal: net26:14 w=1]]']]
C666 _50_:A0 net26:14  C=9.90431E-17
** [instance C667 of CAPACITOR, params={'capacitance': 8.51174e-05 prefix:SIUnitPrefix.PICO} connections=['A: [connection C667/A =>[signal: _50_:A0 w=1]]', 'B: [connection C667/B =>[signal: VSS w=1]]']]
C667 _50_:A0 VSS  C=8.51174E-17
** [instance C668 of CAPACITOR, params={'capacitance': 0.000103267 prefix:SIUnitPrefix.PICO} connections=['A: [connection C668/A =>[signal: _51_:A1 w=1]]', 'B: [connection C668/B =>[signal: hold24:A w=1]]']]
C668 _51_:A1 hold24:A  C=1.03267E-16
** [instance C669 of CAPACITOR, params={'capacitance': 3.37161e-05 prefix:SIUnitPrefix.PICO} connections=['A: [connection C669/A =>[signal: _51_:A1 w=1]]', 'B: [connection C669/B =>[signal: _56_:S w=1]]']]
C669 _51_:A1 _56_:S  C=3.37161E-17
** [instance C670 of CAPACITOR, params={'capacitance': 9.91824e-05 prefix:SIUnitPrefix.PICO} connections=['A: [connection C670/A =>[signal: _51_:A1 w=1]]', 'B: [connection C670/B =>[signal: net13:35 w=1]]']]
C670 _51_:A1 net13:35  C=9.91824E-17
** [instance C671 of CAPACITOR, params={'capacitance': 0.000225616 prefix:SIUnitPrefix.PICO} connections=['A: [connection C671/A =>[signal: _51_:A1 w=1]]', 'B: [connection C671/B =>[signal: _56_:A0 w=1]]']]
C671 _51_:A1 _56_:A0  C=2.25616E-16
** [instance C672 of CAPACITOR, params={'capacitance': 0.0005416 prefix:SIUnitPrefix.PICO} connections=['A: [connection C672/A =>[signal: _51_:A1 w=1]]', 'B: [connection C672/B =>[signal: VSS w=1]]']]
C672 _51_:A1 VSS  C=5.416000000000001E-16
** [instance C673 of CAPACITOR, params={'capacitance': 0.000170511 prefix:SIUnitPrefix.PICO} connections=['A: [connection C673/A =>[signal: _52_:A0 w=1]]', 'B: [connection C673/B =>[signal: hold24:A w=1]]']]
C673 _52_:A0 hold24:A  C=1.70511E-16
** [instance C674 of CAPACITOR, params={'capacitance': 0.000185643 prefix:SIUnitPrefix.PICO} connections=['A: [connection C674/A =>[signal: _52_:A0 w=1]]', 'B: [connection C674/B =>[signal: _52_:A1 w=1]]']]
C674 _52_:A0 _52_:A1  C=1.85643E-16
** [instance C675 of CAPACITOR, params={'capacitance': 3.92757e-05 prefix:SIUnitPrefix.PICO} connections=['A: [connection C675/A =>[signal: _52_:A0 w=1]]', 'B: [connection C675/B =>[signal: net12:103 w=1]]']]
C675 _52_:A0 net12:103  C=3.92757E-17
** [instance C676 of CAPACITOR, params={'capacitance': 3.0629e-05 prefix:SIUnitPrefix.PICO} connections=['A: [connection C676/A =>[signal: _52_:A0 w=1]]', 'B: [connection C676/B =>[signal: net13:35 w=1]]']]
C676 _52_:A0 net13:35  C=3.0629E-17
** [instance C677 of CAPACITOR, params={'capacitance': 0.000197718 prefix:SIUnitPrefix.PICO} connections=['A: [connection C677/A =>[signal: _52_:A0 w=1]]', 'B: [connection C677/B =>[signal: VSS w=1]]']]
C677 _52_:A0 VSS  C=1.97718E-16
** [instance C678 of CAPACITOR, params={'capacitance': 0.000185217 prefix:SIUnitPrefix.PICO} connections=['A: [connection C678/A =>[signal: hold14:A w=1]]', 'B: [connection C678/B =>[signal: VSS w=1]]']]
C678 hold14:A VSS  C=1.85217E-16
** [instance C679 of CAPACITOR, params={'capacitance': 0.000463903 prefix:SIUnitPrefix.PICO} connections=['A: [connection C679/A =>[signal: hold14:A w=1]]', 'B: [connection C679/B =>[signal: hold37:A w=1]]']]
C679 hold14:A hold37:A  C=4.63903E-16
** [instance C680 of CAPACITOR, params={'capacitance': 1.41029e-05 prefix:SIUnitPrefix.PICO} connections=['A: [connection C680/A =>[signal: hold14:A w=1]]', 'B: [connection C680/B =>[signal: net1:10 w=1]]']]
C680 hold14:A net1:10  C=1.41029E-17
** [instance C681 of CAPACITOR, params={'capacitance': 0.000499769 prefix:SIUnitPrefix.PICO} connections=['A: [connection C681/A =>[signal: hold14:A w=1]]', 'B: [connection C681/B =>[signal: net36:14 w=1]]']]
C681 hold14:A net36:14  C=4.997689999999999E-16
** [instance C682 of CAPACITOR, params={'capacitance': 0.000194255 prefix:SIUnitPrefix.PICO} connections=['A: [connection C682/A =>[signal: _31_:A2 w=1]]', 'B: [connection C682/B =>[signal: VSS w=1]]']]
C682 _31_:A2 VSS  C=1.94255E-16
** [instance C683 of CAPACITOR, params={'capacitance': 0.000388749 prefix:SIUnitPrefix.PICO} connections=['A: [connection C683/A =>[signal: _31_:A2 w=1]]', 'B: [connection C683/B =>[signal: hold37:A w=1]]']]
C683 _31_:A2 hold37:A  C=3.88749E-16
** [instance C684 of CAPACITOR, params={'capacitance': 0.000391171 prefix:SIUnitPrefix.PICO} connections=['A: [connection C684/A =>[signal: _31_:A2 w=1]]', 'B: [connection C684/B =>[signal: net36:14 w=1]]']]
C684 _31_:A2 net36:14  C=3.9117099999999997E-16
** [instance C685 of CAPACITOR, params={'capacitance': 0.000120308 prefix:SIUnitPrefix.PICO} connections=['A: [connection C685/A =>[signal: _64_:Q w=1]]', 'B: [connection C685/B =>[signal: VSS w=1]]']]
C685 _64_:Q VSS  C=1.20308E-16
** [instance C686 of CAPACITOR, params={'capacitance': 0.00049978 prefix:SIUnitPrefix.PICO} connections=['A: [connection C686/A =>[signal: mem[10]:8 w=1]]', 'B: [connection C686/B =>[signal: VSS w=1]]']]
C686 mem[10]:8 VSS  C=4.9978E-16
** [instance C687 of CAPACITOR, params={'capacitance': 0.000349236 prefix:SIUnitPrefix.PICO} connections=['A: [connection C687/A =>[signal: hold23:A w=1]]', 'B: [connection C687/B =>[signal: VSS w=1]]']]
C687 hold23:A VSS  C=3.49236E-16
** [instance C688 of CAPACITOR, params={'capacitance': 0.0 prefix:SIUnitPrefix.PICO} connections=['A: [connection C688/A =>[signal: hold23:A w=1]]', 'B: [connection C688/B =>[signal: hold29:A w=1]]']]
** C688 hold23:A hold29:A  C=0.0 [skipped because C=0]
** [instance C689 of CAPACITOR, params={'capacitance': 3.2923e-05 prefix:SIUnitPrefix.PICO} connections=['A: [connection C689/A =>[signal: hold23:A w=1]]', 'B: [connection C689/B =>[signal: mem[9]:23 w=1]]']]
C689 hold23:A mem[9]:23  C=3.2923E-17
** [instance C690 of CAPACITOR, params={'capacitance': 0.000327143 prefix:SIUnitPrefix.PICO} connections=['A: [connection C690/A =>[signal: hold23:A w=1]]', 'B: [connection C690/B =>[signal: net18:10 w=1]]']]
C690 hold23:A net18:10  C=3.27143E-16
** [instance C691 of CAPACITOR, params={'capacitance': 0.0 prefix:SIUnitPrefix.PICO} connections=['A: [connection C691/A =>[signal: hold23:A w=1]]', 'B: [connection C691/B =>[signal: net23:10 w=1]]']]
** C691 hold23:A net23:10  C=0.0 [skipped because C=0]
** [instance C692 of CAPACITOR, params={'capacitance': 0.000177279 prefix:SIUnitPrefix.PICO} connections=['A: [connection C692/A =>[signal: _31_:A3 w=1]]', 'B: [connection C692/B =>[signal: VSS w=1]]']]
C692 _31_:A3 VSS  C=1.77279E-16
** [instance C693 of CAPACITOR, params={'capacitance': 0.000101777 prefix:SIUnitPrefix.PICO} connections=['A: [connection C693/A =>[signal: _31_:A3 w=1]]', 'B: [connection C693/B =>[signal: mem[9]:23 w=1]]']]
C693 _31_:A3 mem[9]:23  C=1.01777E-16
** [instance C694 of CAPACITOR, params={'capacitance': 5.09999e-05 prefix:SIUnitPrefix.PICO} connections=['A: [connection C694/A =>[signal: _31_:A3 w=1]]', 'B: [connection C694/B =>[signal: net18:10 w=1]]']]
C694 _31_:A3 net18:10  C=5.0999899999999996E-17
** [instance C695 of CAPACITOR, params={'capacitance': 0.0 prefix:SIUnitPrefix.PICO} connections=['A: [connection C695/A =>[signal: _63_:Q w=1]]', 'B: [connection C695/B =>[signal: VSS w=1]]']]
** C695 _63_:Q VSS  C=0.0 [skipped because C=0]
** [instance C696 of CAPACITOR, params={'capacitance': 0.000526515 prefix:SIUnitPrefix.PICO} connections=['A: [connection C696/A =>[signal: mem[11]:6 w=1]]', 'B: [connection C696/B =>[signal: VSS w=1]]']]
C696 mem[11]:6 VSS  C=5.265149999999999E-16
** [instance C697 of CAPACITOR, params={'capacitance': 0.00023826 prefix:SIUnitPrefix.PICO} connections=['A: [connection C697/A =>[signal: hold27:A w=1]]', 'B: [connection C697/B =>[signal: VSS w=1]]']]
C697 hold27:A VSS  C=2.3826E-16
** [instance C698 of CAPACITOR, params={'capacitance': 0.0 prefix:SIUnitPrefix.PICO} connections=['A: [connection C698/A =>[signal: hold27:A w=1]]', 'B: [connection C698/B =>[signal: net23:10 w=1]]']]
** C698 hold27:A net23:10  C=0.0 [skipped because C=0]
** [instance C699 of CAPACITOR, params={'capacitance': 0.000114073 prefix:SIUnitPrefix.PICO} connections=['A: [connection C699/A =>[signal: _62_:Q w=1]]', 'B: [connection C699/B =>[signal: VSS w=1]]']]
C699 _62_:Q VSS  C=1.14073E-16
** [instance C700 of CAPACITOR, params={'capacitance': 0.000657799 prefix:SIUnitPrefix.PICO} connections=['A: [connection C700/A =>[signal: mem[12]:27 w=1]]', 'B: [connection C700/B =>[signal: VSS w=1]]']]
C700 mem[12]:27 VSS  C=6.57799E-16
** [instance C701 of CAPACITOR, params={'capacitance': 0.000668676 prefix:SIUnitPrefix.PICO} connections=['A: [connection C701/A =>[signal: mem[12]:6 w=1]]', 'B: [connection C701/B =>[signal: VSS w=1]]']]
C701 mem[12]:6 VSS  C=6.68676E-16
** [instance C702 of CAPACITOR, params={'capacitance': 0.000139478 prefix:SIUnitPrefix.PICO} connections=['A: [connection C702/A =>[signal: hold20:A w=1]]', 'B: [connection C702/B =>[signal: VSS w=1]]']]
C702 hold20:A VSS  C=1.3947800000000002E-16
** [instance C703 of CAPACITOR, params={'capacitance': 0.00030663 prefix:SIUnitPrefix.PICO} connections=['A: [connection C703/A =>[signal: hold20:A w=1]]', 'B: [connection C703/B =>[signal: mem[3]:40 w=1]]']]
C703 hold20:A mem[3]:40  C=3.0663E-16
** [instance C704 of CAPACITOR, params={'capacitance': 9.40531e-05 prefix:SIUnitPrefix.PICO} connections=['A: [connection C704/A =>[signal: _42_:A1 w=1]]', 'B: [connection C704/B =>[signal: VSS w=1]]']]
C704 _42_:A1 VSS  C=9.405309999999999E-17
** [instance C705 of CAPACITOR, params={'capacitance': 0.000107686 prefix:SIUnitPrefix.PICO} connections=['A: [connection C705/A =>[signal: _42_:A1 w=1]]', 'B: [connection C705/B =>[signal: mem[3]:40 w=1]]']]
C705 _42_:A1 mem[3]:40  C=1.07686E-16
** [instance C706 of CAPACITOR, params={'capacitance': 0.0 prefix:SIUnitPrefix.PICO} connections=['A: [connection C706/A =>[signal: _61_:Q w=1]]', 'B: [connection C706/B =>[signal: VSS w=1]]']]
** C706 _61_:Q VSS  C=0.0 [skipped because C=0]
** [instance C707 of CAPACITOR, params={'capacitance': 0.000470231 prefix:SIUnitPrefix.PICO} connections=['A: [connection C707/A =>[signal: mem[13]:8 w=1]]', 'B: [connection C707/B =>[signal: VSS w=1]]']]
C707 mem[13]:8 VSS  C=4.70231E-16
** [instance C708 of CAPACITOR, params={'capacitance': 0.000275878 prefix:SIUnitPrefix.PICO} connections=['A: [connection C708/A =>[signal: mem[13]:8 w=1]]', 'B: [connection C708/B =>[signal: mem[3]:40 w=1]]']]
C708 mem[13]:8 mem[3]:40  C=2.75878E-16
** [instance C709 of CAPACITOR, params={'capacitance': 0.000210375 prefix:SIUnitPrefix.PICO} connections=['A: [connection C709/A =>[signal: mem[13]:6 w=1]]', 'B: [connection C709/B =>[signal: VSS w=1]]']]
C709 mem[13]:6 VSS  C=2.10375E-16
** [instance C710 of CAPACITOR, params={'capacitance': 0.000100726 prefix:SIUnitPrefix.PICO} connections=['A: [connection C710/A =>[signal: hold16:A w=1]]', 'B: [connection C710/B =>[signal: hold20:A w=1]]']]
C710 hold16:A hold20:A  C=1.0072599999999999E-16
** [instance C711 of CAPACITOR, params={'capacitance': 0.000276949 prefix:SIUnitPrefix.PICO} connections=['A: [connection C711/A =>[signal: hold16:A w=1]]', 'B: [connection C711/B =>[signal: VSS w=1]]']]
C711 hold16:A VSS  C=2.7694900000000003E-16
** [instance C712 of CAPACITOR, params={'capacitance': 0.000114829 prefix:SIUnitPrefix.PICO} connections=['A: [connection C712/A =>[signal: hold16:A w=1]]', 'B: [connection C712/B =>[signal: net35:10 w=1]]']]
C712 hold16:A net35:10  C=1.14829E-16
** [instance C713 of CAPACITOR, params={'capacitance': 0.00020261 prefix:SIUnitPrefix.PICO} connections=['A: [connection C713/A =>[signal: _60_:Q w=1]]', 'B: [connection C713/B =>[signal: VSS w=1]]']]
C713 _60_:Q VSS  C=2.0261E-16
** [instance C714 of CAPACITOR, params={'capacitance': 0.000509509 prefix:SIUnitPrefix.PICO} connections=['A: [connection C714/A =>[signal: mem[14]:10 w=1]]', 'B: [connection C714/B =>[signal: VSS w=1]]']]
C714 mem[14]:10 VSS  C=5.09509E-16
** [instance C715 of CAPACITOR, params={'capacitance': 1.59099e-05 prefix:SIUnitPrefix.PICO} connections=['A: [connection C715/A =>[signal: mem[14]:10 w=1]]', 'B: [connection C715/B =>[signal: mem[3]:40 w=1]]']]
C715 mem[14]:10 mem[3]:40  C=1.5909900000000002E-17
** [instance C716 of CAPACITOR, params={'capacitance': 0.000126272 prefix:SIUnitPrefix.PICO} connections=['A: [connection C716/A =>[signal: mem[14]:10 w=1]]', 'B: [connection C716/B =>[signal: net13:31 w=1]]']]
C716 mem[14]:10 net13:31  C=1.26272E-16
** [instance C717 of CAPACITOR, params={'capacitance': 0.000962877 prefix:SIUnitPrefix.PICO} connections=['A: [connection C717/A =>[signal: _59_:Q w=1]]', 'B: [connection C717/B =>[signal: VSS w=1]]']]
C717 _59_:Q VSS  C=9.62877E-16
** [instance C718 of CAPACITOR, params={'capacitance': 0.000578295 prefix:SIUnitPrefix.PICO} connections=['A: [connection C718/A =>[signal: hold26:A w=1]]', 'B: [connection C718/B =>[signal: VSS w=1]]']]
C718 hold26:A VSS  C=5.782950000000001E-16
** [instance C719 of CAPACITOR, params={'capacitance': 0.000832177 prefix:SIUnitPrefix.PICO} connections=['A: [connection C719/A =>[signal: hold26:A w=1]]', 'B: [connection C719/B =>[signal: hold33:A w=1]]']]
C719 hold26:A hold33:A  C=8.32177E-16
** [instance C720 of CAPACITOR, params={'capacitance': 7.05979e-06 prefix:SIUnitPrefix.PICO} connections=['A: [connection C720/A =>[signal: _73_:Q w=1]]', 'B: [connection C720/B =>[signal: VSS w=1]]']]
C720 _73_:Q VSS  C=7.05979E-18
** [instance C721 of CAPACITOR, params={'capacitance': 0.000998875 prefix:SIUnitPrefix.PICO} connections=['A: [connection C721/A =>[signal: mem[1]:8 w=1]]', 'B: [connection C721/B =>[signal: VSS w=1]]']]
C721 mem[1]:8 VSS  C=9.988749999999999E-16
** [instance C722 of CAPACITOR, params={'capacitance': 0.0 prefix:SIUnitPrefix.PICO} connections=['A: [connection C722/A =>[signal: _75_:D w=1]]', 'B: [connection C722/B =>[signal: hold26:A w=1]]']]
** C722 _75_:D hold26:A  C=0.0 [skipped because C=0]
** [instance C723 of CAPACITOR, params={'capacitance': 0.000271673 prefix:SIUnitPrefix.PICO} connections=['A: [connection C723/A =>[signal: _75_:D w=1]]', 'B: [connection C723/B =>[signal: VSS w=1]]']]
C723 _75_:D VSS  C=2.71673E-16
** [instance C724 of CAPACITOR, params={'capacitance': 6.78055e-06 prefix:SIUnitPrefix.PICO} connections=['A: [connection C724/A =>[signal: _75_:D w=1]]', 'B: [connection C724/B =>[signal: net26:14 w=1]]']]
C724 _75_:D net26:14  C=6.78055E-18
** [instance C725 of CAPACITOR, params={'capacitance': 0.000130542 prefix:SIUnitPrefix.PICO} connections=['A: [connection C725/A =>[signal: hold30:A w=1]]', 'B: [connection C725/B =>[signal: VSS w=1]]']]
C725 hold30:A VSS  C=1.30542E-16
** [instance C726 of CAPACITOR, params={'capacitance': 3.63575e-05 prefix:SIUnitPrefix.PICO} connections=['A: [connection C726/A =>[signal: hold30:A w=1]]', 'B: [connection C726/B =>[signal: net12:46 w=1]]']]
C726 hold30:A net12:46  C=3.63575E-17
** [instance C727 of CAPACITOR, params={'capacitance': 9.83388e-05 prefix:SIUnitPrefix.PICO} connections=['A: [connection C727/A =>[signal: hold30:A w=1]]', 'B: [connection C727/B =>[signal: net12:57 w=1]]']]
C727 hold30:A net12:57  C=9.833879999999999E-17
** [instance C728 of CAPACITOR, params={'capacitance': 0.000104198 prefix:SIUnitPrefix.PICO} connections=['A: [connection C728/A =>[signal: _72_:Q w=1]]', 'B: [connection C728/B =>[signal: VSS w=1]]']]
C728 _72_:Q VSS  C=1.0419799999999999E-16
** [instance C729 of CAPACITOR, params={'capacitance': 0.000407665 prefix:SIUnitPrefix.PICO} connections=['A: [connection C729/A =>[signal: mem[2]:8 w=1]]', 'B: [connection C729/B =>[signal: VSS w=1]]']]
C729 mem[2]:8 VSS  C=4.07665E-16
** [instance C730 of CAPACITOR, params={'capacitance': 0.0 prefix:SIUnitPrefix.PICO} connections=['A: [connection C730/A =>[signal: mem[2]:8 w=1]]', 'B: [connection C730/B =>[signal: mem[3]:23 w=1]]']]
** C730 mem[2]:8 mem[3]:23  C=0.0 [skipped because C=0]
** [instance C731 of CAPACITOR, params={'capacitance': 3.37976e-05 prefix:SIUnitPrefix.PICO} connections=['A: [connection C731/A =>[signal: mem[2]:8 w=1]]', 'B: [connection C731/B =>[signal: mem[4]:8 w=1]]']]
C731 mem[2]:8 mem[4]:8  C=3.37976E-17
** [instance C732 of CAPACITOR, params={'capacitance': 0.0 prefix:SIUnitPrefix.PICO} connections=['A: [connection C732/A =>[signal: mem[2]:8 w=1]]', 'B: [connection C732/B =>[signal: net12:65 w=1]]']]
** C732 mem[2]:8 net12:65  C=0.0 [skipped because C=0]
** [instance C733 of CAPACITOR, params={'capacitance': 0.000316383 prefix:SIUnitPrefix.PICO} connections=['A: [connection C733/A =>[signal: _48_:A1 w=1]]', 'B: [connection C733/B =>[signal: hold30:A w=1]]']]
C733 _48_:A1 hold30:A  C=3.16383E-16
** [instance C734 of CAPACITOR, params={'capacitance': 0.000118339 prefix:SIUnitPrefix.PICO} connections=['A: [connection C734/A =>[signal: _48_:A1 w=1]]', 'B: [connection C734/B =>[signal: mem[5]:10 w=1]]']]
C734 _48_:A1 mem[5]:10  C=1.18339E-16
** [instance C735 of CAPACITOR, params={'capacitance': 7.67315e-05 prefix:SIUnitPrefix.PICO} connections=['A: [connection C735/A =>[signal: _48_:A1 w=1]]', 'B: [connection C735/B =>[signal: mem[6]:14 w=1]]']]
C735 _48_:A1 mem[6]:14  C=7.67315E-17
** [instance C736 of CAPACITOR, params={'capacitance': 0.000442962 prefix:SIUnitPrefix.PICO} connections=['A: [connection C736/A =>[signal: _48_:A1 w=1]]', 'B: [connection C736/B =>[signal: net12:46 w=1]]']]
C736 _48_:A1 net12:46  C=4.42962E-16
** [instance C737 of CAPACITOR, params={'capacitance': 0.000234425 prefix:SIUnitPrefix.PICO} connections=['A: [connection C737/A =>[signal: _48_:A1 w=1]]', 'B: [connection C737/B =>[signal: VSS w=1]]']]
C737 _48_:A1 VSS  C=2.34425E-16
** [instance C738 of CAPACITOR, params={'capacitance': 9.91086e-05 prefix:SIUnitPrefix.PICO} connections=['A: [connection C738/A =>[signal: _48_:A1 w=1]]', 'B: [connection C738/B =>[signal: net2:16 w=1]]']]
C738 _48_:A1 net2:16  C=9.91086E-17
** [instance C739 of CAPACITOR, params={'capacitance': 0.0 prefix:SIUnitPrefix.PICO} connections=['A: [connection C739/A =>[signal: hold36:A w=1]]', 'B: [connection C739/B =>[signal: VSS w=1]]']]
** C739 hold36:A VSS  C=0.0 [skipped because C=0]
** [instance C740 of CAPACITOR, params={'capacitance': 0.00010744 prefix:SIUnitPrefix.PICO} connections=['A: [connection C740/A =>[signal: _35_:A3 w=1]]', 'B: [connection C740/B =>[signal: VSS w=1]]']]
C740 _35_:A3 VSS  C=1.0744E-16
** [instance C741 of CAPACITOR, params={'capacitance': 3.08664e-05 prefix:SIUnitPrefix.PICO} connections=['A: [connection C741/A =>[signal: _35_:A3 w=1]]', 'B: [connection C741/B =>[signal: _35_:S1 w=1]]']]
C741 _35_:A3 _35_:S1  C=3.08664E-17
** [instance C742 of CAPACITOR, params={'capacitance': 0.00015422 prefix:SIUnitPrefix.PICO} connections=['A: [connection C742/A =>[signal: _71_:Q w=1]]', 'B: [connection C742/B =>[signal: VSS w=1]]']]
C742 _71_:Q VSS  C=1.5422E-16
** [instance C743 of CAPACITOR, params={'capacitance': 0.00139699 prefix:SIUnitPrefix.PICO} connections=['A: [connection C743/A =>[signal: mem[3]:40 w=1]]', 'B: [connection C743/B =>[signal: VSS w=1]]']]
C743 mem[3]:40 VSS  C=1.39699E-15
** [instance C744 of CAPACITOR, params={'capacitance': 0.000151333 prefix:SIUnitPrefix.PICO} connections=['A: [connection C744/A =>[signal: mem[3]:40 w=1]]', 'B: [connection C744/B =>[signal: net13:10 w=1]]']]
C744 mem[3]:40 net13:10  C=1.51333E-16
** [instance C745 of CAPACITOR, params={'capacitance': 0.000380625 prefix:SIUnitPrefix.PICO} connections=['A: [connection C745/A =>[signal: mem[3]:40 w=1]]', 'B: [connection C745/B =>[signal: net13:14 w=1]]']]
C745 mem[3]:40 net13:14  C=3.80625E-16
** [instance C746 of CAPACITOR, params={'capacitance': 0.0001724 prefix:SIUnitPrefix.PICO} connections=['A: [connection C746/A =>[signal: mem[3]:40 w=1]]', 'B: [connection C746/B =>[signal: net13:31 w=1]]']]
C746 mem[3]:40 net13:31  C=1.7239999999999998E-16
** [instance C747 of CAPACITOR, params={'capacitance': 3.08664e-05 prefix:SIUnitPrefix.PICO} connections=['A: [connection C747/A =>[signal: mem[3]:40 w=1]]', 'B: [connection C747/B =>[signal: net19:12 w=1]]']]
C747 mem[3]:40 net19:12  C=3.08664E-17
** [instance C748 of CAPACITOR, params={'capacitance': 0.0 prefix:SIUnitPrefix.PICO} connections=['A: [connection C748/A =>[signal: mem[3]:40 w=1]]', 'B: [connection C748/B =>[signal: net35:10 w=1]]']]
** C748 mem[3]:40 net35:10  C=0.0 [skipped because C=0]
** [instance C749 of CAPACITOR, params={'capacitance': 0.0017428 prefix:SIUnitPrefix.PICO} connections=['A: [connection C749/A =>[signal: mem[3]:23 w=1]]', 'B: [connection C749/B =>[signal: VSS w=1]]']]
C749 mem[3]:23 VSS  C=1.7428E-15
** [instance C750 of CAPACITOR, params={'capacitance': 0.000262407 prefix:SIUnitPrefix.PICO} connections=['A: [connection C750/A =>[signal: mem[3]:23 w=1]]', 'B: [connection C750/B =>[signal: net12:65 w=1]]']]
C750 mem[3]:23 net12:65  C=2.6240699999999996E-16
** [instance C751 of CAPACITOR, params={'capacitance': 0.000728544 prefix:SIUnitPrefix.PICO} connections=['A: [connection C751/A =>[signal: mem[3]:10 w=1]]', 'B: [connection C751/B =>[signal: VSS w=1]]']]
C751 mem[3]:10 VSS  C=7.28544E-16
** [instance C752 of CAPACITOR, params={'capacitance': 7.02104e-05 prefix:SIUnitPrefix.PICO} connections=['A: [connection C752/A =>[signal: _70_:Q w=1]]', 'B: [connection C752/B =>[signal: VSS w=1]]']]
C752 _70_:Q VSS  C=7.021039999999999E-17
** [instance C753 of CAPACITOR, params={'capacitance': 0.00189581 prefix:SIUnitPrefix.PICO} connections=['A: [connection C753/A =>[signal: mem[4]:8 w=1]]', 'B: [connection C753/B =>[signal: VSS w=1]]']]
C753 mem[4]:8 VSS  C=1.89581E-15
** [instance C754 of CAPACITOR, params={'capacitance': 5.33005e-05 prefix:SIUnitPrefix.PICO} connections=['A: [connection C754/A =>[signal: _35_:S1 w=1]]', 'B: [connection C754/B =>[signal: _36_:A0 w=1]]']]
C754 _35_:S1 _36_:A0  C=5.33005E-17
** [instance C755 of CAPACITOR, params={'capacitance': 5.52302e-05 prefix:SIUnitPrefix.PICO} connections=['A: [connection C755/A =>[signal: _35_:S1 w=1]]', 'B: [connection C755/B =>[signal: _36_:A1 w=1]]']]
C755 _35_:S1 _36_:A1  C=5.5230199999999994E-17
** [instance C756 of CAPACITOR, params={'capacitance': 0.000121931 prefix:SIUnitPrefix.PICO} connections=['A: [connection C756/A =>[signal: _35_:S1 w=1]]', 'B: [connection C756/B =>[signal: mem[5]:26 w=1]]']]
C756 _35_:S1 mem[5]:26  C=1.2193099999999998E-16
** [instance C757 of CAPACITOR, params={'capacitance': 0.000559628 prefix:SIUnitPrefix.PICO} connections=['A: [connection C757/A =>[signal: _35_:S1 w=1]]', 'B: [connection C757/B =>[signal: VSS w=1]]']]
C757 _35_:S1 VSS  C=5.5962799999999995E-16
** [instance C758 of CAPACITOR, params={'capacitance': 1.89507e-06 prefix:SIUnitPrefix.PICO} connections=['A: [connection C758/A =>[signal: _57_:A1 w=1]]', 'B: [connection C758/B =>[signal: hold33:A w=1]]']]
C758 _57_:A1 hold33:A  C=1.89507E-18
** [instance C759 of CAPACITOR, params={'capacitance': 5.52302e-05 prefix:SIUnitPrefix.PICO} connections=['A: [connection C759/A =>[signal: _57_:A1 w=1]]', 'B: [connection C759/B =>[signal: _57_:S w=1]]']]
C759 _57_:A1 _57_:S  C=5.5230199999999994E-17
** [instance C760 of CAPACITOR, params={'capacitance': 7.57374e-05 prefix:SIUnitPrefix.PICO} connections=['A: [connection C760/A =>[signal: _57_:A1 w=1]]', 'B: [connection C760/B =>[signal: _75_:D w=1]]']]
C760 _57_:A1 _75_:D  C=7.57374E-17
** [instance C761 of CAPACITOR, params={'capacitance': 6.57815e-05 prefix:SIUnitPrefix.PICO} connections=['A: [connection C761/A =>[signal: _57_:A1 w=1]]', 'B: [connection C761/B =>[signal: net33:8 w=1]]']]
C761 _57_:A1 net33:8  C=6.57815E-17
** [instance C762 of CAPACITOR, params={'capacitance': 0.000305119 prefix:SIUnitPrefix.PICO} connections=['A: [connection C762/A =>[signal: _57_:A1 w=1]]', 'B: [connection C762/B =>[signal: VSS w=1]]']]
C762 _57_:A1 VSS  C=3.05119E-16
** [instance C763 of CAPACITOR, params={'capacitance': 2.36623e-05 prefix:SIUnitPrefix.PICO} connections=['A: [connection C763/A =>[signal: _36_:A1 w=1]]', 'B: [connection C763/B =>[signal: VSS w=1]]']]
C763 _36_:A1 VSS  C=2.3662299999999998E-17
** [instance C764 of CAPACITOR, params={'capacitance': 0.0 prefix:SIUnitPrefix.PICO} connections=['A: [connection C764/A =>[signal: hold35:A w=1]]', 'B: [connection C764/B =>[signal: VSS w=1]]']]
** C764 hold35:A VSS  C=0.0 [skipped because C=0]
** [instance C765 of CAPACITOR, params={'capacitance': 0.000425003 prefix:SIUnitPrefix.PICO} connections=['A: [connection C765/A =>[signal: _69_:Q w=1]]', 'B: [connection C765/B =>[signal: VSS w=1]]']]
C765 _69_:Q VSS  C=4.25003E-16
** [instance C766 of CAPACITOR, params={'capacitance': 0.00113142 prefix:SIUnitPrefix.PICO} connections=['A: [connection C766/A =>[signal: mem[5]:26 w=1]]', 'B: [connection C766/B =>[signal: VSS w=1]]']]
C766 mem[5]:26 VSS  C=1.13142E-15
** [instance C767 of CAPACITOR, params={'capacitance': 9.41642e-05 prefix:SIUnitPrefix.PICO} connections=['A: [connection C767/A =>[signal: mem[5]:26 w=1]]', 'B: [connection C767/B =>[signal: mem[6]:18 w=1]]']]
C767 mem[5]:26 mem[6]:18  C=9.416420000000001E-17
** [instance C768 of CAPACITOR, params={'capacitance': 5.88598e-05 prefix:SIUnitPrefix.PICO} connections=['A: [connection C768/A =>[signal: mem[5]:26 w=1]]', 'B: [connection C768/B =>[signal: net1:10 w=1]]']]
C768 mem[5]:26 net1:10  C=5.88598E-17
** [instance C769 of CAPACITOR, params={'capacitance': 0.000317609 prefix:SIUnitPrefix.PICO} connections=['A: [connection C769/A =>[signal: mem[5]:26 w=1]]', 'B: [connection C769/B =>[signal: net14:10 w=1]]']]
C769 mem[5]:26 net14:10  C=3.17609E-16
** [instance C770 of CAPACITOR, params={'capacitance': 0.00158009 prefix:SIUnitPrefix.PICO} connections=['A: [connection C770/A =>[signal: mem[5]:10 w=1]]', 'B: [connection C770/B =>[signal: VSS w=1]]']]
C770 mem[5]:10 VSS  C=1.5800899999999998E-15
** [instance C771 of CAPACITOR, params={'capacitance': 0.0 prefix:SIUnitPrefix.PICO} connections=['A: [connection C771/A =>[signal: mem[5]:10 w=1]]', 'B: [connection C771/B =>[signal: mem[6]:14 w=1]]']]
** C771 mem[5]:10 mem[6]:14  C=0.0 [skipped because C=0]
** [instance C772 of CAPACITOR, params={'capacitance': 9.34004e-05 prefix:SIUnitPrefix.PICO} connections=['A: [connection C772/A =>[signal: fanout12:A w=1]]', 'B: [connection C772/B =>[signal: mem[5]:26 w=1]]']]
C772 fanout12:A mem[5]:26  C=9.340039999999999E-17
** [instance C773 of CAPACITOR, params={'capacitance': 0.0 prefix:SIUnitPrefix.PICO} connections=['A: [connection C773/A =>[signal: fanout12:A w=1]]', 'B: [connection C773/B =>[signal: hold18:A w=1]]']]
** C773 fanout12:A hold18:A  C=0.0 [skipped because C=0]
** [instance C774 of CAPACITOR, params={'capacitance': 0.000362545 prefix:SIUnitPrefix.PICO} connections=['A: [connection C774/A =>[signal: fanout12:A w=1]]', 'B: [connection C774/B =>[signal: net1:10 w=1]]']]
C774 fanout12:A net1:10  C=3.6254499999999996E-16
** [instance C775 of CAPACITOR, params={'capacitance': 0.000162528 prefix:SIUnitPrefix.PICO} connections=['A: [connection C775/A =>[signal: fanout12:A w=1]]', 'B: [connection C775/B =>[signal: VSS w=1]]']]
C775 fanout12:A VSS  C=1.62528E-16
** [instance C776 of CAPACITOR, params={'capacitance': 0.00109723 prefix:SIUnitPrefix.PICO} connections=['A: [connection C776/A =>[signal: hold18:A w=1]]', 'B: [connection C776/B =>[signal: mem[5]:26 w=1]]']]
C776 hold18:A mem[5]:26  C=1.09723E-15
** [instance C777 of CAPACITOR, params={'capacitance': 0.000909193 prefix:SIUnitPrefix.PICO} connections=['A: [connection C777/A =>[signal: hold18:A w=1]]', 'B: [connection C777/B =>[signal: VSS w=1]]']]
C777 hold18:A VSS  C=9.09193E-16
** [instance C778 of CAPACITOR, params={'capacitance': 0.000119125 prefix:SIUnitPrefix.PICO} connections=['A: [connection C778/A =>[signal: hold18:A w=1]]', 'B: [connection C778/B =>[signal: net1:10 w=1]]']]
C778 hold18:A net1:10  C=1.19125E-16
** [instance C779 of CAPACITOR, params={'capacitance': 6.44449e-05 prefix:SIUnitPrefix.PICO} connections=['A: [connection C779/A =>[signal: hold18:A w=1]]', 'B: [connection C779/B =>[signal: net12:8 w=1]]']]
C779 hold18:A net12:8  C=6.44449E-17
** [instance C780 of CAPACITOR, params={'capacitance': 1.8191e-05 prefix:SIUnitPrefix.PICO} connections=['A: [connection C780/A =>[signal: hold18:A w=1]]', 'B: [connection C780/B =>[signal: net12:16 w=1]]']]
C780 hold18:A net12:16  C=1.8190999999999998E-17
** [instance C781 of CAPACITOR, params={'capacitance': 0.000319323 prefix:SIUnitPrefix.PICO} connections=['A: [connection C781/A =>[signal: hold18:A w=1]]', 'B: [connection C781/B =>[signal: net14:10 w=1]]']]
C781 hold18:A net14:10  C=3.19323E-16
** [instance C782 of CAPACITOR, params={'capacitance': 0.000225609 prefix:SIUnitPrefix.PICO} connections=['A: [connection C782/A =>[signal: hold18:A w=1]]', 'B: [connection C782/B =>[signal: net19:12 w=1]]']]
C782 hold18:A net19:12  C=2.2560899999999996E-16
** [instance C783 of CAPACITOR, params={'capacitance': 0.00035452 prefix:SIUnitPrefix.PICO} connections=['A: [connection C783/A =>[signal: hold37:A w=1]]', 'B: [connection C783/B =>[signal: mem[5]:26 w=1]]']]
C783 hold37:A mem[5]:26  C=3.5452E-16
** [instance C784 of CAPACITOR, params={'capacitance': 0.00111887 prefix:SIUnitPrefix.PICO} connections=['A: [connection C784/A =>[signal: hold37:A w=1]]', 'B: [connection C784/B =>[signal: VSS w=1]]']]
C784 hold37:A VSS  C=1.1188700000000002E-15
** [instance C785 of CAPACITOR, params={'capacitance': 0.000927134 prefix:SIUnitPrefix.PICO} connections=['A: [connection C785/A =>[signal: hold37:A w=1]]', 'B: [connection C785/B =>[signal: net1:10 w=1]]']]
C785 hold37:A net1:10  C=9.27134E-16
** [instance C786 of CAPACITOR, params={'capacitance': 0.000194492 prefix:SIUnitPrefix.PICO} connections=['A: [connection C786/A =>[signal: hold37:A w=1]]', 'B: [connection C786/B =>[signal: net2:16 w=1]]']]
C786 hold37:A net2:16  C=1.94492E-16
** [instance C787 of CAPACITOR, params={'capacitance': 5.60962e-05 prefix:SIUnitPrefix.PICO} connections=['A: [connection C787/A =>[signal: hold37:A w=1]]', 'B: [connection C787/B =>[signal: net35:10 w=1]]']]
C787 hold37:A net35:10  C=5.60962E-17
** [instance C788 of CAPACITOR, params={'capacitance': 0.000195808 prefix:SIUnitPrefix.PICO} connections=['A: [connection C788/A =>[signal: hold37:A w=1]]', 'B: [connection C788/B =>[signal: net36:14 w=1]]']]
C788 hold37:A net36:14  C=1.95808E-16
** [instance C789 of CAPACITOR, params={'capacitance': 0.0 prefix:SIUnitPrefix.PICO} connections=['A: [connection C789/A =>[signal: _36_:A2 w=1]]', 'B: [connection C789/B =>[signal: VSS w=1]]']]
** C789 _36_:A2 VSS  C=0.0 [skipped because C=0]
** [instance C790 of CAPACITOR, params={'capacitance': 0.000823015 prefix:SIUnitPrefix.PICO} connections=['A: [connection C790/A =>[signal: _68_:Q w=1]]', 'B: [connection C790/B =>[signal: VSS w=1]]']]
C790 _68_:Q VSS  C=8.230149999999999E-16
** [instance C791 of CAPACITOR, params={'capacitance': 0.000183807 prefix:SIUnitPrefix.PICO} connections=['A: [connection C791/A =>[signal: mem[6]:18 w=1]]', 'B: [connection C791/B =>[signal: VSS w=1]]']]
C791 mem[6]:18 VSS  C=1.83807E-16
** [instance C792 of CAPACITOR, params={'capacitance': 0.00196844 prefix:SIUnitPrefix.PICO} connections=['A: [connection C792/A =>[signal: mem[6]:14 w=1]]', 'B: [connection C792/B =>[signal: VSS w=1]]']]
C792 mem[6]:14 VSS  C=1.96844E-15
** [instance C793 of CAPACITOR, params={'capacitance': 4.46186e-06 prefix:SIUnitPrefix.PICO} connections=['A: [connection C793/A =>[signal: mem[6]:14 w=1]]', 'B: [connection C793/B =>[signal: net2:16 w=1]]']]
C793 mem[6]:14 net2:16  C=4.46186E-18
** [instance C794 of CAPACITOR, params={'capacitance': 0.00023761 prefix:SIUnitPrefix.PICO} connections=['A: [connection C794/A =>[signal: _67_:Q w=1]]', 'B: [connection C794/B =>[signal: VSS w=1]]']]
C794 _67_:Q VSS  C=2.3761E-16
** [instance C795 of CAPACITOR, params={'capacitance': 0.00129786 prefix:SIUnitPrefix.PICO} connections=['A: [connection C795/A =>[signal: mem[7]:10 w=1]]', 'B: [connection C795/B =>[signal: VSS w=1]]']]
C795 mem[7]:10 VSS  C=1.29786E-15
** [instance C796 of CAPACITOR, params={'capacitance': 0.000139907 prefix:SIUnitPrefix.PICO} connections=['A: [connection C796/A =>[signal: mem[7]:10 w=1]]', 'B: [connection C796/B =>[signal: net12:46 w=1]]']]
C796 mem[7]:10 net12:46  C=1.3990699999999999E-16
** [instance C797 of CAPACITOR, params={'capacitance': 0.000173414 prefix:SIUnitPrefix.PICO} connections=['A: [connection C797/A =>[signal: hold29:A w=1]]', 'B: [connection C797/B =>[signal: VSS w=1]]']]
C797 hold29:A VSS  C=1.7341399999999999E-16
** [instance C798 of CAPACITOR, params={'capacitance': 4.90803e-05 prefix:SIUnitPrefix.PICO} connections=['A: [connection C798/A =>[signal: hold29:A w=1]]', 'B: [connection C798/B =>[signal: net23:10 w=1]]']]
C798 hold29:A net23:10  C=4.9080299999999996E-17
** [instance C799 of CAPACITOR, params={'capacitance': 3.78891e-05 prefix:SIUnitPrefix.PICO} connections=['A: [connection C799/A =>[signal: _31_:A0 w=1]]', 'B: [connection C799/B =>[signal: VSS w=1]]']]
C799 _31_:A0 VSS  C=3.78891E-17
** [instance C800 of CAPACITOR, params={'capacitance': 2.29097e-05 prefix:SIUnitPrefix.PICO} connections=['A: [connection C800/A =>[signal: _31_:A0 w=1]]', 'B: [connection C800/B =>[signal: _33_:S0 w=1]]']]
C800 _31_:A0 _33_:S0  C=2.2909699999999998E-17
** [instance C801 of CAPACITOR, params={'capacitance': 0.000680674 prefix:SIUnitPrefix.PICO} connections=['A: [connection C801/A =>[signal: _66_:Q w=1]]', 'B: [connection C801/B =>[signal: VSS w=1]]']]
C801 _66_:Q VSS  C=6.80674E-16
** [instance C802 of CAPACITOR, params={'capacitance': 0.000891977 prefix:SIUnitPrefix.PICO} connections=['A: [connection C802/A =>[signal: mem[8]:10 w=1]]', 'B: [connection C802/B =>[signal: VSS w=1]]']]
C802 mem[8]:10 VSS  C=8.919769999999999E-16
** [instance C803 of CAPACITOR, params={'capacitance': 9.91973e-05 prefix:SIUnitPrefix.PICO} connections=['A: [connection C803/A =>[signal: mem[8]:10 w=1]]', 'B: [connection C803/B =>[signal: mem[9]:10 w=1]]']]
C803 mem[8]:10 mem[9]:10  C=9.91973E-17
** [instance C804 of CAPACITOR, params={'capacitance': 1.13019e-05 prefix:SIUnitPrefix.PICO} connections=['A: [connection C804/A =>[signal: mem[8]:10 w=1]]', 'B: [connection C804/B =>[signal: net36:14 w=1]]']]
C804 mem[8]:10 net36:14  C=1.1301899999999998E-17
** [instance C805 of CAPACITOR, params={'capacitance': 0.000285015 prefix:SIUnitPrefix.PICO} connections=['A: [connection C805/A =>[signal: hold31:A w=1]]', 'B: [connection C805/B =>[signal: VSS w=1]]']]
C805 hold31:A VSS  C=2.85015E-16
** [instance C806 of CAPACITOR, params={'capacitance': 0.0 prefix:SIUnitPrefix.PICO} connections=['A: [connection C806/A =>[signal: _31_:A1 w=1]]', 'B: [connection C806/B =>[signal: VSS w=1]]']]
** C806 _31_:A1 VSS  C=0.0 [skipped because C=0]
** [instance C807 of CAPACITOR, params={'capacitance': 0.000471211 prefix:SIUnitPrefix.PICO} connections=['A: [connection C807/A =>[signal: _65_:Q w=1]]', 'B: [connection C807/B =>[signal: VSS w=1]]']]
C807 _65_:Q VSS  C=4.71211E-16
** [instance C808 of CAPACITOR, params={'capacitance': 0.000986639 prefix:SIUnitPrefix.PICO} connections=['A: [connection C808/A =>[signal: mem[9]:23 w=1]]', 'B: [connection C808/B =>[signal: VSS w=1]]']]
C808 mem[9]:23 VSS  C=9.86639E-16
** [instance C809 of CAPACITOR, params={'capacitance': 4.40513e-06 prefix:SIUnitPrefix.PICO} connections=['A: [connection C809/A =>[signal: mem[9]:23 w=1]]', 'B: [connection C809/B =>[signal: net18:10 w=1]]']]
C809 mem[9]:23 net18:10  C=4.40513E-18
** [instance C810 of CAPACITOR, params={'capacitance': 0.000985814 prefix:SIUnitPrefix.PICO} connections=['A: [connection C810/A =>[signal: mem[9]:10 w=1]]', 'B: [connection C810/B =>[signal: VSS w=1]]']]
C810 mem[9]:10 VSS  C=9.85814E-16
** [instance C811 of CAPACITOR, params={'capacitance': 0.000172056 prefix:SIUnitPrefix.PICO} connections=['A: [connection C811/A =>[signal: mem[9]:10 w=1]]', 'B: [connection C811/B =>[signal: net18:10 w=1]]']]
C811 mem[9]:10 net18:10  C=1.7205599999999998E-16
** [instance C812 of CAPACITOR, params={'capacitance': 0.000126638 prefix:SIUnitPrefix.PICO} connections=['A: [connection C812/A =>[signal: _35_:S0 w=1]]', 'B: [connection C812/B =>[signal: VSS w=1]]']]
C812 _35_:S0 VSS  C=1.26638E-16
** [instance C813 of CAPACITOR, params={'capacitance': 0.00019933 prefix:SIUnitPrefix.PICO} connections=['A: [connection C813/A =>[signal: _35_:S0 w=1]]', 'B: [connection C813/B =>[signal: _35_:S1 w=1]]']]
C813 _35_:S0 _35_:S1  C=1.9933E-16
** [instance C814 of CAPACITOR, params={'capacitance': 0.000324844 prefix:SIUnitPrefix.PICO} connections=['A: [connection C814/A =>[signal: _31_:S0 w=1]]', 'B: [connection C814/B =>[signal: VSS w=1]]']]
C814 _31_:S0 VSS  C=3.2484400000000004E-16
** [instance C815 of CAPACITOR, params={'capacitance': 0.000618107 prefix:SIUnitPrefix.PICO} connections=['A: [connection C815/A =>[signal: input1:X w=1]]', 'B: [connection C815/B =>[signal: VSS w=1]]']]
C815 input1:X VSS  C=6.181069999999999E-16
** [instance C816 of CAPACITOR, params={'capacitance': 0.000927709 prefix:SIUnitPrefix.PICO} connections=['A: [connection C816/A =>[signal: net1:10 w=1]]', 'B: [connection C816/B =>[signal: VSS w=1]]']]
C816 net1:10 VSS  C=9.27709E-16
** [instance C817 of CAPACITOR, params={'capacitance': 6.78942e-05 prefix:SIUnitPrefix.PICO} connections=['A: [connection C817/A =>[signal: net1:10 w=1]]', 'B: [connection C817/B =>[signal: net19:12 w=1]]']]
C817 net1:10 net19:12  C=6.78942E-17
** [instance C818 of CAPACITOR, params={'capacitance': 6.22145e-05 prefix:SIUnitPrefix.PICO} connections=['A: [connection C818/A =>[signal: net1:10 w=1]]', 'B: [connection C818/B =>[signal: net36:14 w=1]]']]
C818 net1:10 net36:14  C=6.221450000000001E-17
** [instance C819 of CAPACITOR, params={'capacitance': 0.0 prefix:SIUnitPrefix.PICO} connections=['A: [connection C819/A =>[signal: output10:A w=1]]', 'B: [connection C819/B =>[signal: VSS w=1]]']]
** C819 output10:A VSS  C=0.0 [skipped because C=0]
** [instance C820 of CAPACITOR, params={'capacitance': 0.00104205 prefix:SIUnitPrefix.PICO} connections=['A: [connection C820/A =>[signal: _77_:Q w=1]]', 'B: [connection C820/B =>[signal: VSS w=1]]']]
C820 _77_:Q VSS  C=1.04205E-15
** [instance C821 of CAPACITOR, params={'capacitance': 0.000109972 prefix:SIUnitPrefix.PICO} connections=['A: [connection C821/A =>[signal: output11:A w=1]]', 'B: [connection C821/B =>[signal: VSS w=1]]']]
C821 output11:A VSS  C=1.09972E-16
** [instance C822 of CAPACITOR, params={'capacitance': 4.26984e-05 prefix:SIUnitPrefix.PICO} connections=['A: [connection C822/A =>[signal: _40_:S w=1]]', 'B: [connection C822/B =>[signal: VSS w=1]]']]
C822 _40_:S VSS  C=4.2698399999999995E-17
** [instance C823 of CAPACITOR, params={'capacitance': 0.000169349 prefix:SIUnitPrefix.PICO} connections=['A: [connection C823/A =>[signal: _76_:Q w=1]]', 'B: [connection C823/B =>[signal: VSS w=1]]']]
C823 _76_:Q VSS  C=1.6934900000000001E-16
** [instance C824 of CAPACITOR, params={'capacitance': 1.16062e-05 prefix:SIUnitPrefix.PICO} connections=['A: [connection C824/A =>[signal: _46_:S w=1]]', 'B: [connection C824/B =>[signal: VSS w=1]]']]
C824 _46_:S VSS  C=1.16062E-17
** [instance C825 of CAPACITOR, params={'capacitance': 5.52302e-05 prefix:SIUnitPrefix.PICO} connections=['A: [connection C825/A =>[signal: _46_:S w=1]]', 'B: [connection C825/B =>[signal: net29:14 w=1]]']]
C825 _46_:S net29:14  C=5.5230199999999994E-17
** [instance C826 of CAPACITOR, params={'capacitance': 0.000168957 prefix:SIUnitPrefix.PICO} connections=['A: [connection C826/A =>[signal: _47_:S w=1]]', 'B: [connection C826/B =>[signal: VSS w=1]]']]
C826 _47_:S VSS  C=1.6895699999999999E-16
** [instance C827 of CAPACITOR, params={'capacitance': 0.000135028 prefix:SIUnitPrefix.PICO} connections=['A: [connection C827/A =>[signal: _47_:S w=1]]', 'B: [connection C827/B =>[signal: net29:14 w=1]]']]
C827 _47_:S net29:14  C=1.35028E-16
** [instance C828 of CAPACITOR, params={'capacitance': 6.95605e-05 prefix:SIUnitPrefix.PICO} connections=['A: [connection C828/A =>[signal: _53_:S w=1]]', 'B: [connection C828/B =>[signal: VSS w=1]]']]
C828 _53_:S VSS  C=6.95605E-17
** [instance C829 of CAPACITOR, params={'capacitance': 0.0 prefix:SIUnitPrefix.PICO} connections=['A: [connection C829/A =>[signal: _49_:S w=1]]', 'B: [connection C829/B =>[signal: VSS w=1]]']]
** C829 _49_:S VSS  C=0.0 [skipped because C=0]
** [instance C830 of CAPACITOR, params={'capacitance': 0.0 prefix:SIUnitPrefix.PICO} connections=['A: [connection C830/A =>[signal: _52_:S w=1]]', 'B: [connection C830/B =>[signal: VSS w=1]]']]
** C830 _52_:S VSS  C=0.0 [skipped because C=0]
** [instance C831 of CAPACITOR, params={'capacitance': 4.67764e-05 prefix:SIUnitPrefix.PICO} connections=['A: [connection C831/A =>[signal: _51_:S w=1]]', 'B: [connection C831/B =>[signal: VSS w=1]]']]
C831 _51_:S VSS  C=4.67764E-17
** [instance C832 of CAPACITOR, params={'capacitance': 0.0 prefix:SIUnitPrefix.PICO} connections=['A: [connection C832/A =>[signal: _48_:S w=1]]', 'B: [connection C832/B =>[signal: VSS w=1]]']]
** C832 _48_:S VSS  C=0.0 [skipped because C=0]
** [instance C833 of CAPACITOR, params={'capacitance': 0.000198184 prefix:SIUnitPrefix.PICO} connections=['A: [connection C833/A =>[signal: fanout12:X w=1]]', 'B: [connection C833/B =>[signal: VSS w=1]]']]
C833 fanout12:X VSS  C=1.9818400000000002E-16
** [instance C834 of CAPACITOR, params={'capacitance': 0.00081155 prefix:SIUnitPrefix.PICO} connections=['A: [connection C834/A =>[signal: net12:103 w=1]]', 'B: [connection C834/B =>[signal: VSS w=1]]']]
C834 net12:103 VSS  C=8.115499999999999E-16
** [instance C835 of CAPACITOR, params={'capacitance': 0.000150618 prefix:SIUnitPrefix.PICO} connections=['A: [connection C835/A =>[signal: net12:103 w=1]]', 'B: [connection C835/B =>[signal: net13:35 w=1]]']]
C835 net12:103 net13:35  C=1.5061799999999999E-16
** [instance C836 of CAPACITOR, params={'capacitance': 0.000884545 prefix:SIUnitPrefix.PICO} connections=['A: [connection C836/A =>[signal: net12:65 w=1]]', 'B: [connection C836/B =>[signal: VSS w=1]]']]
C836 net12:65 VSS  C=8.845450000000001E-16
** [instance C837 of CAPACITOR, params={'capacitance': 0.00112092 prefix:SIUnitPrefix.PICO} connections=['A: [connection C837/A =>[signal: net12:57 w=1]]', 'B: [connection C837/B =>[signal: VSS w=1]]']]
C837 net12:57 VSS  C=1.12092E-15
** [instance C838 of CAPACITOR, params={'capacitance': 0.000934919 prefix:SIUnitPrefix.PICO} connections=['A: [connection C838/A =>[signal: net12:46 w=1]]', 'B: [connection C838/B =>[signal: VSS w=1]]']]
C838 net12:46 VSS  C=9.34919E-16
** [instance C839 of CAPACITOR, params={'capacitance': 0.000838408 prefix:SIUnitPrefix.PICO} connections=['A: [connection C839/A =>[signal: net12:32 w=1]]', 'B: [connection C839/B =>[signal: VSS w=1]]']]
C839 net12:32 VSS  C=8.38408E-16
** [instance C840 of CAPACITOR, params={'capacitance': 0.000363801 prefix:SIUnitPrefix.PICO} connections=['A: [connection C840/A =>[signal: net12:26 w=1]]', 'B: [connection C840/B =>[signal: VSS w=1]]']]
C840 net12:26 VSS  C=3.6380100000000003E-16
** [instance C841 of CAPACITOR, params={'capacitance': 1.34741e-05 prefix:SIUnitPrefix.PICO} connections=['A: [connection C841/A =>[signal: net12:26 w=1]]', 'B: [connection C841/B =>[signal: net29:14 w=1]]']]
C841 net12:26 net29:14  C=1.34741E-17
** [instance C842 of CAPACITOR, params={'capacitance': 0.000550142 prefix:SIUnitPrefix.PICO} connections=['A: [connection C842/A =>[signal: net12:22 w=1]]', 'B: [connection C842/B =>[signal: VSS w=1]]']]
C842 net12:22 VSS  C=5.501419999999999E-16
** [instance C843 of CAPACITOR, params={'capacitance': 0.000192103 prefix:SIUnitPrefix.PICO} connections=['A: [connection C843/A =>[signal: net12:22 w=1]]', 'B: [connection C843/B =>[signal: net19:12 w=1]]']]
C843 net12:22 net19:12  C=1.92103E-16
** [instance C844 of CAPACITOR, params={'capacitance': 0.000544456 prefix:SIUnitPrefix.PICO} connections=['A: [connection C844/A =>[signal: net12:22 w=1]]', 'B: [connection C844/B =>[signal: net29:14 w=1]]']]
C844 net12:22 net29:14  C=5.44456E-16
** [instance C845 of CAPACITOR, params={'capacitance': 0.000549162 prefix:SIUnitPrefix.PICO} connections=['A: [connection C845/A =>[signal: net12:16 w=1]]', 'B: [connection C845/B =>[signal: VSS w=1]]']]
C845 net12:16 VSS  C=5.49162E-16
** [instance C846 of CAPACITOR, params={'capacitance': 0.000301904 prefix:SIUnitPrefix.PICO} connections=['A: [connection C846/A =>[signal: net12:8 w=1]]', 'B: [connection C846/B =>[signal: VSS w=1]]']]
C846 net12:8 VSS  C=3.0190399999999996E-16
** [instance C847 of CAPACITOR, params={'capacitance': 0.0 prefix:SIUnitPrefix.PICO} connections=['A: [connection C847/A =>[signal: net12:8 w=1]]', 'B: [connection C847/B =>[signal: net19:12 w=1]]']]
** C847 net12:8 net19:12  C=0.0 [skipped because C=0]
** [instance C848 of CAPACITOR, params={'capacitance': 9.41642e-05 prefix:SIUnitPrefix.PICO} connections=['A: [connection C848/A =>[signal: _45_:A0 w=1]]', 'B: [connection C848/B =>[signal: _45_:S w=1]]']]
C848 _45_:A0 _45_:S  C=9.416420000000001E-17
** [instance C849 of CAPACITOR, params={'capacitance': 0.000426049 prefix:SIUnitPrefix.PICO} connections=['A: [connection C849/A =>[signal: _45_:A0 w=1]]', 'B: [connection C849/B =>[signal: VSS w=1]]']]
C849 _45_:A0 VSS  C=4.26049E-16
** [instance C850 of CAPACITOR, params={'capacitance': 0.000102593 prefix:SIUnitPrefix.PICO} connections=['A: [connection C850/A =>[signal: _45_:A0 w=1]]', 'B: [connection C850/B =>[signal: net29:14 w=1]]']]
C850 _45_:A0 net29:14  C=1.02593E-16
** [instance C851 of CAPACITOR, params={'capacitance': 0.000103977 prefix:SIUnitPrefix.PICO} connections=['A: [connection C851/A =>[signal: _45_:A1 w=1]]', 'B: [connection C851/B =>[signal: _45_:S w=1]]']]
C851 _45_:A1 _45_:S  C=1.03977E-16
** [instance C852 of CAPACITOR, params={'capacitance': 7.05282e-05 prefix:SIUnitPrefix.PICO} connections=['A: [connection C852/A =>[signal: _45_:A1 w=1]]', 'B: [connection C852/B =>[signal: VSS w=1]]']]
C852 _45_:A1 VSS  C=7.05282E-17
** [instance C853 of CAPACITOR, params={'capacitance': 0.000219711 prefix:SIUnitPrefix.PICO} connections=['A: [connection C853/A =>[signal: _45_:A1 w=1]]', 'B: [connection C853/B =>[signal: net29:14 w=1]]']]
C853 _45_:A1 net29:14  C=2.1971100000000002E-16
** [instance C854 of CAPACITOR, params={'capacitance': 5.52302e-05 prefix:SIUnitPrefix.PICO} connections=['A: [connection C854/A =>[signal: _46_:A0 w=1]]', 'B: [connection C854/B =>[signal: _46_:S w=1]]']]
C854 _46_:A0 _46_:S  C=5.5230199999999994E-17
** [instance C855 of CAPACITOR, params={'capacitance': 9.71197e-05 prefix:SIUnitPrefix.PICO} connections=['A: [connection C855/A =>[signal: _46_:A0 w=1]]', 'B: [connection C855/B =>[signal: net12:22 w=1]]']]
C855 _46_:A0 net12:22  C=9.711969999999999E-17
** [instance C856 of CAPACITOR, params={'capacitance': 7.73135e-05 prefix:SIUnitPrefix.PICO} connections=['A: [connection C856/A =>[signal: _46_:A0 w=1]]', 'B: [connection C856/B =>[signal: VSS w=1]]']]
C856 _46_:A0 VSS  C=7.73135E-17
** [instance C857 of CAPACITOR, params={'capacitance': 8.12055e-05 prefix:SIUnitPrefix.PICO} connections=['A: [connection C857/A =>[signal: _46_:A0 w=1]]', 'B: [connection C857/B =>[signal: net29:14 w=1]]']]
C857 _46_:A0 net29:14  C=8.12055E-17
** [instance C858 of CAPACITOR, params={'capacitance': 5.50052e-05 prefix:SIUnitPrefix.PICO} connections=['A: [connection C858/A =>[signal: _47_:A1 w=1]]', 'B: [connection C858/B =>[signal: _47_:S w=1]]']]
C858 _47_:A1 _47_:S  C=5.50052E-17
** [instance C859 of CAPACITOR, params={'capacitance': 1.99614e-05 prefix:SIUnitPrefix.PICO} connections=['A: [connection C859/A =>[signal: _47_:A1 w=1]]', 'B: [connection C859/B =>[signal: VSS w=1]]']]
C859 _47_:A1 VSS  C=1.99614E-17
** [instance C860 of CAPACITOR, params={'capacitance': 0.000200973 prefix:SIUnitPrefix.PICO} connections=['A: [connection C860/A =>[signal: _58_:S w=1]]', 'B: [connection C860/B =>[signal: VSS w=1]]']]
C860 _58_:S VSS  C=2.00973E-16
** [instance C861 of CAPACITOR, params={'capacitance': 0.0 prefix:SIUnitPrefix.PICO} connections=['A: [connection C861/A =>[signal: _41_:S w=1]]', 'B: [connection C861/B =>[signal: VSS w=1]]']]
** C861 _41_:S VSS  C=0.0 [skipped because C=0]
** [instance C862 of CAPACITOR, params={'capacitance': 0.0 prefix:SIUnitPrefix.PICO} connections=['A: [connection C862/A =>[signal: _42_:S w=1]]', 'B: [connection C862/B =>[signal: VSS w=1]]']]
** C862 _42_:S VSS  C=0.0 [skipped because C=0]
** [instance C863 of CAPACITOR, params={'capacitance': 7.36172e-05 prefix:SIUnitPrefix.PICO} connections=['A: [connection C863/A =>[signal: _56_:S w=1]]', 'B: [connection C863/B =>[signal: VSS w=1]]']]
C863 _56_:S VSS  C=7.36172E-17
** [instance C864 of CAPACITOR, params={'capacitance': 2.28499e-05 prefix:SIUnitPrefix.PICO} connections=['A: [connection C864/A =>[signal: _56_:S w=1]]', 'B: [connection C864/B =>[signal: net3:33 w=1]]']]
C864 _56_:S net3:33  C=2.28499E-17
** [instance C865 of CAPACITOR, params={'capacitance': 0.0 prefix:SIUnitPrefix.PICO} connections=['A: [connection C865/A =>[signal: _54_:S w=1]]', 'B: [connection C865/B =>[signal: VSS w=1]]']]
** C865 _54_:S VSS  C=0.0 [skipped because C=0]
** [instance C866 of CAPACITOR, params={'capacitance': 0.00012615 prefix:SIUnitPrefix.PICO} connections=['A: [connection C866/A =>[signal: fanout13:X w=1]]', 'B: [connection C866/B =>[signal: VSS w=1]]']]
C866 fanout13:X VSS  C=1.2615E-16
** [instance C867 of CAPACITOR, params={'capacitance': 0.000601433 prefix:SIUnitPrefix.PICO} connections=['A: [connection C867/A =>[signal: net13:82 w=1]]', 'B: [connection C867/B =>[signal: VSS w=1]]']]
C867 net13:82 VSS  C=6.014329999999999E-16
** [instance C868 of CAPACITOR, params={'capacitance': 0.000345193 prefix:SIUnitPrefix.PICO} connections=['A: [connection C868/A =>[signal: net13:44 w=1]]', 'B: [connection C868/B =>[signal: VSS w=1]]']]
C868 net13:44 VSS  C=3.45193E-16
** [instance C869 of CAPACITOR, params={'capacitance': 5.71472e-05 prefix:SIUnitPrefix.PICO} connections=['A: [connection C869/A =>[signal: net13:44 w=1]]', 'B: [connection C869/B =>[signal: net26:14 w=1]]']]
C869 net13:44 net26:14  C=5.71472E-17
** [instance C870 of CAPACITOR, params={'capacitance': 0.000434269 prefix:SIUnitPrefix.PICO} connections=['A: [connection C870/A =>[signal: net13:35 w=1]]', 'B: [connection C870/B =>[signal: VSS w=1]]']]
C870 net13:35 VSS  C=4.34269E-16
** [instance C871 of CAPACITOR, params={'capacitance': 0.000710266 prefix:SIUnitPrefix.PICO} connections=['A: [connection C871/A =>[signal: net13:31 w=1]]', 'B: [connection C871/B =>[signal: VSS w=1]]']]
C871 net13:31 VSS  C=7.102659999999999E-16
** [instance C872 of CAPACITOR, params={'capacitance': 0.000323871 prefix:SIUnitPrefix.PICO} connections=['A: [connection C872/A =>[signal: net13:23 w=1]]', 'B: [connection C872/B =>[signal: VSS w=1]]']]
C872 net13:23 VSS  C=3.23871E-16
** [instance C873 of CAPACITOR, params={'capacitance': 0.000320413 prefix:SIUnitPrefix.PICO} connections=['A: [connection C873/A =>[signal: net13:14 w=1]]', 'B: [connection C873/B =>[signal: VSS w=1]]']]
C873 net13:14 VSS  C=3.20413E-16
** [instance C874 of CAPACITOR, params={'capacitance': 0.000667488 prefix:SIUnitPrefix.PICO} connections=['A: [connection C874/A =>[signal: net13:10 w=1]]', 'B: [connection C874/B =>[signal: VSS w=1]]']]
C874 net13:10 VSS  C=6.67488E-16
** [instance C875 of CAPACITOR, params={'capacitance': 0.000102679 prefix:SIUnitPrefix.PICO} connections=['A: [connection C875/A =>[signal: _41_:A0 w=1]]', 'B: [connection C875/B =>[signal: _58_:S w=1]]']]
C875 _41_:A0 _58_:S  C=1.02679E-16
** [instance C876 of CAPACITOR, params={'capacitance': 3.32631e-05 prefix:SIUnitPrefix.PICO} connections=['A: [connection C876/A =>[signal: _41_:A0 w=1]]', 'B: [connection C876/B =>[signal: net13:82 w=1]]']]
C876 _41_:A0 net13:82  C=3.3263099999999994E-17
** [instance C877 of CAPACITOR, params={'capacitance': 0.000340137 prefix:SIUnitPrefix.PICO} connections=['A: [connection C877/A =>[signal: _41_:A0 w=1]]', 'B: [connection C877/B =>[signal: VSS w=1]]']]
C877 _41_:A0 VSS  C=3.40137E-16
** [instance C878 of CAPACITOR, params={'capacitance': 5.71472e-05 prefix:SIUnitPrefix.PICO} connections=['A: [connection C878/A =>[signal: _41_:A0 w=1]]', 'B: [connection C878/B =>[signal: _58_:A0 w=1]]']]
C878 _41_:A0 _58_:A0  C=5.71472E-17
** [instance C879 of CAPACITOR, params={'capacitance': 9.31644e-05 prefix:SIUnitPrefix.PICO} connections=['A: [connection C879/A =>[signal: hold14:X w=1]]', 'B: [connection C879/B =>[signal: VSS w=1]]']]
C879 hold14:X VSS  C=9.31644E-17
** [instance C880 of CAPACITOR, params={'capacitance': 0.000241006 prefix:SIUnitPrefix.PICO} connections=['A: [connection C880/A =>[signal: net14:10 w=1]]', 'B: [connection C880/B =>[signal: VSS w=1]]']]
C880 net14:10 VSS  C=2.41006E-16
** [instance C881 of CAPACITOR, params={'capacitance': 0.00018853 prefix:SIUnitPrefix.PICO} connections=['A: [connection C881/A =>[signal: hold15:X w=1]]', 'B: [connection C881/B =>[signal: VSS w=1]]']]
C881 hold15:X VSS  C=1.8853E-16
** [instance C882 of CAPACITOR, params={'capacitance': 0.0 prefix:SIUnitPrefix.PICO} connections=['A: [connection C882/A =>[signal: _41_:A1 w=1]]', 'B: [connection C882/B =>[signal: VSS w=1]]']]
** C882 _41_:A1 VSS  C=0.0 [skipped because C=0]
** [instance C883 of CAPACITOR, params={'capacitance': 0.000198643 prefix:SIUnitPrefix.PICO} connections=['A: [connection C883/A =>[signal: hold16:X w=1]]', 'B: [connection C883/B =>[signal: VSS w=1]]']]
C883 hold16:X VSS  C=1.9864299999999999E-16
** [instance C884 of CAPACITOR, params={'capacitance': 0.000547426 prefix:SIUnitPrefix.PICO} connections=['A: [connection C884/A =>[signal: net16:10 w=1]]', 'B: [connection C884/B =>[signal: VSS w=1]]']]
C884 net16:10 VSS  C=5.47426E-16
** [instance C885 of CAPACITOR, params={'capacitance': 0.000320024 prefix:SIUnitPrefix.PICO} connections=['A: [connection C885/A =>[signal: net16:10 w=1]]', 'B: [connection C885/B =>[signal: net37:14 w=1]]']]
C885 net16:10 net37:14  C=3.2002400000000004E-16
** [instance C886 of CAPACITOR, params={'capacitance': 0.000311006 prefix:SIUnitPrefix.PICO} connections=['A: [connection C886/A =>[signal: hold17:X w=1]]', 'B: [connection C886/B =>[signal: VSS w=1]]']]
C886 hold17:X VSS  C=3.11006E-16
** [instance C887 of CAPACITOR, params={'capacitance': 0.000803255 prefix:SIUnitPrefix.PICO} connections=['A: [connection C887/A =>[signal: hold18:X w=1]]', 'B: [connection C887/B =>[signal: VSS w=1]]']]
C887 hold18:X VSS  C=8.03255E-16
** [instance C888 of CAPACITOR, params={'capacitance': 0.00148806 prefix:SIUnitPrefix.PICO} connections=['A: [connection C888/A =>[signal: net18:10 w=1]]', 'B: [connection C888/B =>[signal: VSS w=1]]']]
C888 net18:10 VSS  C=1.48806E-15
** [instance C889 of CAPACITOR, params={'capacitance': 9.90431e-05 prefix:SIUnitPrefix.PICO} connections=['A: [connection C889/A =>[signal: net18:10 w=1]]', 'B: [connection C889/B =>[signal: net19:12 w=1]]']]
C889 net18:10 net19:12  C=9.90431E-17
** [instance C890 of CAPACITOR, params={'capacitance': 0.000718613 prefix:SIUnitPrefix.PICO} connections=['A: [connection C890/A =>[signal: net18:10 w=1]]', 'B: [connection C890/B =>[signal: net2:10 w=1]]']]
C890 net18:10 net2:10  C=7.18613E-16
** [instance C891 of CAPACITOR, params={'capacitance': 0.000175281 prefix:SIUnitPrefix.PICO} connections=['A: [connection C891/A =>[signal: net18:10 w=1]]', 'B: [connection C891/B =>[signal: net2:12 w=1]]']]
C891 net18:10 net2:12  C=1.75281E-16
** [instance C892 of CAPACITOR, params={'capacitance': 0.000468135 prefix:SIUnitPrefix.PICO} connections=['A: [connection C892/A =>[signal: net18:10 w=1]]', 'B: [connection C892/B =>[signal: net2:16 w=1]]']]
C892 net18:10 net2:16  C=4.68135E-16
** [instance C893 of CAPACITOR, params={'capacitance': 0.000184504 prefix:SIUnitPrefix.PICO} connections=['A: [connection C893/A =>[signal: net18:10 w=1]]', 'B: [connection C893/B =>[signal: net36:14 w=1]]']]
C893 net18:10 net36:14  C=1.8450399999999999E-16
** [instance C894 of CAPACITOR, params={'capacitance': 0.00102624 prefix:SIUnitPrefix.PICO} connections=['A: [connection C894/A =>[signal: hold19:X w=1]]', 'B: [connection C894/B =>[signal: VSS w=1]]']]
C894 hold19:X VSS  C=1.02624E-15
** [instance C895 of CAPACITOR, params={'capacitance': 0.00159224 prefix:SIUnitPrefix.PICO} connections=['A: [connection C895/A =>[signal: net19:12 w=1]]', 'B: [connection C895/B =>[signal: VSS w=1]]']]
C895 net19:12 VSS  C=1.59224E-15
** [instance C896 of CAPACITOR, params={'capacitance': 4.23086e-05 prefix:SIUnitPrefix.PICO} connections=['A: [connection C896/A =>[signal: net19:12 w=1]]', 'B: [connection C896/B =>[signal: net29:14 w=1]]']]
C896 net19:12 net29:14  C=4.2308599999999997E-17
** [instance C897 of CAPACITOR, params={'capacitance': 0.000318107 prefix:SIUnitPrefix.PICO} connections=['A: [connection C897/A =>[signal: net19:12 w=1]]', 'B: [connection C897/B =>[signal: net36:14 w=1]]']]
C897 net19:12 net36:14  C=3.1810699999999995E-16
** [instance C898 of CAPACITOR, params={'capacitance': 0.0 prefix:SIUnitPrefix.PICO} connections=['A: [connection C898/A =>[signal: _31_:S1 w=1]]', 'B: [connection C898/B =>[signal: VSS w=1]]']]
** C898 _31_:S1 VSS  C=0.0 [skipped because C=0]
** [instance C899 of CAPACITOR, params={'capacitance': 0.0 prefix:SIUnitPrefix.PICO} connections=['A: [connection C899/A =>[signal: _36_:S1 w=1]]', 'B: [connection C899/B =>[signal: VSS w=1]]']]
** C899 _36_:S1 VSS  C=0.0 [skipped because C=0]
** [instance C900 of CAPACITOR, params={'capacitance': 0.000350667 prefix:SIUnitPrefix.PICO} connections=['A: [connection C900/A =>[signal: input2:X w=1]]', 'B: [connection C900/B =>[signal: VSS w=1]]']]
C900 input2:X VSS  C=3.50667E-16
** [instance C901 of CAPACITOR, params={'capacitance': 0.000769718 prefix:SIUnitPrefix.PICO} connections=['A: [connection C901/A =>[signal: net2:16 w=1]]', 'B: [connection C901/B =>[signal: VSS w=1]]']]
C901 net2:16 VSS  C=7.69718E-16
** [instance C902 of CAPACITOR, params={'capacitance': 0.000172821 prefix:SIUnitPrefix.PICO} connections=['A: [connection C902/A =>[signal: net2:16 w=1]]', 'B: [connection C902/B =>[signal: net36:14 w=1]]']]
C902 net2:16 net36:14  C=1.72821E-16
** [instance C903 of CAPACITOR, params={'capacitance': 0.00120511 prefix:SIUnitPrefix.PICO} connections=['A: [connection C903/A =>[signal: net2:12 w=1]]', 'B: [connection C903/B =>[signal: VSS w=1]]']]
C903 net2:12 VSS  C=1.20511E-15
** [instance C904 of CAPACITOR, params={'capacitance': 0.000166852 prefix:SIUnitPrefix.PICO} connections=['A: [connection C904/A =>[signal: net2:12 w=1]]', 'B: [connection C904/B =>[signal: net36:14 w=1]]']]
C904 net2:12 net36:14  C=1.66852E-16
** [instance C905 of CAPACITOR, params={'capacitance': 0.000393292 prefix:SIUnitPrefix.PICO} connections=['A: [connection C905/A =>[signal: net2:10 w=1]]', 'B: [connection C905/B =>[signal: VSS w=1]]']]
C905 net2:10 VSS  C=3.93292E-16
** [instance C906 of CAPACITOR, params={'capacitance': 0.000710946 prefix:SIUnitPrefix.PICO} connections=['A: [connection C906/A =>[signal: net2:10 w=1]]', 'B: [connection C906/B =>[signal: net36:14 w=1]]']]
C906 net2:10 net36:14  C=7.10946E-16
** [instance C907 of CAPACITOR, params={'capacitance': 5.30637e-06 prefix:SIUnitPrefix.PICO} connections=['A: [connection C907/A =>[signal: net2:10 w=1]]', 'B: [connection C907/B =>[signal: net6:6 w=1]]']]
C907 net2:10 net6:6  C=5.30637E-18
** [instance C908 of CAPACITOR, params={'capacitance': 0.000495322 prefix:SIUnitPrefix.PICO} connections=['A: [connection C908/A =>[signal: hold20:X w=1]]', 'B: [connection C908/B =>[signal: VSS w=1]]']]
C908 hold20:X VSS  C=4.95322E-16
** [instance C909 of CAPACITOR, params={'capacitance': 0.000206631 prefix:SIUnitPrefix.PICO} connections=['A: [connection C909/A =>[signal: hold21:X w=1]]', 'B: [connection C909/B =>[signal: VSS w=1]]']]
C909 hold21:X VSS  C=2.06631E-16
** [instance C910 of CAPACITOR, params={'capacitance': 0.0 prefix:SIUnitPrefix.PICO} connections=['A: [connection C910/A =>[signal: _58_:A1 w=1]]', 'B: [connection C910/B =>[signal: VSS w=1]]']]
** C910 _58_:A1 VSS  C=0.0 [skipped because C=0]
** [instance C911 of CAPACITOR, params={'capacitance': 0.000210328 prefix:SIUnitPrefix.PICO} connections=['A: [connection C911/A =>[signal: hold22:X w=1]]', 'B: [connection C911/B =>[signal: VSS w=1]]']]
C911 hold22:X VSS  C=2.10328E-16
** [instance C912 of CAPACITOR, params={'capacitance': 0.000550465 prefix:SIUnitPrefix.PICO} connections=['A: [connection C912/A =>[signal: net22:12 w=1]]', 'B: [connection C912/B =>[signal: VSS w=1]]']]
C912 net22:12 VSS  C=5.50465E-16
** [instance C913 of CAPACITOR, params={'capacitance': 0.000186163 prefix:SIUnitPrefix.PICO} connections=['A: [connection C913/A =>[signal: hold23:X w=1]]', 'B: [connection C913/B =>[signal: VSS w=1]]']]
C913 hold23:X VSS  C=1.86163E-16
** [instance C914 of CAPACITOR, params={'capacitance': 0.000972362 prefix:SIUnitPrefix.PICO} connections=['A: [connection C914/A =>[signal: net23:10 w=1]]', 'B: [connection C914/B =>[signal: VSS w=1]]']]
C914 net23:10 VSS  C=9.723620000000001E-16
** [instance C915 of CAPACITOR, params={'capacitance': 0.000226845 prefix:SIUnitPrefix.PICO} connections=['A: [connection C915/A =>[signal: _55_:A1 w=1]]', 'B: [connection C915/B =>[signal: VSS w=1]]']]
C915 _55_:A1 VSS  C=2.26845E-16
** [instance C916 of CAPACITOR, params={'capacitance': 5.11184e-05 prefix:SIUnitPrefix.PICO} connections=['A: [connection C916/A =>[signal: _55_:A1 w=1]]', 'B: [connection C916/B =>[signal: net26:14 w=1]]']]
C916 _55_:A1 net26:14  C=5.1118400000000004E-17
** [instance C917 of CAPACITOR, params={'capacitance': 0.000209457 prefix:SIUnitPrefix.PICO} connections=['A: [connection C917/A =>[signal: hold24:X w=1]]', 'B: [connection C917/B =>[signal: VSS w=1]]']]
C917 hold24:X VSS  C=2.09457E-16
** [instance C918 of CAPACITOR, params={'capacitance': 0.000576136 prefix:SIUnitPrefix.PICO} connections=['A: [connection C918/A =>[signal: net24:10 w=1]]', 'B: [connection C918/B =>[signal: VSS w=1]]']]
C918 net24:10 VSS  C=5.76136E-16
** [instance C919 of CAPACITOR, params={'capacitance': 0.000271673 prefix:SIUnitPrefix.PICO} connections=['A: [connection C919/A =>[signal: hold25:X w=1]]', 'B: [connection C919/B =>[signal: VSS w=1]]']]
C919 hold25:X VSS  C=2.71673E-16
** [instance C920 of CAPACITOR, params={'capacitance': 0.0 prefix:SIUnitPrefix.PICO} connections=['A: [connection C920/A =>[signal: _54_:A1 w=1]]', 'B: [connection C920/B =>[signal: VSS w=1]]']]
** C920 _54_:A1 VSS  C=0.0 [skipped because C=0]
** [instance C921 of CAPACITOR, params={'capacitance': 0.0004013 prefix:SIUnitPrefix.PICO} connections=['A: [connection C921/A =>[signal: hold26:X w=1]]', 'B: [connection C921/B =>[signal: VSS w=1]]']]
C921 hold26:X VSS  C=4.013E-16
** [instance C922 of CAPACITOR, params={'capacitance': 0.000464902 prefix:SIUnitPrefix.PICO} connections=['A: [connection C922/A =>[signal: net26:14 w=1]]', 'B: [connection C922/B =>[signal: VSS w=1]]']]
C922 net26:14 VSS  C=4.64902E-16
** [instance C923 of CAPACITOR, params={'capacitance': 7.50697e-05 prefix:SIUnitPrefix.PICO} connections=['A: [connection C923/A =>[signal: net26:14 w=1]]', 'B: [connection C923/B =>[signal: net37:14 w=1]]']]
C923 net26:14 net37:14  C=7.50697E-17
** [instance C924 of CAPACITOR, params={'capacitance': 0.00123218 prefix:SIUnitPrefix.PICO} connections=['A: [connection C924/A =>[signal: hold27:X w=1]]', 'B: [connection C924/B =>[signal: VSS w=1]]']]
C924 hold27:X VSS  C=1.23218E-15
** [instance C925 of CAPACITOR, params={'capacitance': 0.000377006 prefix:SIUnitPrefix.PICO} connections=['A: [connection C925/A =>[signal: hold28:X w=1]]', 'B: [connection C925/B =>[signal: VSS w=1]]']]
C925 hold28:X VSS  C=3.7700599999999997E-16
** [instance C926 of CAPACITOR, params={'capacitance': 0.000655087 prefix:SIUnitPrefix.PICO} connections=['A: [connection C926/A =>[signal: hold29:X w=1]]', 'B: [connection C926/B =>[signal: VSS w=1]]']]
C926 hold29:X VSS  C=6.55087E-16
** [instance C927 of CAPACITOR, params={'capacitance': 0.00142313 prefix:SIUnitPrefix.PICO} connections=['A: [connection C927/A =>[signal: net29:14 w=1]]', 'B: [connection C927/B =>[signal: VSS w=1]]']]
C927 net29:14 VSS  C=1.4231300000000001E-15
** [instance C928 of CAPACITOR, params={'capacitance': 0.0 prefix:SIUnitPrefix.PICO} connections=['A: [connection C928/A =>[signal: _37_:S w=1]]', 'B: [connection C928/B =>[signal: VSS w=1]]']]
** C928 _37_:S VSS  C=0.0 [skipped because C=0]
** [instance C929 of CAPACITOR, params={'capacitance': 0.000262602 prefix:SIUnitPrefix.PICO} connections=['A: [connection C929/A =>[signal: _29_:A w=1]]', 'B: [connection C929/B =>[signal: VSS w=1]]']]
C929 _29_:A VSS  C=2.62602E-16
** [instance C930 of CAPACITOR, params={'capacitance': 0.000269556 prefix:SIUnitPrefix.PICO} connections=['A: [connection C930/A =>[signal: _29_:A w=1]]', 'B: [connection C930/B =>[signal: _50_:A1 w=1]]']]
C930 _29_:A _50_:A1  C=2.69556E-16
** [instance C931 of CAPACITOR, params={'capacitance': 0.000881683 prefix:SIUnitPrefix.PICO} connections=['A: [connection C931/A =>[signal: input3:X w=1]]', 'B: [connection C931/B =>[signal: VSS w=1]]']]
C931 input3:X VSS  C=8.816829999999999E-16
** [instance C932 of CAPACITOR, params={'capacitance': 0.000542922 prefix:SIUnitPrefix.PICO} connections=['A: [connection C932/A =>[signal: net3:33 w=1]]', 'B: [connection C932/B =>[signal: VSS w=1]]']]
C932 net3:33 VSS  C=5.42922E-16
** [instance C933 of CAPACITOR, params={'capacitance': 0.00159067 prefix:SIUnitPrefix.PICO} connections=['A: [connection C933/A =>[signal: net3:12 w=1]]', 'B: [connection C933/B =>[signal: VSS w=1]]']]
C933 net3:12 VSS  C=1.5906699999999999E-15
** [instance C934 of CAPACITOR, params={'capacitance': 3.75628e-05 prefix:SIUnitPrefix.PICO} connections=['A: [connection C934/A =>[signal: net3:12 w=1]]', 'B: [connection C934/B =>[signal: net8:12 w=1]]']]
C934 net3:12 net8:12  C=3.7562799999999996E-17
** [instance C935 of CAPACITOR, params={'capacitance': 8.15939e-05 prefix:SIUnitPrefix.PICO} connections=['A: [connection C935/A =>[signal: output9:A w=1]]', 'B: [connection C935/B =>[signal: net3:12 w=1]]']]
C935 output9:A net3:12  C=8.15939E-17
** [instance C936 of CAPACITOR, params={'capacitance': 0.000153047 prefix:SIUnitPrefix.PICO} connections=['A: [connection C936/A =>[signal: output9:A w=1]]', 'B: [connection C936/B =>[signal: net8:12 w=1]]']]
C936 output9:A net8:12  C=1.53047E-16
** [instance C937 of CAPACITOR, params={'capacitance': 0.00012088 prefix:SIUnitPrefix.PICO} connections=['A: [connection C937/A =>[signal: output9:A w=1]]', 'B: [connection C937/B =>[signal: VSS w=1]]']]
C937 output9:A VSS  C=1.2088E-16
** [instance C938 of CAPACITOR, params={'capacitance': 0.00195347 prefix:SIUnitPrefix.PICO} connections=['A: [connection C938/A =>[signal: hold30:X w=1]]', 'B: [connection C938/B =>[signal: VSS w=1]]']]
C938 hold30:X VSS  C=1.95347E-15
** [instance C939 of CAPACITOR, params={'capacitance': 0.000115319 prefix:SIUnitPrefix.PICO} connections=['A: [connection C939/A =>[signal: hold31:X w=1]]', 'B: [connection C939/B =>[signal: VSS w=1]]']]
C939 hold31:X VSS  C=1.15319E-16
** [instance C940 of CAPACITOR, params={'capacitance': 0.000606476 prefix:SIUnitPrefix.PICO} connections=['A: [connection C940/A =>[signal: hold32:X w=1]]', 'B: [connection C940/B =>[signal: VSS w=1]]']]
C940 hold32:X VSS  C=6.06476E-16
** [instance C941 of CAPACITOR, params={'capacitance': 0.000357424 prefix:SIUnitPrefix.PICO} connections=['A: [connection C941/A =>[signal: hold33:X w=1]]', 'B: [connection C941/B =>[signal: VSS w=1]]']]
C941 hold33:X VSS  C=3.57424E-16
** [instance C942 of CAPACITOR, params={'capacitance': 0.00109674 prefix:SIUnitPrefix.PICO} connections=['A: [connection C942/A =>[signal: net33:8 w=1]]', 'B: [connection C942/B =>[signal: VSS w=1]]']]
C942 net33:8 VSS  C=1.09674E-15
** [instance C943 of CAPACITOR, params={'capacitance': 0.000511771 prefix:SIUnitPrefix.PICO} connections=['A: [connection C943/A =>[signal: hold34:X w=1]]', 'B: [connection C943/B =>[signal: VSS w=1]]']]
C943 hold34:X VSS  C=5.1177099999999995E-16
** [instance C944 of CAPACITOR, params={'capacitance': 0.000952917 prefix:SIUnitPrefix.PICO} connections=['A: [connection C944/A =>[signal: hold35:X w=1]]', 'B: [connection C944/B =>[signal: VSS w=1]]']]
C944 hold35:X VSS  C=9.529169999999999E-16
** [instance C945 of CAPACITOR, params={'capacitance': 0.0024826 prefix:SIUnitPrefix.PICO} connections=['A: [connection C945/A =>[signal: net35:10 w=1]]', 'B: [connection C945/B =>[signal: VSS w=1]]']]
C945 net35:10 VSS  C=2.4826E-15
** [instance C946 of CAPACITOR, params={'capacitance': 0.000271345 prefix:SIUnitPrefix.PICO} connections=['A: [connection C946/A =>[signal: net35:10 w=1]]', 'B: [connection C946/B =>[signal: net37:14 w=1]]']]
C946 net35:10 net37:14  C=2.7134499999999997E-16
** [instance C947 of CAPACITOR, params={'capacitance': 0.0 prefix:SIUnitPrefix.PICO} connections=['A: [connection C947/A =>[signal: _53_:A0 w=1]]', 'B: [connection C947/B =>[signal: VSS w=1]]']]
** C947 _53_:A0 VSS  C=0.0 [skipped because C=0]
** [instance C948 of CAPACITOR, params={'capacitance': 0.000930951 prefix:SIUnitPrefix.PICO} connections=['A: [connection C948/A =>[signal: hold36:X w=1]]', 'B: [connection C948/B =>[signal: VSS w=1]]']]
C948 hold36:X VSS  C=9.309509999999999E-16
** [instance C949 of CAPACITOR, params={'capacitance': 0.000930951 prefix:SIUnitPrefix.PICO} connections=['A: [connection C949/A =>[signal: net36:14 w=1]]', 'B: [connection C949/B =>[signal: VSS w=1]]']]
C949 net36:14 VSS  C=9.309509999999999E-16
** [instance C950 of CAPACITOR, params={'capacitance': 0.00120792 prefix:SIUnitPrefix.PICO} connections=['A: [connection C950/A =>[signal: hold37:X w=1]]', 'B: [connection C950/B =>[signal: VSS w=1]]']]
C950 hold37:X VSS  C=1.20792E-15
** [instance C951 of CAPACITOR, params={'capacitance': 0.00129304 prefix:SIUnitPrefix.PICO} connections=['A: [connection C951/A =>[signal: net37:14 w=1]]', 'B: [connection C951/B =>[signal: VSS w=1]]']]
C951 net37:14 VSS  C=1.29304E-15
** [instance C952 of CAPACITOR, params={'capacitance': 0.000913963 prefix:SIUnitPrefix.PICO} connections=['A: [connection C952/A =>[signal: net37:14 w=1]]', 'B: [connection C952/B =>[signal: net4:18 w=1]]']]
C952 net37:14 net4:18  C=9.13963E-16
** [instance C953 of CAPACITOR, params={'capacitance': 0.0 prefix:SIUnitPrefix.PICO} connections=['A: [connection C953/A =>[signal: _30_:A w=1]]', 'B: [connection C953/B =>[signal: VSS w=1]]']]
** C953 _30_:A VSS  C=0.0 [skipped because C=0]
** [instance C954 of CAPACITOR, params={'capacitance': 0.000738153 prefix:SIUnitPrefix.PICO} connections=['A: [connection C954/A =>[signal: input4:X w=1]]', 'B: [connection C954/B =>[signal: VSS w=1]]']]
C954 input4:X VSS  C=7.381529999999999E-16
** [instance C955 of CAPACITOR, params={'capacitance': 0.00162374 prefix:SIUnitPrefix.PICO} connections=['A: [connection C955/A =>[signal: net4:18 w=1]]', 'B: [connection C955/B =>[signal: VSS w=1]]']]
C955 net4:18 VSS  C=1.62374E-15
** [instance C956 of CAPACITOR, params={'capacitance': 0.000438127 prefix:SIUnitPrefix.PICO} connections=['A: [connection C956/A =>[signal: input5:X w=1]]', 'B: [connection C956/B =>[signal: VSS w=1]]']]
C956 input5:X VSS  C=4.3812700000000003E-16
** [instance C957 of CAPACITOR, params={'capacitance': 0.000258908 prefix:SIUnitPrefix.PICO} connections=['A: [connection C957/A =>[signal: input6:X w=1]]', 'B: [connection C957/B =>[signal: VSS w=1]]']]
C957 input6:X VSS  C=2.58908E-16
** [instance C958 of CAPACITOR, params={'capacitance': 0.00123585 prefix:SIUnitPrefix.PICO} connections=['A: [connection C958/A =>[signal: net6:6 w=1]]', 'B: [connection C958/B =>[signal: VSS w=1]]']]
C958 net6:6 VSS  C=1.23585E-15
** [instance C959 of CAPACITOR, params={'capacitance': 0.00063921 prefix:SIUnitPrefix.PICO} connections=['A: [connection C959/A =>[signal: input7:X w=1]]', 'B: [connection C959/B =>[signal: VSS w=1]]']]
C959 input7:X VSS  C=6.3921E-16
** [instance C960 of CAPACITOR, params={'capacitance': 4.74518e-05 prefix:SIUnitPrefix.PICO} connections=['A: [connection C960/A =>[signal: _40_:A1 w=1]]', 'B: [connection C960/B =>[signal: VSS w=1]]']]
C960 _40_:A1 VSS  C=4.7451799999999996E-17
** [instance C961 of CAPACITOR, params={'capacitance': 0.000251984 prefix:SIUnitPrefix.PICO} connections=['A: [connection C961/A =>[signal: input8:X w=1]]', 'B: [connection C961/B =>[signal: VSS w=1]]']]
C961 input8:X VSS  C=2.51984E-16
** [instance C962 of CAPACITOR, params={'capacitance': 0.000803191 prefix:SIUnitPrefix.PICO} connections=['A: [connection C962/A =>[signal: net8:12 w=1]]', 'B: [connection C962/B =>[signal: VSS w=1]]']]
C962 net8:12 VSS  C=8.03191E-16
** [instance C963 of CAPACITOR, params={'capacitance': 0.00012088 prefix:SIUnitPrefix.PICO} connections=['A: [connection C963/A =>[signal: _40_:X w=1]]', 'B: [connection C963/B =>[signal: VSS w=1]]']]
C963 _40_:X VSS  C=1.2088E-16
** [instance C964 of CAPACITOR, params={'capacitance': 0.000135031 prefix:SIUnitPrefix.PICO} connections=['A: [connection C964/A =>[signal: hold32:A w=1]]', 'B: [connection C964/B =>[signal: VSS w=1]]']]
C964 hold32:A VSS  C=1.35031E-16
** [instance C965 of CAPACITOR, params={'capacitance': 0.0 prefix:SIUnitPrefix.PICO} connections=['A: [connection C965/A =>[signal: _74_:Q w=1]]', 'B: [connection C965/B =>[signal: VSS w=1]]']]
** C965 _74_:Q VSS  C=0.0 [skipped because C=0]
** [instance C966 of CAPACITOR, params={'capacitance': 0.00074539 prefix:SIUnitPrefix.PICO} connections=['A: [connection C966/A =>[signal: q_control:4 w=1]]', 'B: [connection C966/B =>[signal: VSS w=1]]']]
C966 q_control:4 VSS  C=7.4539E-16
** [instance R0 of RESISTOR, params={'resistance': 35.484 prefix:None} connections=['A: [connection R0/A =>[signal: input1:A w=1]]', 'B: [connection R0/B =>[slice: addr[0:0]]]']]
R0 input1:A addr.0  R=35.484
** [instance R1 of RESISTOR, params={'resistance': 32.204 prefix:None} connections=['A: [connection R1/A =>[signal: input2:A w=1]]', 'B: [connection R1/B =>[slice: addr[1:1]]]']]
R1 input2:A addr.1  R=32.204
** [instance R2 of RESISTOR, params={'resistance': 24.0179 prefix:None} connections=['A: [connection R2/A =>[signal: addr.2:11 w=1]]', 'B: [connection R2/B =>[slice: addr[2:2]]]']]
R2 addr.2:11 addr.2  R=24.0179
** [instance R3 of RESISTOR, params={'resistance': 48.8714 prefix:None} connections=['A: [connection R3/A =>[signal: input3:A w=1]]', 'B: [connection R3/B =>[signal: addr.2:11 w=1]]']]
R3 input3:A addr.2:11  R=48.8714
** [instance R4 of RESISTOR, params={'resistance': 44.8752 prefix:None} connections=['A: [connection R4/A =>[signal: input4:A w=1]]', 'B: [connection R4/B =>[slice: addr[3:3]]]']]
R4 input4:A addr.3  R=44.8752
** [instance R5 of RESISTOR, params={'resistance': 36.9122 prefix:None} connections=['A: [connection R5/A =>[signal: input5:A w=1]]', 'B: [connection R5/B =>[signal: clk w=1]]']]
R5 input5:A clk  R=36.9122
** [instance R6 of RESISTOR, params={'resistance': 23.4868 prefix:None} connections=['A: [connection R6/A =>[signal: output9:X w=1]]', 'B: [connection R6/B =>[signal: mux w=1]]']]
R6 output9:X mux  R=23.4868
** [instance R7 of RESISTOR, params={'resistance': 41.3714 prefix:None} connections=['A: [connection R7/A =>[signal: output10:X w=1]]', 'B: [connection R7/B =>[signal: q w=1]]']]
R7 output10:X q  R=41.3714
** [instance R8 of RESISTOR, params={'resistance': 22.9694 prefix:None} connections=['A: [connection R8/A =>[signal: scan_clk:18 w=1]]', 'B: [connection R8/B =>[signal: scan_clk w=1]]']]
R8 scan_clk:18 scan_clk  R=22.9694
** [instance R9 of RESISTOR, params={'resistance': 15.175 prefix:None} connections=['A: [connection R9/A =>[signal: scan_clk:18 w=1]]', 'B: [connection R9/B =>[signal: clkbuf_0_scan_clk:A w=1]]']]
R9 scan_clk:18 clkbuf_0_scan_clk:A  R=15.175
** [instance R10 of RESISTOR, params={'resistance': 24.3482 prefix:None} connections=['A: [connection R10/A =>[signal: input6:A w=1]]', 'B: [connection R10/B =>[signal: scan_en w=1]]']]
R10 input6:A scan_en  R=24.3482
** [instance R11 of RESISTOR, params={'resistance': 45.0219 prefix:None} connections=['A: [connection R11/A =>[signal: input7:A w=1]]', 'B: [connection R11/B =>[signal: scan_in w=1]]']]
R11 input7:A scan_in  R=45.0219
** [instance R12 of RESISTOR, params={'resistance': 31.2834 prefix:None} connections=['A: [connection R12/A =>[signal: output11:X w=1]]', 'B: [connection R12/B =>[signal: scan_out w=1]]']]
R12 output11:X scan_out  R=31.2834
** [instance R13 of RESISTOR, params={'resistance': 31.9256 prefix:None} connections=['A: [connection R13/A =>[signal: input8:A w=1]]', 'B: [connection R13/B =>[signal: x w=1]]']]
R13 input8:A x  R=31.9256
** [instance R14 of RESISTOR, params={'resistance': 20.658 prefix:None} connections=['A: [connection R14/A =>[signal: _39_:X w=1]]', 'B: [connection R14/B =>[signal: _77_:D w=1]]']]
R14 _39_:X _77_:D  R=20.658
** [instance R15 of RESISTOR, params={'resistance': 30.658 prefix:None} connections=['A: [connection R15/A =>[signal: _41_:X w=1]]', 'B: [connection R15/B =>[signal: _59_:D w=1]]']]
R15 _41_:X _59_:D  R=30.658
** [instance R16 of RESISTOR, params={'resistance': 37.2786 prefix:None} connections=['A: [connection R16/A =>[signal: _42_:X w=1]]', 'B: [connection R16/B =>[signal: hold17:A w=1]]']]
R16 _42_:X hold17:A  R=37.2786
** [instance R17 of RESISTOR, params={'resistance': 36.6536 prefix:None} connections=['A: [connection R17/A =>[signal: _43_:X w=1]]', 'B: [connection R17/B =>[signal: hold21:A w=1]]']]
R17 _43_:X hold21:A  R=36.6536
** [instance R18 of RESISTOR, params={'resistance': 37.033 prefix:None} connections=['A: [connection R18/A =>[signal: _44_:X w=1]]', 'B: [connection R18/B =>[signal: _62_:D w=1]]']]
R18 _44_:X _62_:D  R=37.033
** [instance R19 of RESISTOR, params={'resistance': 32.6759 prefix:None} connections=['A: [connection R19/A =>[signal: _45_:X w=1]]', 'B: [connection R19/B =>[signal: _63_:D w=1]]']]
R19 _45_:X _63_:D  R=32.6759
** [instance R20 of RESISTOR, params={'resistance': 34.2607 prefix:None} connections=['A: [connection R20/A =>[signal: _46_:X w=1]]', 'B: [connection R20/B =>[signal: hold15:A w=1]]']]
R20 _46_:X hold15:A  R=34.2607
** [instance R21 of RESISTOR, params={'resistance': 34.5687 prefix:None} connections=['A: [connection R21/A =>[signal: _47_:X w=1]]', 'B: [connection R21/B =>[signal: _65_:D w=1]]']]
R21 _47_:X _65_:D  R=34.5687
** [instance R22 of RESISTOR, params={'resistance': 36.8679 prefix:None} connections=['A: [connection R22/A =>[signal: _48_:X w=1]]', 'B: [connection R22/B =>[signal: _66_:D w=1]]']]
R22 _48_:X _66_:D  R=36.8679
** [instance R23 of RESISTOR, params={'resistance': 44.0857 prefix:None} connections=['A: [connection R23/A =>[signal: _49_:X w=1]]', 'B: [connection R23/B =>[signal: _09_:12 w=1]]']]
R23 _49_:X _09_:12  R=44.0857
** [instance R24 of RESISTOR, params={'resistance': 33.6214 prefix:None} connections=['A: [connection R24/A =>[signal: _09_:12 w=1]]', 'B: [connection R24/B =>[signal: hold19:A w=1]]']]
R24 _09_:12 hold19:A  R=33.6214
** [instance R25 of RESISTOR, params={'resistance': 41.9964 prefix:None} connections=['A: [connection R25/A =>[signal: _50_:X w=1]]', 'B: [connection R25/B =>[signal: _10_:26 w=1]]']]
R25 _50_:X _10_:26  R=41.9964
** [instance R26 of RESISTOR, params={'resistance': 9.3 prefix:None} connections=['A: [connection R26/A =>[signal: _68_:D w=1]]', 'B: [connection R26/B =>[signal: _10_:26 w=1]]']]
R26 _68_:D _10_:26  R=9.3
** [instance R27 of RESISTOR, params={'resistance': 49.408 prefix:None} connections=['A: [connection R27/A =>[signal: _51_:X w=1]]', 'B: [connection R27/B =>[signal: _69_:D w=1]]']]
R27 _51_:X _69_:D  R=49.408
** [instance R28 of RESISTOR, params={'resistance': 44.6393 prefix:None} connections=['A: [connection R28/A =>[signal: _52_:X w=1]]', 'B: [connection R28/B =>[signal: _12_:26 w=1]]']]
R28 _52_:X _12_:26  R=44.6393
** [instance R29 of RESISTOR, params={'resistance': 9.3 prefix:None} connections=['A: [connection R29/A =>[signal: _12_:26 w=1]]', 'B: [connection R29/B =>[signal: hold34:A w=1]]']]
R29 _12_:26 hold34:A  R=9.3
** [instance R30 of RESISTOR, params={'resistance': 47.0286 prefix:None} connections=['A: [connection R30/A =>[signal: _53_:X w=1]]', 'B: [connection R30/B =>[signal: _71_:D w=1]]']]
R30 _53_:X _71_:D  R=47.0286
** [instance R31 of RESISTOR, params={'resistance': 32.5821 prefix:None} connections=['A: [connection R31/A =>[signal: _54_:X w=1]]', 'B: [connection R31/B =>[signal: _72_:D w=1]]']]
R31 _54_:X _72_:D  R=32.5821
** [instance R32 of RESISTOR, params={'resistance': 32.4795 prefix:None} connections=['A: [connection R32/A =>[signal: _55_:X w=1]]', 'B: [connection R32/B =>[signal: _73_:D w=1]]']]
R32 _55_:X _73_:D  R=32.4795
** [instance R33 of RESISTOR, params={'resistance': 37.6402 prefix:None} connections=['A: [connection R33/A =>[signal: _56_:X w=1]]', 'B: [connection R33/B =>[signal: _74_:D w=1]]']]
R33 _56_:X _74_:D  R=37.6402
** [instance R34 of RESISTOR, params={'resistance': 30.6 prefix:None} connections=['A: [connection R34/A =>[signal: _57_:X w=1]]', 'B: [connection R34/B =>[signal: hold25:A w=1]]']]
R34 _57_:X hold25:A  R=30.6
** [instance R35 of RESISTOR, params={'resistance': 31.533 prefix:None} connections=['A: [connection R35/A =>[signal: _58_:X w=1]]', 'B: [connection R35/B =>[signal: _76_:D w=1]]']]
R35 _58_:X _76_:D  R=31.533
** [instance R36 of RESISTOR, params={'resistance': 40.7786 prefix:None} connections=['A: [connection R36/A =>[signal: _29_:Y w=1]]', 'B: [connection R36/B =>[signal: _34_:A1 w=1]]']]
R36 _29_:Y _34_:A1  R=40.7786
** [instance R37 of RESISTOR, params={'resistance': 36.2786 prefix:None} connections=['A: [connection R37/A =>[signal: _30_:Y w=1]]', 'B: [connection R37/B =>[signal: _38_:B2 w=1]]']]
R37 _30_:Y _38_:B2  R=36.2786
** [instance R38 of RESISTOR, params={'resistance': 42.0464 prefix:None} connections=['A: [connection R38/A =>[signal: _31_:X w=1]]', 'B: [connection R38/B =>[signal: _32_:B w=1]]']]
R38 _31_:X _32_:B  R=42.0464
** [instance R39 of RESISTOR, params={'resistance': 35.8893 prefix:None} connections=['A: [connection R39/A =>[signal: _32_:X w=1]]', 'B: [connection R39/B =>[signal: _22_:12 w=1]]']]
R39 _32_:X _22_:12  R=35.8893
** [instance R40 of RESISTOR, params={'resistance': 26.4786 prefix:None} connections=['A: [connection R40/A =>[signal: _38_:A1 w=1]]', 'B: [connection R40/B =>[signal: _22_:12 w=1]]']]
R40 _38_:A1 _22_:12  R=26.4786
** [instance R41 of RESISTOR, params={'resistance': 46.5321 prefix:None} connections=['A: [connection R41/A =>[signal: _33_:X w=1]]', 'B: [connection R41/B =>[signal: _23_:24 w=1]]']]
R41 _33_:X _23_:24  R=46.5321
** [instance R42 of RESISTOR, params={'resistance': 9.3 prefix:None} connections=['A: [connection R42/A =>[signal: _34_:A2 w=1]]', 'B: [connection R42/B =>[signal: _23_:24 w=1]]']]
R42 _34_:A2 _23_:24  R=9.3
** [instance R43 of RESISTOR, params={'resistance': 45.1831 prefix:None} connections=['A: [connection R43/A =>[signal: _34_:X w=1]]', 'B: [connection R43/B =>[signal: _24_:36 w=1]]']]
R43 _34_:X _24_:36  R=45.1831
** [instance R44 of RESISTOR, params={'resistance': 9.3 prefix:None} connections=['A: [connection R44/A =>[signal: _38_:A2 w=1]]', 'B: [connection R44/B =>[signal: _24_:36 w=1]]']]
R44 _38_:A2 _24_:36  R=9.3
** [instance R45 of RESISTOR, params={'resistance': 37.9214 prefix:None} connections=['A: [connection R45/A =>[signal: _35_:X w=1]]', 'B: [connection R45/B =>[signal: _37_:A0 w=1]]']]
R45 _35_:X _37_:A0  R=37.9214
** [instance R46 of RESISTOR, params={'resistance': 28.6357 prefix:None} connections=['A: [connection R46/A =>[signal: _36_:X w=1]]', 'B: [connection R46/B =>[signal: _37_:A1 w=1]]']]
R46 _36_:X _37_:A1  R=28.6357
** [instance R47 of RESISTOR, params={'resistance': 48.1893 prefix:None} connections=['A: [connection R47/A =>[signal: _37_:X w=1]]', 'B: [connection R47/B =>[signal: _38_:B1 w=1]]']]
R47 _37_:X _38_:B1  R=48.1893
** [instance R48 of RESISTOR, params={'resistance': 19.6929 prefix:None} connections=['A: [connection R48/A =>[signal: _38_:X w=1]]', 'B: [connection R48/B =>[signal: _28_:8 w=1]]']]
R48 _38_:X _28_:8  R=19.6929
** [instance R49 of RESISTOR, params={'resistance': 24.8893 prefix:None} connections=['A: [connection R49/A =>[signal: _39_:A0 w=1]]', 'B: [connection R49/B =>[signal: _28_:8 w=1]]']]
R49 _39_:A0 _28_:8  R=24.8893
** [instance R50 of RESISTOR, params={'resistance': 21.9964 prefix:None} connections=['A: [connection R50/A =>[signal: _40_:A0 w=1]]', 'B: [connection R50/B =>[signal: _28_:8 w=1]]']]
R50 _40_:A0 _28_:8  R=21.9964
** [instance R51 of RESISTOR, params={'resistance': 9.83571 prefix:None} connections=['A: [connection R51/A =>[signal: clkbuf_0_scan_clk:X w=1]]', 'B: [connection R51/B =>[signal: clknet_0_scan_clk:6 w=1]]']]
R51 clkbuf_0_scan_clk:X clknet_0_scan_clk:6  R=9.83571
** [instance R52 of RESISTOR, params={'resistance': 0.995536 prefix:None} connections=['A: [connection R52/A =>[signal: clknet_0_scan_clk:6 w=1]]', 'B: [connection R52/B =>[signal: clknet_0_scan_clk:8 w=1]]']]
R52 clknet_0_scan_clk:6 clknet_0_scan_clk:8  R=0.995536
** [instance R53 of RESISTOR, params={'resistance': 18.9286 prefix:None} connections=['A: [connection R53/A =>[signal: clknet_0_scan_clk:33 w=1]]', 'B: [connection R53/B =>[signal: clknet_0_scan_clk:8 w=1]]']]
R53 clknet_0_scan_clk:33 clknet_0_scan_clk:8  R=18.9286
** [instance R54 of RESISTOR, params={'resistance': 11.108 prefix:None} connections=['A: [connection R54/A =>[signal: clkbuf_1_0__f_scan_clk:A w=1]]', 'B: [connection R54/B =>[signal: clknet_0_scan_clk:33 w=1]]']]
R54 clkbuf_1_0__f_scan_clk:A clknet_0_scan_clk:33  R=11.108
** [instance R55 of RESISTOR, params={'resistance': 4.5 prefix:None} connections=['A: [connection R55/A =>[signal: clknet_0_scan_clk:44 w=1]]', 'B: [connection R55/B =>[signal: clknet_0_scan_clk:6 w=1]]']]
R55 clknet_0_scan_clk:44 clknet_0_scan_clk:6  R=4.5
** [instance R56 of RESISTOR, params={'resistance': 2.55357 prefix:None} connections=['A: [connection R56/A =>[signal: clknet_0_scan_clk:44 w=1]]', 'B: [connection R56/B =>[signal: clknet_0_scan_clk:49 w=1]]']]
R56 clknet_0_scan_clk:44 clknet_0_scan_clk:49  R=2.55357
** [instance R57 of RESISTOR, params={'resistance': 18.5679 prefix:None} connections=['A: [connection R57/A =>[signal: clkbuf_1_1__f_scan_clk:A w=1]]', 'B: [connection R57/B =>[signal: clknet_0_scan_clk:49 w=1]]']]
R57 clkbuf_1_1__f_scan_clk:A clknet_0_scan_clk:49  R=18.5679
** [instance R58 of RESISTOR, params={'resistance': 19.8357 prefix:None} connections=['A: [connection R58/A =>[signal: clkbuf_1_0__f_scan_clk:X w=1]]', 'B: [connection R58/B =>[signal: clknet_1_0__leaf_scan_clk:10 w=1]]']]
R58 clkbuf_1_0__f_scan_clk:X clknet_1_0__leaf_scan_clk:10  R=19.8357
** [instance R59 of RESISTOR, params={'resistance': 18.4071 prefix:None} connections=['A: [connection R59/A =>[signal: clkbuf_1_0__f_scan_clk:X w=1]]', 'B: [connection R59/B =>[signal: clknet_1_0__leaf_scan_clk:81 w=1]]']]
R59 clkbuf_1_0__f_scan_clk:X clknet_1_0__leaf_scan_clk:81  R=18.4071
** [instance R60 of RESISTOR, params={'resistance': 4.98214 prefix:None} connections=['A: [connection R60/A =>[signal: clknet_1_0__leaf_scan_clk:10 w=1]]', 'B: [connection R60/B =>[signal: clknet_1_0__leaf_scan_clk:12 w=1]]']]
R60 clknet_1_0__leaf_scan_clk:10 clknet_1_0__leaf_scan_clk:12  R=4.98214
** [instance R61 of RESISTOR, params={'resistance': 1.94643 prefix:None} connections=['A: [connection R61/A =>[signal: clknet_1_0__leaf_scan_clk:12 w=1]]', 'B: [connection R61/B =>[signal: clknet_1_0__leaf_scan_clk:14 w=1]]']]
R61 clknet_1_0__leaf_scan_clk:12 clknet_1_0__leaf_scan_clk:14  R=1.94643
** [instance R62 of RESISTOR, params={'resistance': 10.3571 prefix:None} connections=['A: [connection R62/A =>[signal: clknet_1_0__leaf_scan_clk:14 w=1]]', 'B: [connection R62/B =>[signal: clknet_1_0__leaf_scan_clk:20 w=1]]']]
R62 clknet_1_0__leaf_scan_clk:14 clknet_1_0__leaf_scan_clk:20  R=10.3571
** [instance R63 of RESISTOR, params={'resistance': 11.2143 prefix:None} connections=['A: [connection R63/A =>[signal: clknet_1_0__leaf_scan_clk:14 w=1]]', 'B: [connection R63/B =>[signal: clknet_1_0__leaf_scan_clk:40 w=1]]']]
R63 clknet_1_0__leaf_scan_clk:14 clknet_1_0__leaf_scan_clk:40  R=11.2143
** [instance R64 of RESISTOR, params={'resistance': 17.2464 prefix:None} connections=['A: [connection R64/A =>[signal: _71_:CLK w=1]]', 'B: [connection R64/B =>[signal: clknet_1_0__leaf_scan_clk:20 w=1]]']]
R64 _71_:CLK clknet_1_0__leaf_scan_clk:20  R=17.2464
** [instance R65 of RESISTOR, params={'resistance': 9.3 prefix:None} connections=['A: [connection R65/A =>[signal: _69_:CLK w=1]]', 'B: [connection R65/B =>[signal: clknet_1_0__leaf_scan_clk:20 w=1]]']]
R65 _69_:CLK clknet_1_0__leaf_scan_clk:20  R=9.3
** [instance R66 of RESISTOR, params={'resistance': 9.3 prefix:None} connections=['A: [connection R66/A =>[signal: _68_:CLK w=1]]', 'B: [connection R66/B =>[signal: clknet_1_0__leaf_scan_clk:40 w=1]]']]
R66 _68_:CLK clknet_1_0__leaf_scan_clk:40  R=9.3
** [instance R67 of RESISTOR, params={'resistance': 9.83571 prefix:None} connections=['A: [connection R67/A =>[signal: _70_:CLK w=1]]', 'B: [connection R67/B =>[signal: clknet_1_0__leaf_scan_clk:40 w=1]]']]
R67 _70_:CLK clknet_1_0__leaf_scan_clk:40  R=9.83571
** [instance R68 of RESISTOR, params={'resistance': 14.3357 prefix:None} connections=['A: [connection R68/A =>[signal: _67_:CLK w=1]]', 'B: [connection R68/B =>[signal: clknet_1_0__leaf_scan_clk:12 w=1]]']]
R68 _67_:CLK clknet_1_0__leaf_scan_clk:12  R=14.3357
** [instance R69 of RESISTOR, params={'resistance': 14.3357 prefix:None} connections=['A: [connection R69/A =>[signal: _65_:CLK w=1]]', 'B: [connection R69/B =>[signal: clknet_1_0__leaf_scan_clk:10 w=1]]']]
R69 _65_:CLK clknet_1_0__leaf_scan_clk:10  R=14.3357
** [instance R70 of RESISTOR, params={'resistance': 13.8 prefix:None} connections=['A: [connection R70/A =>[signal: _63_:CLK w=1]]', 'B: [connection R70/B =>[signal: clknet_1_0__leaf_scan_clk:81 w=1]]']]
R70 _63_:CLK clknet_1_0__leaf_scan_clk:81  R=13.8
** [instance R71 of RESISTOR, params={'resistance': 1.94643 prefix:None} connections=['A: [connection R71/A =>[signal: clknet_1_0__leaf_scan_clk:81 w=1]]', 'B: [connection R71/B =>[signal: clknet_1_0__leaf_scan_clk:90 w=1]]']]
R71 clknet_1_0__leaf_scan_clk:81 clknet_1_0__leaf_scan_clk:90  R=1.94643
** [instance R72 of RESISTOR, params={'resistance': 17.9429 prefix:None} connections=['A: [connection R72/A =>[signal: _64_:CLK w=1]]', 'B: [connection R72/B =>[signal: clknet_1_0__leaf_scan_clk:90 w=1]]']]
R72 _64_:CLK clknet_1_0__leaf_scan_clk:90  R=17.9429
** [instance R73 of RESISTOR, params={'resistance': 19.5143 prefix:None} connections=['A: [connection R73/A =>[signal: _62_:CLK w=1]]', 'B: [connection R73/B =>[signal: clknet_1_0__leaf_scan_clk:90 w=1]]']]
R73 _62_:CLK clknet_1_0__leaf_scan_clk:90  R=19.5143
** [instance R74 of RESISTOR, params={'resistance': 18.0321 prefix:None} connections=['A: [connection R74/A =>[signal: clkbuf_1_1__f_scan_clk:X w=1]]', 'B: [connection R74/B =>[signal: clknet_1_1__leaf_scan_clk:8 w=1]]']]
R74 clkbuf_1_1__f_scan_clk:X clknet_1_1__leaf_scan_clk:8  R=18.0321
** [instance R75 of RESISTOR, params={'resistance': 1.03571 prefix:None} connections=['A: [connection R75/A =>[signal: clknet_1_1__leaf_scan_clk:10 w=1]]', 'B: [connection R75/B =>[signal: clknet_1_1__leaf_scan_clk:8 w=1]]']]
R75 clknet_1_1__leaf_scan_clk:10 clknet_1_1__leaf_scan_clk:8  R=1.03571
** [instance R76 of RESISTOR, params={'resistance': 6.5 prefix:None} connections=['A: [connection R76/A =>[signal: clknet_1_1__leaf_scan_clk:10 w=1]]', 'B: [connection R76/B =>[signal: clknet_1_1__leaf_scan_clk:23 w=1]]']]
R76 clknet_1_1__leaf_scan_clk:10 clknet_1_1__leaf_scan_clk:23  R=6.5
** [instance R77 of RESISTOR, params={'resistance': 15.4786 prefix:None} connections=['A: [connection R77/A =>[signal: _74_:CLK w=1]]', 'B: [connection R77/B =>[signal: clknet_1_1__leaf_scan_clk:10 w=1]]']]
R77 _74_:CLK clknet_1_1__leaf_scan_clk:10  R=15.4786
** [instance R78 of RESISTOR, params={'resistance': 10.2679 prefix:None} connections=['A: [connection R78/A =>[signal: clknet_1_1__leaf_scan_clk:23 w=1]]', 'B: [connection R78/B =>[signal: clknet_1_1__leaf_scan_clk:29 w=1]]']]
R78 clknet_1_1__leaf_scan_clk:23 clknet_1_1__leaf_scan_clk:29  R=10.2679
** [instance R79 of RESISTOR, params={'resistance': 12.7107 prefix:None} connections=['A: [connection R79/A =>[signal: _73_:CLK w=1]]', 'B: [connection R79/B =>[signal: clknet_1_1__leaf_scan_clk:29 w=1]]']]
R79 _73_:CLK clknet_1_1__leaf_scan_clk:29  R=12.7107
** [instance R80 of RESISTOR, params={'resistance': 20.55 prefix:None} connections=['A: [connection R80/A =>[signal: _72_:CLK w=1]]', 'B: [connection R80/B =>[signal: clknet_1_1__leaf_scan_clk:29 w=1]]']]
R80 _72_:CLK clknet_1_1__leaf_scan_clk:29  R=20.55
** [instance R81 of RESISTOR, params={'resistance': 19.175 prefix:None} connections=['A: [connection R81/A =>[signal: _75_:CLK w=1]]', 'B: [connection R81/B =>[signal: clknet_1_1__leaf_scan_clk:23 w=1]]']]
R81 _75_:CLK clknet_1_1__leaf_scan_clk:23  R=19.175
** [instance R82 of RESISTOR, params={'resistance': 3.46429 prefix:None} connections=['A: [connection R82/A =>[signal: clknet_1_1__leaf_scan_clk:60 w=1]]', 'B: [connection R82/B =>[signal: clknet_1_1__leaf_scan_clk:8 w=1]]']]
R82 clknet_1_1__leaf_scan_clk:60 clknet_1_1__leaf_scan_clk:8  R=3.46429
** [instance R83 of RESISTOR, params={'resistance': 9.33929 prefix:None} connections=['A: [connection R83/A =>[signal: clknet_1_1__leaf_scan_clk:60 w=1]]', 'B: [connection R83/B =>[signal: clknet_1_1__leaf_scan_clk:75 w=1]]']]
R83 clknet_1_1__leaf_scan_clk:60 clknet_1_1__leaf_scan_clk:75  R=9.33929
** [instance R84 of RESISTOR, params={'resistance': 14.3357 prefix:None} connections=['A: [connection R84/A =>[signal: _76_:CLK w=1]]', 'B: [connection R84/B =>[signal: clknet_1_1__leaf_scan_clk:60 w=1]]']]
R84 _76_:CLK clknet_1_1__leaf_scan_clk:60  R=14.3357
** [instance R85 of RESISTOR, params={'resistance': 12.0179 prefix:None} connections=['A: [connection R85/A =>[signal: clknet_1_1__leaf_scan_clk:75 w=1]]', 'B: [connection R85/B =>[signal: clknet_1_1__leaf_scan_clk:79 w=1]]']]
R85 clknet_1_1__leaf_scan_clk:75 clknet_1_1__leaf_scan_clk:79  R=12.0179
** [instance R86 of RESISTOR, params={'resistance': 4.67857 prefix:None} connections=['A: [connection R86/A =>[signal: clknet_1_1__leaf_scan_clk:79 w=1]]', 'B: [connection R86/B =>[signal: clknet_1_1__leaf_scan_clk:81 w=1]]']]
R86 clknet_1_1__leaf_scan_clk:79 clknet_1_1__leaf_scan_clk:81  R=4.67857
** [instance R87 of RESISTOR, params={'resistance': 20.175 prefix:None} connections=['A: [connection R87/A =>[signal: _66_:CLK w=1]]', 'B: [connection R87/B =>[signal: clknet_1_1__leaf_scan_clk:81 w=1]]']]
R87 _66_:CLK clknet_1_1__leaf_scan_clk:81  R=20.175
** [instance R88 of RESISTOR, params={'resistance': 15.1571 prefix:None} connections=['A: [connection R88/A =>[signal: _60_:CLK w=1]]', 'B: [connection R88/B =>[signal: clknet_1_1__leaf_scan_clk:81 w=1]]']]
R88 _60_:CLK clknet_1_1__leaf_scan_clk:81  R=15.1571
** [instance R89 of RESISTOR, params={'resistance': 17.1929 prefix:None} connections=['A: [connection R89/A =>[signal: _61_:CLK w=1]]', 'B: [connection R89/B =>[signal: clknet_1_1__leaf_scan_clk:79 w=1]]']]
R89 _61_:CLK clknet_1_1__leaf_scan_clk:79  R=17.1929
** [instance R90 of RESISTOR, params={'resistance': 9.3 prefix:None} connections=['A: [connection R90/A =>[signal: _59_:CLK w=1]]', 'B: [connection R90/B =>[signal: clknet_1_1__leaf_scan_clk:75 w=1]]']]
R90 _59_:CLK clknet_1_1__leaf_scan_clk:75  R=9.3
** [instance R91 of RESISTOR, params={'resistance': 43.7964 prefix:None} connections=['A: [connection R91/A =>[signal: _75_:Q w=1]]', 'B: [connection R91/B =>[signal: hold24:A w=1]]']]
R91 _75_:Q hold24:A  R=43.7964
** [instance R92 of RESISTOR, params={'resistance': 22.0107 prefix:None} connections=['A: [connection R92/A =>[signal: _35_:A0 w=1]]', 'B: [connection R92/B =>[signal: _75_:Q w=1]]']]
R92 _35_:A0 _75_:Q  R=22.0107
** [instance R93 of RESISTOR, params={'resistance': 15.1571 prefix:None} connections=['A: [connection R93/A =>[signal: _64_:Q w=1]]', 'B: [connection R93/B =>[signal: mem[10]:8 w=1]]']]
R93 _64_:Q mem[10]:8  R=15.1571
** [instance R94 of RESISTOR, params={'resistance': 19.7286 prefix:None} connections=['A: [connection R94/A =>[signal: _31_:A2 w=1]]', 'B: [connection R94/B =>[signal: mem[10]:8 w=1]]']]
R94 _31_:A2 mem[10]:8  R=19.7286
** [instance R95 of RESISTOR, params={'resistance': 20.3 prefix:None} connections=['A: [connection R95/A =>[signal: hold14:A w=1]]', 'B: [connection R95/B =>[signal: mem[10]:8 w=1]]']]
R95 hold14:A mem[10]:8  R=20.3
** [instance R96 of RESISTOR, params={'resistance': 13.8 prefix:None} connections=['A: [connection R96/A =>[signal: _63_:Q w=1]]', 'B: [connection R96/B =>[signal: mem[11]:6 w=1]]']]
R96 _63_:Q mem[11]:6  R=13.8
** [instance R97 of RESISTOR, params={'resistance': 16.9071 prefix:None} connections=['A: [connection R97/A =>[signal: _31_:A3 w=1]]', 'B: [connection R97/B =>[signal: mem[11]:6 w=1]]']]
R97 _31_:A3 mem[11]:6  R=16.9071
** [instance R98 of RESISTOR, params={'resistance': 22.7643 prefix:None} connections=['A: [connection R98/A =>[signal: hold23:A w=1]]', 'B: [connection R98/B =>[signal: mem[11]:6 w=1]]']]
R98 hold23:A mem[11]:6  R=22.7643
** [instance R99 of RESISTOR, params={'resistance': 10.6571 prefix:None} connections=['A: [connection R99/A =>[signal: _62_:Q w=1]]', 'B: [connection R99/B =>[signal: mem[12]:6 w=1]]']]
R99 _62_:Q mem[12]:6  R=10.6571
** [instance R100 of RESISTOR, params={'resistance': 23.7286 prefix:None} connections=['A: [connection R100/A =>[signal: hold27:A w=1]]', 'B: [connection R100/B =>[signal: mem[12]:6 w=1]]']]
R100 hold27:A mem[12]:6  R=23.7286
** [instance R101 of RESISTOR, params={'resistance': 14.8393 prefix:None} connections=['A: [connection R101/A =>[signal: mem[12]:27 w=1]]', 'B: [connection R101/B =>[signal: mem[12]:6 w=1]]']]
R101 mem[12]:27 mem[12]:6  R=14.8393
** [instance R102 of RESISTOR, params={'resistance': 10.2464 prefix:None} connections=['A: [connection R102/A =>[signal: _33_:A0 w=1]]', 'B: [connection R102/B =>[signal: mem[12]:27 w=1]]']]
R102 _33_:A0 mem[12]:27  R=10.2464
** [instance R103 of RESISTOR, params={'resistance': 23.9071 prefix:None} connections=['A: [connection R103/A =>[signal: _43_:A1 w=1]]', 'B: [connection R103/B =>[signal: mem[12]:27 w=1]]']]
R103 _43_:A1 mem[12]:27  R=23.9071
** [instance R104 of RESISTOR, params={'resistance': 13.8 prefix:None} connections=['A: [connection R104/A =>[signal: _61_:Q w=1]]', 'B: [connection R104/B =>[signal: mem[13]:6 w=1]]']]
R104 _61_:Q mem[13]:6  R=13.8
** [instance R105 of RESISTOR, params={'resistance': 3.61607 prefix:None} connections=['A: [connection R105/A =>[signal: mem[13]:6 w=1]]', 'B: [connection R105/B =>[signal: mem[13]:8 w=1]]']]
R105 mem[13]:6 mem[13]:8  R=3.61607
** [instance R106 of RESISTOR, params={'resistance': 15.8268 prefix:None} connections=['A: [connection R106/A =>[signal: _42_:A1 w=1]]', 'B: [connection R106/B =>[signal: mem[13]:8 w=1]]']]
R106 _42_:A1 mem[13]:8  R=15.8268
** [instance R107 of RESISTOR, params={'resistance': 21.5203 prefix:None} connections=['A: [connection R107/A =>[signal: _33_:A1 w=1]]', 'B: [connection R107/B =>[signal: mem[13]:8 w=1]]']]
R107 _33_:A1 mem[13]:8  R=21.5203
** [instance R108 of RESISTOR, params={'resistance': 18.4071 prefix:None} connections=['A: [connection R108/A =>[signal: hold20:A w=1]]', 'B: [connection R108/B =>[signal: mem[13]:6 w=1]]']]
R108 hold20:A mem[13]:6  R=18.4071
** [instance R109 of RESISTOR, params={'resistance': 18.5143 prefix:None} connections=['A: [connection R109/A =>[signal: _60_:Q w=1]]', 'B: [connection R109/B =>[signal: mem[14]:10 w=1]]']]
R109 _60_:Q mem[14]:10  R=18.5143
** [instance R110 of RESISTOR, params={'resistance': 14.7464 prefix:None} connections=['A: [connection R110/A =>[signal: _33_:A2 w=1]]', 'B: [connection R110/B =>[signal: mem[14]:10 w=1]]']]
R110 _33_:A2 mem[14]:10  R=14.7464
** [instance R111 of RESISTOR, params={'resistance': 22.8714 prefix:None} connections=['A: [connection R111/A =>[signal: hold16:A w=1]]', 'B: [connection R111/B =>[signal: mem[14]:10 w=1]]']]
R111 hold16:A mem[14]:10  R=22.8714
** [instance R112 of RESISTOR, params={'resistance': 28.3143 prefix:None} connections=['A: [connection R112/A =>[signal: _33_:A3 w=1]]', 'B: [connection R112/B =>[signal: _59_:Q w=1]]']]
R112 _33_:A3 _59_:Q  R=28.3143
** [instance R113 of RESISTOR, params={'resistance': 32.7429 prefix:None} connections=['A: [connection R113/A =>[signal: _59_:Q w=1]]', 'B: [connection R113/B =>[signal: hold22:A w=1]]']]
R113 _59_:Q hold22:A  R=32.7429
** [instance R114 of RESISTOR, params={'resistance': 14.0768 prefix:None} connections=['A: [connection R114/A =>[signal: _73_:Q w=1]]', 'B: [connection R114/B =>[signal: mem[1]:8 w=1]]']]
R114 _73_:Q mem[1]:8  R=14.0768
** [instance R115 of RESISTOR, params={'resistance': 23.7196 prefix:None} connections=['A: [connection R115/A =>[signal: _35_:A1 w=1]]', 'B: [connection R115/B =>[signal: mem[1]:8 w=1]]']]
R115 _35_:A1 mem[1]:8  R=23.7196
** [instance R116 of RESISTOR, params={'resistance': 23.5994 prefix:None} connections=['A: [connection R116/A =>[signal: hold26:A w=1]]', 'B: [connection R116/B =>[signal: mem[1]:8 w=1]]']]
R116 hold26:A mem[1]:8  R=23.5994
** [instance R117 of RESISTOR, params={'resistance': 15.4429 prefix:None} connections=['A: [connection R117/A =>[signal: _72_:Q w=1]]', 'B: [connection R117/B =>[signal: mem[2]:8 w=1]]']]
R117 _72_:Q mem[2]:8  R=15.4429
** [instance R118 of RESISTOR, params={'resistance': 18.4429 prefix:None} connections=['A: [connection R118/A =>[signal: hold30:A w=1]]', 'B: [connection R118/B =>[signal: mem[2]:8 w=1]]']]
R118 hold30:A mem[2]:8  R=18.4429
** [instance R119 of RESISTOR, params={'resistance': 16.9607 prefix:None} connections=['A: [connection R119/A =>[signal: _35_:A2 w=1]]', 'B: [connection R119/B =>[signal: mem[2]:8 w=1]]']]
R119 _35_:A2 mem[2]:8  R=16.9607
** [instance R120 of RESISTOR, params={'resistance': 16.5857 prefix:None} connections=['A: [connection R120/A =>[signal: _71_:Q w=1]]', 'B: [connection R120/B =>[signal: mem[3]:10 w=1]]']]
R120 _71_:Q mem[3]:10  R=16.5857
** [instance R121 of RESISTOR, params={'resistance': 20.9071 prefix:None} connections=['A: [connection R121/A =>[signal: _52_:A1 w=1]]', 'B: [connection R121/B =>[signal: mem[3]:10 w=1]]']]
R121 _52_:A1 mem[3]:10  R=20.9071
** [instance R122 of RESISTOR, params={'resistance': 9.17857 prefix:None} connections=['A: [connection R122/A =>[signal: mem[3]:10 w=1]]', 'B: [connection R122/B =>[signal: mem[3]:23 w=1]]']]
R122 mem[3]:10 mem[3]:23  R=9.17857
** [instance R123 of RESISTOR, params={'resistance': 11.0679 prefix:None} connections=['A: [connection R123/A =>[signal: _35_:A3 w=1]]', 'B: [connection R123/B =>[signal: mem[3]:23 w=1]]']]
R123 _35_:A3 mem[3]:23  R=11.0679
** [instance R124 of RESISTOR, params={'resistance': 42.2857 prefix:None} connections=['A: [connection R124/A =>[signal: mem[3]:23 w=1]]', 'B: [connection R124/B =>[signal: mem[3]:40 w=1]]']]
R124 mem[3]:23 mem[3]:40  R=42.2857
** [instance R125 of RESISTOR, params={'resistance': 9.3 prefix:None} connections=['A: [connection R125/A =>[signal: hold36:A w=1]]', 'B: [connection R125/B =>[signal: mem[3]:40 w=1]]']]
R125 hold36:A mem[3]:40  R=9.3
** [instance R126 of RESISTOR, params={'resistance': 15.2911 prefix:None} connections=['A: [connection R126/A =>[signal: _70_:Q w=1]]', 'B: [connection R126/B =>[signal: mem[4]:8 w=1]]']]
R126 _70_:Q mem[4]:8  R=15.2911
** [instance R127 of RESISTOR, params={'resistance': 19.0054 prefix:None} connections=['A: [connection R127/A =>[signal: _36_:A0 w=1]]', 'B: [connection R127/B =>[signal: mem[4]:8 w=1]]']]
R127 _36_:A0 mem[4]:8  R=19.0054
** [instance R128 of RESISTOR, params={'resistance': 24.0427 prefix:None} connections=['A: [connection R128/A =>[signal: hold33:A w=1]]', 'B: [connection R128/B =>[signal: mem[4]:8 w=1]]']]
R128 hold33:A mem[4]:8  R=24.0427
** [instance R129 of RESISTOR, params={'resistance': 25.7107 prefix:None} connections=['A: [connection R129/A =>[signal: _69_:Q w=1]]', 'B: [connection R129/B =>[signal: mem[5]:10 w=1]]']]
R129 _69_:Q mem[5]:10  R=25.7107
** [instance R130 of RESISTOR, params={'resistance': 44.0357 prefix:None} connections=['A: [connection R130/A =>[signal: mem[5]:10 w=1]]', 'B: [connection R130/B =>[signal: mem[5]:26 w=1]]']]
R130 mem[5]:10 mem[5]:26  R=44.0357
** [instance R131 of RESISTOR, params={'resistance': 9.3 prefix:None} connections=['A: [connection R131/A =>[signal: hold35:A w=1]]', 'B: [connection R131/B =>[signal: mem[5]:26 w=1]]']]
R131 hold35:A mem[5]:26  R=9.3
** [instance R132 of RESISTOR, params={'resistance': 9.83571 prefix:None} connections=['A: [connection R132/A =>[signal: _36_:A1 w=1]]', 'B: [connection R132/B =>[signal: mem[5]:10 w=1]]']]
R132 _36_:A1 mem[5]:10  R=9.83571
** [instance R133 of RESISTOR, params={'resistance': 27.3536 prefix:None} connections=['A: [connection R133/A =>[signal: _68_:Q w=1]]', 'B: [connection R133/B =>[signal: mem[6]:14 w=1]]']]
R133 _68_:Q mem[6]:14  R=27.3536
** [instance R134 of RESISTOR, params={'resistance': 5.44643 prefix:None} connections=['A: [connection R134/A =>[signal: mem[6]:14 w=1]]', 'B: [connection R134/B =>[signal: mem[6]:18 w=1]]']]
R134 mem[6]:14 mem[6]:18  R=5.44643
** [instance R135 of RESISTOR, params={'resistance': 13.2643 prefix:None} connections=['A: [connection R135/A =>[signal: _49_:A1 w=1]]', 'B: [connection R135/B =>[signal: mem[6]:18 w=1]]']]
R135 _49_:A1 mem[6]:18  R=13.2643
** [instance R136 of RESISTOR, params={'resistance': 9.3 prefix:None} connections=['A: [connection R136/A =>[signal: _36_:A2 w=1]]', 'B: [connection R136/B =>[signal: mem[6]:18 w=1]]']]
R136 _36_:A2 mem[6]:18  R=9.3
** [instance R137 of RESISTOR, params={'resistance': 45.5321 prefix:None} connections=['A: [connection R137/A =>[signal: hold37:A w=1]]', 'B: [connection R137/B =>[signal: mem[6]:14 w=1]]']]
R137 hold37:A mem[6]:14  R=45.5321
** [instance R138 of RESISTOR, params={'resistance': 17.925 prefix:None} connections=['A: [connection R138/A =>[signal: _67_:Q w=1]]', 'B: [connection R138/B =>[signal: mem[7]:10 w=1]]']]
R138 _67_:Q mem[7]:10  R=17.925
** [instance R139 of RESISTOR, params={'resistance': 17.6214 prefix:None} connections=['A: [connection R139/A =>[signal: _36_:A3 w=1]]', 'B: [connection R139/B =>[signal: mem[7]:10 w=1]]']]
R139 _36_:A3 mem[7]:10  R=17.6214
** [instance R140 of RESISTOR, params={'resistance': 41.8179 prefix:None} connections=['A: [connection R140/A =>[signal: hold18:A w=1]]', 'B: [connection R140/B =>[signal: mem[7]:10 w=1]]']]
R140 hold18:A mem[7]:10  R=41.8179
** [instance R141 of RESISTOR, params={'resistance': 25.05 prefix:None} connections=['A: [connection R141/A =>[signal: _66_:Q w=1]]', 'B: [connection R141/B =>[signal: mem[8]:10 w=1]]']]
R141 _66_:Q mem[8]:10  R=25.05
** [instance R142 of RESISTOR, params={'resistance': 14.3357 prefix:None} connections=['A: [connection R142/A =>[signal: _31_:A0 w=1]]', 'B: [connection R142/B =>[signal: mem[8]:10 w=1]]']]
R142 _31_:A0 mem[8]:10  R=14.3357
** [instance R143 of RESISTOR, params={'resistance': 20.6036 prefix:None} connections=['A: [connection R143/A =>[signal: hold29:A w=1]]', 'B: [connection R143/B =>[signal: mem[8]:10 w=1]]']]
R143 hold29:A mem[8]:10  R=20.6036
** [instance R144 of RESISTOR, params={'resistance': 23.6036 prefix:None} connections=['A: [connection R144/A =>[signal: _65_:Q w=1]]', 'B: [connection R144/B =>[signal: mem[9]:10 w=1]]']]
R144 _65_:Q mem[9]:10  R=23.6036
** [instance R145 of RESISTOR, params={'resistance': 13.8 prefix:None} connections=['A: [connection R145/A =>[signal: _31_:A1 w=1]]', 'B: [connection R145/B =>[signal: mem[9]:10 w=1]]']]
R145 _31_:A1 mem[9]:10  R=13.8
** [instance R146 of RESISTOR, params={'resistance': 12.3214 prefix:None} connections=['A: [connection R146/A =>[signal: mem[9]:10 w=1]]', 'B: [connection R146/B =>[signal: mem[9]:23 w=1]]']]
R146 mem[9]:10 mem[9]:23  R=12.3214
** [instance R147 of RESISTOR, params={'resistance': 13.55 prefix:None} connections=['A: [connection R147/A =>[signal: hold31:A w=1]]', 'B: [connection R147/B =>[signal: mem[9]:23 w=1]]']]
R147 hold31:A mem[9]:23  R=13.55
** [instance R148 of RESISTOR, params={'resistance': 23.925 prefix:None} connections=['A: [connection R148/A =>[signal: _46_:A1 w=1]]', 'B: [connection R148/B =>[signal: mem[9]:23 w=1]]']]
R148 _46_:A1 mem[9]:23  R=23.925
** [instance R149 of RESISTOR, params={'resistance': 32.925 prefix:None} connections=['A: [connection R149/A =>[signal: input1:X w=1]]', 'B: [connection R149/B =>[signal: net1:10 w=1]]']]
R149 input1:X net1:10  R=32.925
** [instance R150 of RESISTOR, params={'resistance': 14.875 prefix:None} connections=['A: [connection R150/A =>[signal: _36_:S0 w=1]]', 'B: [connection R150/B =>[signal: net1:10 w=1]]']]
R150 _36_:S0 net1:10  R=14.875
** [instance R151 of RESISTOR, params={'resistance': 4.5 prefix:None} connections=['A: [connection R151/A =>[signal: _31_:S0 w=1]]', 'B: [connection R151/B =>[signal: net1:10 w=1]]']]
R151 _31_:S0 net1:10  R=4.5
** [instance R152 of RESISTOR, params={'resistance': 16.5 prefix:None} connections=['A: [connection R152/A =>[signal: _31_:S0 w=1]]', 'B: [connection R152/B =>[signal: _33_:S0 w=1]]']]
R152 _31_:S0 _33_:S0  R=16.5
** [instance R153 of RESISTOR, params={'resistance': 2.46429 prefix:None} connections=['A: [connection R153/A =>[signal: _35_:S0 w=1]]', 'B: [connection R153/B =>[signal: _36_:S0 w=1]]']]
R153 _35_:S0 _36_:S0  R=2.46429
** [instance R154 of RESISTOR, params={'resistance': 42.3893 prefix:None} connections=['A: [connection R154/A =>[signal: _77_:Q w=1]]', 'B: [connection R154/B =>[signal: net10:14 w=1]]']]
R154 _77_:Q net10:14  R=42.3893
** [instance R155 of RESISTOR, params={'resistance': 9.3 prefix:None} connections=['A: [connection R155/A =>[signal: output10:A w=1]]', 'B: [connection R155/B =>[signal: net10:14 w=1]]']]
R155 output10:A net10:14  R=9.3
** [instance R156 of RESISTOR, params={'resistance': 17.1036 prefix:None} connections=['A: [connection R156/A =>[signal: _76_:Q w=1]]', 'B: [connection R156/B =>[signal: net11:10 w=1]]']]
R156 _76_:Q net11:10  R=17.1036
** [instance R157 of RESISTOR, params={'resistance': 14.3357 prefix:None} connections=['A: [connection R157/A =>[signal: _40_:S w=1]]', 'B: [connection R157/B =>[signal: net11:10 w=1]]']]
R157 _40_:S net11:10  R=14.3357
** [instance R158 of RESISTOR, params={'resistance': 7.41071 prefix:None} connections=['A: [connection R158/A =>[signal: net11:10 w=1]]', 'B: [connection R158/B =>[signal: net11:21 w=1]]']]
R158 net11:10 net11:21  R=7.41071
** [instance R159 of RESISTOR, params={'resistance': 16.3893 prefix:None} connections=['A: [connection R159/A =>[signal: output11:A w=1]]', 'B: [connection R159/B =>[signal: net11:21 w=1]]']]
R159 output11:A net11:21  R=16.3893
** [instance R160 of RESISTOR, params={'resistance': 16.05 prefix:None} connections=['A: [connection R160/A =>[signal: hold28:A w=1]]', 'B: [connection R160/B =>[signal: net11:21 w=1]]']]
R160 hold28:A net11:21  R=16.05
** [instance R161 of RESISTOR, params={'resistance': 20.3 prefix:None} connections=['A: [connection R161/A =>[signal: fanout12:X w=1]]', 'B: [connection R161/B =>[signal: net12:8 w=1]]']]
R161 fanout12:X net12:8  R=20.3
** [instance R162 of RESISTOR, params={'resistance': 5.89286 prefix:None} connections=['A: [connection R162/A =>[signal: net12:16 w=1]]', 'B: [connection R162/B =>[signal: net12:8 w=1]]']]
R162 net12:16 net12:8  R=5.89286
** [instance R163 of RESISTOR, params={'resistance': 13.0714 prefix:None} connections=['A: [connection R163/A =>[signal: net12:16 w=1]]', 'B: [connection R163/B =>[signal: net12:22 w=1]]']]
R163 net12:16 net12:22  R=13.0714
** [instance R164 of RESISTOR, params={'resistance': 5.82143 prefix:None} connections=['A: [connection R164/A =>[signal: net12:22 w=1]]', 'B: [connection R164/B =>[signal: net12:26 w=1]]']]
R164 net12:22 net12:26  R=5.82143
** [instance R165 of RESISTOR, params={'resistance': 10.4286 prefix:None} connections=['A: [connection R165/A =>[signal: net12:26 w=1]]', 'B: [connection R165/B =>[signal: net12:32 w=1]]']]
R165 net12:26 net12:32  R=10.4286
** [instance R166 of RESISTOR, params={'resistance': 22.8393 prefix:None} connections=['A: [connection R166/A =>[signal: net12:32 w=1]]', 'B: [connection R166/B =>[signal: net12:46 w=1]]']]
R166 net12:32 net12:46  R=22.8393
** [instance R167 of RESISTOR, params={'resistance': 9.3 prefix:None} connections=['A: [connection R167/A =>[signal: _48_:S w=1]]', 'B: [connection R167/B =>[signal: net12:46 w=1]]']]
R167 _48_:S net12:46  R=9.3
** [instance R168 of RESISTOR, params={'resistance': 4.57143 prefix:None} connections=['A: [connection R168/A =>[signal: net12:46 w=1]]', 'B: [connection R168/B =>[signal: net12:57 w=1]]']]
R168 net12:46 net12:57  R=4.57143
** [instance R169 of RESISTOR, params={'resistance': 10.1429 prefix:None} connections=['A: [connection R169/A =>[signal: net12:57 w=1]]', 'B: [connection R169/B =>[signal: net12:65 w=1]]']]
R169 net12:57 net12:65  R=10.1429
** [instance R170 of RESISTOR, params={'resistance': 32.7643 prefix:None} connections=['A: [connection R170/A =>[signal: _44_:S w=1]]', 'B: [connection R170/B =>[signal: net12:65 w=1]]']]
R170 _44_:S net12:65  R=32.7643
** [instance R171 of RESISTOR, params={'resistance': 14.8357 prefix:None} connections=['A: [connection R171/A =>[signal: _51_:S w=1]]', 'B: [connection R171/B =>[signal: net12:65 w=1]]']]
R171 _51_:S net12:65  R=14.8357
** [instance R172 of RESISTOR, params={'resistance': 19.4107 prefix:None} connections=['A: [connection R172/A =>[signal: net12:103 w=1]]', 'B: [connection R172/B =>[signal: net12:57 w=1]]']]
R172 net12:103 net12:57  R=19.4107
** [instance R173 of RESISTOR, params={'resistance': 9.3 prefix:None} connections=['A: [connection R173/A =>[signal: _52_:S w=1]]', 'B: [connection R173/B =>[signal: net12:103 w=1]]']]
R173 _52_:S net12:103  R=9.3
** [instance R174 of RESISTOR, params={'resistance': 24.0857 prefix:None} connections=['A: [connection R174/A =>[signal: _50_:S w=1]]', 'B: [connection R174/B =>[signal: net12:103 w=1]]']]
R174 _50_:S net12:103  R=24.0857
** [instance R175 of RESISTOR, params={'resistance': 9.3 prefix:None} connections=['A: [connection R175/A =>[signal: _49_:S w=1]]', 'B: [connection R175/B =>[signal: net12:32 w=1]]']]
R175 _49_:S net12:32  R=9.3
** [instance R176 of RESISTOR, params={'resistance': 14.7464 prefix:None} connections=['A: [connection R176/A =>[signal: _53_:S w=1]]', 'B: [connection R176/B =>[signal: net12:26 w=1]]']]
R176 _53_:S net12:26  R=14.7464
** [instance R177 of RESISTOR, params={'resistance': 16.8179 prefix:None} connections=['A: [connection R177/A =>[signal: _47_:S w=1]]', 'B: [connection R177/B =>[signal: net12:22 w=1]]']]
R177 _47_:S net12:22  R=16.8179
** [instance R178 of RESISTOR, params={'resistance': 13.8536 prefix:None} connections=['A: [connection R178/A =>[signal: _45_:S w=1]]', 'B: [connection R178/B =>[signal: net12:16 w=1]]']]
R178 _45_:S net12:16  R=13.8536
** [instance R179 of RESISTOR, params={'resistance': 14.3357 prefix:None} connections=['A: [connection R179/A =>[signal: _46_:S w=1]]', 'B: [connection R179/B =>[signal: net12:8 w=1]]']]
R179 _46_:S net12:8  R=14.3357
** [instance R180 of RESISTOR, params={'resistance': 16.6929 prefix:None} connections=['A: [connection R180/A =>[signal: fanout13:X w=1]]', 'B: [connection R180/B =>[signal: net13:10 w=1]]']]
R180 fanout13:X net13:10  R=16.6929
** [instance R181 of RESISTOR, params={'resistance': 9.48214 prefix:None} connections=['A: [connection R181/A =>[signal: net13:10 w=1]]', 'B: [connection R181/B =>[signal: net13:14 w=1]]']]
R181 net13:10 net13:14  R=9.48214
** [instance R182 of RESISTOR, params={'resistance': 9.96429 prefix:None} connections=['A: [connection R182/A =>[signal: net13:10 w=1]]', 'B: [connection R182/B =>[signal: net13:82 w=1]]']]
R182 net13:10 net13:82  R=9.96429
** [instance R183 of RESISTOR, params={'resistance': 11.8893 prefix:None} connections=['A: [connection R183/A =>[signal: _43_:S w=1]]', 'B: [connection R183/B =>[signal: net13:14 w=1]]']]
R183 _43_:S net13:14  R=11.8893
** [instance R184 of RESISTOR, params={'resistance': 1.35714 prefix:None} connections=['A: [connection R184/A =>[signal: net13:14 w=1]]', 'B: [connection R184/B =>[signal: net13:23 w=1]]']]
R184 net13:14 net13:23  R=1.35714
** [instance R185 of RESISTOR, params={'resistance': 12.5714 prefix:None} connections=['A: [connection R185/A =>[signal: net13:23 w=1]]', 'B: [connection R185/B =>[signal: net13:31 w=1]]']]
R185 net13:23 net13:31  R=12.5714
** [instance R186 of RESISTOR, params={'resistance': 14.0357 prefix:None} connections=['A: [connection R186/A =>[signal: net13:31 w=1]]', 'B: [connection R186/B =>[signal: net13:35 w=1]]']]
R186 net13:31 net13:35  R=14.0357
** [instance R187 of RESISTOR, params={'resistance': 9.83571 prefix:None} connections=['A: [connection R187/A =>[signal: _55_:S w=1]]', 'B: [connection R187/B =>[signal: net13:35 w=1]]']]
R187 _55_:S net13:35  R=9.83571
** [instance R188 of RESISTOR, params={'resistance': 3.82143 prefix:None} connections=['A: [connection R188/A =>[signal: net13:35 w=1]]', 'B: [connection R188/B =>[signal: net13:44 w=1]]']]
R188 net13:35 net13:44  R=3.82143
** [instance R189 of RESISTOR, params={'resistance': 9.3 prefix:None} connections=['A: [connection R189/A =>[signal: _54_:S w=1]]', 'B: [connection R189/B =>[signal: net13:44 w=1]]']]
R189 _54_:S net13:44  R=9.3
** [instance R190 of RESISTOR, params={'resistance': 25.8714 prefix:None} connections=['A: [connection R190/A =>[signal: _57_:S w=1]]', 'B: [connection R190/B =>[signal: net13:44 w=1]]']]
R190 _57_:S net13:44  R=25.8714
** [instance R191 of RESISTOR, params={'resistance': 15.9964 prefix:None} connections=['A: [connection R191/A =>[signal: _56_:S w=1]]', 'B: [connection R191/B =>[signal: net13:31 w=1]]']]
R191 _56_:S net13:31  R=15.9964
** [instance R192 of RESISTOR, params={'resistance': 9.3 prefix:None} connections=['A: [connection R192/A =>[signal: _42_:S w=1]]', 'B: [connection R192/B =>[signal: net13:23 w=1]]']]
R192 _42_:S net13:23  R=9.3
** [instance R193 of RESISTOR, params={'resistance': 9.3 prefix:None} connections=['A: [connection R193/A =>[signal: _41_:S w=1]]', 'B: [connection R193/B =>[signal: net13:82 w=1]]']]
R193 _41_:S net13:82  R=9.3
** [instance R194 of RESISTOR, params={'resistance': 13.1214 prefix:None} connections=['A: [connection R194/A =>[signal: _58_:S w=1]]', 'B: [connection R194/B =>[signal: net13:82 w=1]]']]
R194 _58_:S net13:82  R=13.1214
** [instance R195 of RESISTOR, params={'resistance': 22.3714 prefix:None} connections=['A: [connection R195/A =>[signal: hold14:X w=1]]', 'B: [connection R195/B =>[signal: net14:10 w=1]]']]
R195 hold14:X net14:10  R=22.3714
** [instance R196 of RESISTOR, params={'resistance': 11.9071 prefix:None} connections=['A: [connection R196/A =>[signal: _46_:A0 w=1]]', 'B: [connection R196/B =>[signal: net14:10 w=1]]']]
R196 _46_:A0 net14:10  R=11.9071
** [instance R197 of RESISTOR, params={'resistance': 11.4786 prefix:None} connections=['A: [connection R197/A =>[signal: _45_:A1 w=1]]', 'B: [connection R197/B =>[signal: net14:10 w=1]]']]
R197 _45_:A1 net14:10  R=11.4786
** [instance R198 of RESISTOR, params={'resistance': 33.9616 prefix:None} connections=['A: [connection R198/A =>[signal: _64_:D w=1]]', 'B: [connection R198/B =>[signal: hold15:X w=1]]']]
R198 _64_:D hold15:X  R=33.9616
** [instance R199 of RESISTOR, params={'resistance': 18.8179 prefix:None} connections=['A: [connection R199/A =>[signal: hold16:X w=1]]', 'B: [connection R199/B =>[signal: net16:10 w=1]]']]
R199 hold16:X net16:10  R=18.8179
** [instance R200 of RESISTOR, params={'resistance': 23.9607 prefix:None} connections=['A: [connection R200/A =>[signal: _42_:A0 w=1]]', 'B: [connection R200/B =>[signal: net16:10 w=1]]']]
R200 _42_:A0 net16:10  R=23.9607
** [instance R201 of RESISTOR, params={'resistance': 13.8 prefix:None} connections=['A: [connection R201/A =>[signal: _41_:A1 w=1]]', 'B: [connection R201/B =>[signal: net16:10 w=1]]']]
R201 _41_:A1 net16:10  R=13.8
** [instance R202 of RESISTOR, params={'resistance': 44.5464 prefix:None} connections=['A: [connection R202/A =>[signal: _60_:D w=1]]', 'B: [connection R202/B =>[signal: hold17:X w=1]]']]
R202 _60_:D hold17:X  R=44.5464
** [instance R203 of RESISTOR, params={'resistance': 36.7286 prefix:None} connections=['A: [connection R203/A =>[signal: hold18:X w=1]]', 'B: [connection R203/B =>[signal: net18:10 w=1]]']]
R203 hold18:X net18:10  R=36.7286
** [instance R204 of RESISTOR, params={'resistance': 22.1036 prefix:None} connections=['A: [connection R204/A =>[signal: _48_:A1 w=1]]', 'B: [connection R204/B =>[signal: net18:10 w=1]]']]
R204 _48_:A1 net18:10  R=22.1036
** [instance R205 of RESISTOR, params={'resistance': 28.8893 prefix:None} connections=['A: [connection R205/A =>[signal: _49_:A0 w=1]]', 'B: [connection R205/B =>[signal: net18:10 w=1]]']]
R205 _49_:A0 net18:10  R=28.8893
** [instance R206 of RESISTOR, params={'resistance': 36.4696 prefix:None} connections=['A: [connection R206/A =>[signal: hold19:X w=1]]', 'B: [connection R206/B =>[signal: net19:12 w=1]]']]
R206 hold19:X net19:12  R=36.4696
** [instance R207 of RESISTOR, params={'resistance': 30.9384 prefix:None} connections=['A: [connection R207/A =>[signal: _67_:D w=1]]', 'B: [connection R207/B =>[signal: net19:12 w=1]]']]
R207 _67_:D net19:12  R=30.9384
** [instance R208 of RESISTOR, params={'resistance': 25.2107 prefix:None} connections=['A: [connection R208/A =>[signal: input2:X w=1]]', 'B: [connection R208/B =>[signal: net2:10 w=1]]']]
R208 input2:X net2:10  R=25.2107
** [instance R209 of RESISTOR, params={'resistance': 2.25 prefix:None} connections=['A: [connection R209/A =>[signal: net2:10 w=1]]', 'B: [connection R209/B =>[signal: net2:12 w=1]]']]
R209 net2:10 net2:12  R=2.25
** [instance R210 of RESISTOR, params={'resistance': 11.9107 prefix:None} connections=['A: [connection R210/A =>[signal: net2:12 w=1]]', 'B: [connection R210/B =>[signal: net2:16 w=1]]']]
R210 net2:12 net2:16  R=11.9107
** [instance R211 of RESISTOR, params={'resistance': 9.3 prefix:None} connections=['A: [connection R211/A =>[signal: _36_:S1 w=1]]', 'B: [connection R211/B =>[signal: net2:16 w=1]]']]
R211 _36_:S1 net2:16  R=9.3
** [instance R212 of RESISTOR, params={'resistance': 19.3179 prefix:None} connections=['A: [connection R212/A =>[signal: _35_:S1 w=1]]', 'B: [connection R212/B =>[signal: net2:16 w=1]]']]
R212 _35_:S1 net2:16  R=19.3179
** [instance R213 of RESISTOR, params={'resistance': 37.5143 prefix:None} connections=['A: [connection R213/A =>[signal: _33_:S1 w=1]]', 'B: [connection R213/B =>[signal: net2:12 w=1]]']]
R213 _33_:S1 net2:12  R=37.5143
** [instance R214 of RESISTOR, params={'resistance': 13.8 prefix:None} connections=['A: [connection R214/A =>[signal: _31_:S1 w=1]]', 'B: [connection R214/B =>[signal: net2:10 w=1]]']]
R214 _31_:S1 net2:10  R=13.8
** [instance R215 of RESISTOR, params={'resistance': 38.8143 prefix:None} connections=['A: [connection R215/A =>[signal: _43_:A0 w=1]]', 'B: [connection R215/B =>[signal: hold20:X w=1]]']]
R215 _43_:A0 hold20:X  R=38.8143
** [instance R216 of RESISTOR, params={'resistance': 30.8723 prefix:None} connections=['A: [connection R216/A =>[signal: _61_:D w=1]]', 'B: [connection R216/B =>[signal: hold21:X w=1]]']]
R216 _61_:D hold21:X  R=30.8723
** [instance R217 of RESISTOR, params={'resistance': 21.1036 prefix:None} connections=['A: [connection R217/A =>[signal: hold22:X w=1]]', 'B: [connection R217/B =>[signal: net22:12 w=1]]']]
R217 hold22:X net22:12  R=21.1036
** [instance R218 of RESISTOR, params={'resistance': 13.5321 prefix:None} connections=['A: [connection R218/A =>[signal: _41_:A0 w=1]]', 'B: [connection R218/B =>[signal: net22:12 w=1]]']]
R218 _41_:A0 net22:12  R=13.5321
** [instance R219 of RESISTOR, params={'resistance': 9.3 prefix:None} connections=['A: [connection R219/A =>[signal: _58_:A1 w=1]]', 'B: [connection R219/B =>[signal: net22:12 w=1]]']]
R219 _58_:A1 net22:12  R=9.3
** [instance R220 of RESISTOR, params={'resistance': 16.8893 prefix:None} connections=['A: [connection R220/A =>[signal: hold23:X w=1]]', 'B: [connection R220/B =>[signal: net23:10 w=1]]']]
R220 hold23:X net23:10  R=16.8893
** [instance R221 of RESISTOR, params={'resistance': 24.2107 prefix:None} connections=['A: [connection R221/A =>[signal: _44_:A1 w=1]]', 'B: [connection R221/B =>[signal: net23:10 w=1]]']]
R221 _44_:A1 net23:10  R=24.2107
** [instance R222 of RESISTOR, params={'resistance': 18.8536 prefix:None} connections=['A: [connection R222/A =>[signal: _45_:A0 w=1]]', 'B: [connection R222/B =>[signal: net23:10 w=1]]']]
R222 _45_:A0 net23:10  R=18.8536
** [instance R223 of RESISTOR, params={'resistance': 13.2643 prefix:None} connections=['A: [connection R223/A =>[signal: hold24:X w=1]]', 'B: [connection R223/B =>[signal: net24:10 w=1]]']]
R223 hold24:X net24:10  R=13.2643
** [instance R224 of RESISTOR, params={'resistance': 16.55 prefix:None} connections=['A: [connection R224/A =>[signal: _55_:A1 w=1]]', 'B: [connection R224/B =>[signal: net24:10 w=1]]']]
R224 _55_:A1 net24:10  R=16.55
** [instance R225 of RESISTOR, params={'resistance': 23.2821 prefix:None} connections=['A: [connection R225/A =>[signal: _57_:A0 w=1]]', 'B: [connection R225/B =>[signal: net24:10 w=1]]']]
R225 _57_:A0 net24:10  R=23.2821
** [instance R226 of RESISTOR, params={'resistance': 33.3679 prefix:None} connections=['A: [connection R226/A =>[signal: _75_:D w=1]]', 'B: [connection R226/B =>[signal: hold25:X w=1]]']]
R226 _75_:D hold25:X  R=33.3679
** [instance R227 of RESISTOR, params={'resistance': 25.425 prefix:None} connections=['A: [connection R227/A =>[signal: hold26:X w=1]]', 'B: [connection R227/B =>[signal: net26:14 w=1]]']]
R227 hold26:X net26:14  R=25.425
** [instance R228 of RESISTOR, params={'resistance': 14.3536 prefix:None} connections=['A: [connection R228/A =>[signal: _55_:A0 w=1]]', 'B: [connection R228/B =>[signal: net26:14 w=1]]']]
R228 _55_:A0 net26:14  R=14.3536
** [instance R229 of RESISTOR, params={'resistance': 9.3 prefix:None} connections=['A: [connection R229/A =>[signal: _54_:A1 w=1]]', 'B: [connection R229/B =>[signal: net26:14 w=1]]']]
R229 _54_:A1 net26:14  R=9.3
** [instance R230 of RESISTOR, params={'resistance': 49.4571 prefix:None} connections=['A: [connection R230/A =>[signal: _44_:A0 w=1]]', 'B: [connection R230/B =>[signal: hold27:X w=1]]']]
R230 _44_:A0 hold27:X  R=49.4571
** [instance R231 of RESISTOR, params={'resistance': 36.1 prefix:None} connections=['A: [connection R231/A =>[signal: _58_:A0 w=1]]', 'B: [connection R231/B =>[signal: hold28:X w=1]]']]
R231 _58_:A0 hold28:X  R=36.1
** [instance R232 of RESISTOR, params={'resistance': 38.8893 prefix:None} connections=['A: [connection R232/A =>[signal: hold29:X w=1]]', 'B: [connection R232/B =>[signal: net29:14 w=1]]']]
R232 hold29:X net29:14  R=38.8893
** [instance R233 of RESISTOR, params={'resistance': 40.6929 prefix:None} connections=['A: [connection R233/A =>[signal: _48_:A0 w=1]]', 'B: [connection R233/B =>[signal: net29:14 w=1]]']]
R233 _48_:A0 net29:14  R=40.6929
** [instance R234 of RESISTOR, params={'resistance': 9.83571 prefix:None} connections=['A: [connection R234/A =>[signal: _47_:A1 w=1]]', 'B: [connection R234/B =>[signal: net29:14 w=1]]']]
R234 _47_:A1 net29:14  R=9.83571
** [instance R235 of RESISTOR, params={'resistance': 36.9071 prefix:None} connections=['A: [connection R235/A =>[signal: input3:X w=1]]', 'B: [connection R235/B =>[signal: net3:12 w=1]]']]
R235 input3:X net3:12  R=36.9071
** [instance R236 of RESISTOR, params={'resistance': 13.0321 prefix:None} connections=['A: [connection R236/A =>[signal: _29_:A w=1]]', 'B: [connection R236/B =>[signal: net3:12 w=1]]']]
R236 _29_:A net3:12  R=13.0321
** [instance R237 of RESISTOR, params={'resistance': 26.5 prefix:None} connections=['A: [connection R237/A =>[signal: net3:12 w=1]]', 'B: [connection R237/B =>[signal: net3:33 w=1]]']]
R237 net3:12 net3:33  R=26.5
** [instance R238 of RESISTOR, params={'resistance': 13.1571 prefix:None} connections=['A: [connection R238/A =>[signal: _32_:A w=1]]', 'B: [connection R238/B =>[signal: net3:33 w=1]]']]
R238 _32_:A net3:33  R=13.1571
** [instance R239 of RESISTOR, params={'resistance': 9.3 prefix:None} connections=['A: [connection R239/A =>[signal: _37_:S w=1]]', 'B: [connection R239/B =>[signal: net3:33 w=1]]']]
R239 _37_:S net3:33  R=9.3
** [instance R240 of RESISTOR, params={'resistance': 49.7964 prefix:None} connections=['A: [connection R240/A =>[signal: _54_:A0 w=1]]', 'B: [connection R240/B =>[signal: hold30:X w=1]]']]
R240 _54_:A0 hold30:X  R=49.7964
** [instance R241 of RESISTOR, params={'resistance': 38.7786 prefix:None} connections=['A: [connection R241/A =>[signal: _53_:A1 w=1]]', 'B: [connection R241/B =>[signal: hold30:X w=1]]']]
R241 _53_:A1 hold30:X  R=38.7786
** [instance R242 of RESISTOR, params={'resistance': 29.5821 prefix:None} connections=['A: [connection R242/A =>[signal: _47_:A0 w=1]]', 'B: [connection R242/B =>[signal: hold31:X w=1]]']]
R242 _47_:A0 hold31:X  R=29.5821
** [instance R243 of RESISTOR, params={'resistance': 38.225 prefix:None} connections=['A: [connection R243/A =>[signal: _56_:A0 w=1]]', 'B: [connection R243/B =>[signal: hold32:X w=1]]']]
R243 _56_:A0 hold32:X  R=38.225
** [instance R244 of RESISTOR, params={'resistance': 20.0857 prefix:None} connections=['A: [connection R244/A =>[signal: hold33:X w=1]]', 'B: [connection R244/B =>[signal: net33:8 w=1]]']]
R244 hold33:X net33:8  R=20.0857
** [instance R245 of RESISTOR, params={'resistance': 17.8179 prefix:None} connections=['A: [connection R245/A =>[signal: _52_:A0 w=1]]', 'B: [connection R245/B =>[signal: net33:8 w=1]]']]
R245 _52_:A0 net33:8  R=17.8179
** [instance R246 of RESISTOR, params={'resistance': 23.0321 prefix:None} connections=['A: [connection R246/A =>[signal: _51_:A1 w=1]]', 'B: [connection R246/B =>[signal: net33:8 w=1]]']]
R246 _51_:A1 net33:8  R=23.0321
** [instance R247 of RESISTOR, params={'resistance': 35.0464 prefix:None} connections=['A: [connection R247/A =>[signal: _70_:D w=1]]', 'B: [connection R247/B =>[signal: hold34:X w=1]]']]
R247 _70_:D hold34:X  R=35.0464
** [instance R248 of RESISTOR, params={'resistance': 35.2821 prefix:None} connections=['A: [connection R248/A =>[signal: hold35:X w=1]]', 'B: [connection R248/B =>[signal: net35:10 w=1]]']]
R248 hold35:X net35:10  R=35.2821
** [instance R249 of RESISTOR, params={'resistance': 44.4607 prefix:None} connections=['A: [connection R249/A =>[signal: _50_:A1 w=1]]', 'B: [connection R249/B =>[signal: net35:10 w=1]]']]
R249 _50_:A1 net35:10  R=44.4607
** [instance R250 of RESISTOR, params={'resistance': 31.7286 prefix:None} connections=['A: [connection R250/A =>[signal: _51_:A0 w=1]]', 'B: [connection R250/B =>[signal: net35:10 w=1]]']]
R250 _51_:A0 net35:10  R=31.7286
** [instance R251 of RESISTOR, params={'resistance': 44.175 prefix:None} connections=['A: [connection R251/A =>[signal: hold36:X w=1]]', 'B: [connection R251/B =>[signal: net36:14 w=1]]']]
R251 hold36:X net36:14  R=44.175
** [instance R252 of RESISTOR, params={'resistance': 9.3 prefix:None} connections=['A: [connection R252/A =>[signal: _53_:A0 w=1]]', 'B: [connection R252/B =>[signal: net36:14 w=1]]']]
R252 _53_:A0 net36:14  R=9.3
** [instance R253 of RESISTOR, params={'resistance': 49.1929 prefix:None} connections=['A: [connection R253/A =>[signal: hold37:X w=1]]', 'B: [connection R253/B =>[signal: net37:14 w=1]]']]
R253 hold37:X net37:14  R=49.1929
** [instance R254 of RESISTOR, params={'resistance': 16.9429 prefix:None} connections=['A: [connection R254/A =>[signal: _50_:A0 w=1]]', 'B: [connection R254/B =>[signal: net37:14 w=1]]']]
R254 _50_:A0 net37:14  R=16.9429
** [instance R255 of RESISTOR, params={'resistance': 36.4786 prefix:None} connections=['A: [connection R255/A =>[signal: input4:X w=1]]', 'B: [connection R255/B =>[signal: net4:18 w=1]]']]
R255 input4:X net4:18  R=36.4786
** [instance R256 of RESISTOR, params={'resistance': 39.4964 prefix:None} connections=['A: [connection R256/A =>[signal: _34_:B1 w=1]]', 'B: [connection R256/B =>[signal: net4:18 w=1]]']]
R256 _34_:B1 net4:18  R=39.4964
** [instance R257 of RESISTOR, params={'resistance': 9.3 prefix:None} connections=['A: [connection R257/A =>[signal: _30_:A w=1]]', 'B: [connection R257/B =>[signal: net4:18 w=1]]']]
R257 _30_:A net4:18  R=9.3
** [instance R258 of RESISTOR, params={'resistance': 44.9571 prefix:None} connections=['A: [connection R258/A =>[signal: _77_:CLK w=1]]', 'B: [connection R258/B =>[signal: input5:X w=1]]']]
R258 _77_:CLK input5:X  R=44.9571
** [instance R259 of RESISTOR, params={'resistance': 12.7107 prefix:None} connections=['A: [connection R259/A =>[signal: input6:X w=1]]', 'B: [connection R259/B =>[signal: net6:6 w=1]]']]
R259 input6:X net6:6  R=12.7107
** [instance R260 of RESISTOR, params={'resistance': 22.9786 prefix:None} connections=['A: [connection R260/A =>[signal: fanout12:A w=1]]', 'B: [connection R260/B =>[signal: net6:6 w=1]]']]
R260 fanout12:A net6:6  R=22.9786
** [instance R261 of RESISTOR, params={'resistance': 32.8 prefix:None} connections=['A: [connection R261/A =>[signal: fanout13:A w=1]]', 'B: [connection R261/B =>[signal: net6:6 w=1]]']]
R261 fanout13:A net6:6  R=32.8
** [instance R262 of RESISTOR, params={'resistance': 49.2429 prefix:None} connections=['A: [connection R262/A =>[signal: _56_:A1 w=1]]', 'B: [connection R262/B =>[signal: input7:X w=1]]']]
R262 _56_:A1 input7:X  R=49.2429
** [instance R263 of RESISTOR, params={'resistance': 23.5143 prefix:None} connections=['A: [connection R263/A =>[signal: input8:X w=1]]', 'B: [connection R263/B =>[signal: net8:12 w=1]]']]
R263 input8:X net8:12  R=23.5143
** [instance R264 of RESISTOR, params={'resistance': 34.6571 prefix:None} connections=['A: [connection R264/A =>[signal: _39_:A1 w=1]]', 'B: [connection R264/B =>[signal: net8:12 w=1]]']]
R264 _39_:A1 net8:12  R=34.6571
** [instance R265 of RESISTOR, params={'resistance': 10.2464 prefix:None} connections=['A: [connection R265/A =>[signal: _40_:A1 w=1]]', 'B: [connection R265/B =>[signal: net8:12 w=1]]']]
R265 _40_:A1 net8:12  R=10.2464
** [instance R266 of RESISTOR, params={'resistance': 30.4929 prefix:None} connections=['A: [connection R266/A =>[signal: _40_:X w=1]]', 'B: [connection R266/B =>[signal: output9:A w=1]]']]
R266 _40_:X output9:A  R=30.4929
** [instance R267 of RESISTOR, params={'resistance': 9.3 prefix:None} connections=['A: [connection R267/A =>[signal: q_control:4 w=1]]', 'B: [connection R267/B =>[signal: _74_:Q w=1]]']]
R267 q_control:4 _74_:Q  R=9.3
** [instance R268 of RESISTOR, params={'resistance': 26.7643 prefix:None} connections=['A: [connection R268/A =>[signal: q_control:4 w=1]]', 'B: [connection R268/B =>[signal: _39_:S w=1]]']]
R268 q_control:4 _39_:S  R=26.7643
** [instance R269 of RESISTOR, params={'resistance': 8.57143 prefix:None} connections=['A: [connection R269/A =>[signal: q_control:23 w=1]]', 'B: [connection R269/B =>[signal: q_control:4 w=1]]']]
R269 q_control:23 q_control:4  R=8.57143
** [instance R270 of RESISTOR, params={'resistance': 19.6571 prefix:None} connections=['A: [connection R270/A =>[signal: q_control:23 w=1]]', 'B: [connection R270/B =>[signal: _57_:A1 w=1]]']]
R270 q_control:23 _57_:A1  R=19.6571
** [instance R271 of RESISTOR, params={'resistance': 15.9786 prefix:None} connections=['A: [connection R271/A =>[signal: q_control:23 w=1]]', 'B: [connection R271/B =>[signal: hold32:A w=1]]']]
R271 q_control:23 hold32:A  R=15.9786
** replacing input1 with the contents of sky130_fd_sc_hd__clkdlybuf4s25_1
** [instance X0 of sky130_fd_pr__pfet_01v8_hvt, params={'w': '820000u', 'l': '250000u'} connections=['d: [connection X0/d =>[signal: a_355_47# w=1]]', 'g: [connection X0/g =>[signal: a_244_47# w=1]]', 's: [connection X0/s =>[signal: VPWR w=1]]', 'b: [connection X0/b =>[signal: VPB w=1]]']]
X_input1_0 input1_a_355_47# input1_a_244_47# VPWR no_conn_1 sky130_fd_pr__pfet_01v8_hvt w=820000u l=250000u
** [instance X1 of sky130_fd_pr__pfet_01v8_hvt, params={'w': '820000u', 'l': '250000u'} connections=['d: [connection X1/d =>[signal: VPWR w=1]]', 'g: [connection X1/g =>[signal: a_27_47# w=1]]', 's: [connection X1/s =>[signal: a_244_47# w=1]]', 'b: [connection X1/b =>[signal: VPB w=1]]']]
X_input1_1 VPWR input1_a_27_47# input1_a_244_47# no_conn_1 sky130_fd_pr__pfet_01v8_hvt w=820000u l=250000u
** [instance X2 of sky130_fd_pr__pfet_01v8_hvt, params={'w': '1e+06u', 'l': '150000u'} connections=['d: [connection X2/d =>[signal: VPWR w=1]]', 'g: [connection X2/g =>[signal: a_355_47# w=1]]', 's: [connection X2/s =>[signal: X w=1]]', 'b: [connection X2/b =>[signal: VPB w=1]]']]
X_input1_2 VPWR input1_a_355_47# input1:X no_conn_1 sky130_fd_pr__pfet_01v8_hvt w=1e+06u l=150000u
** [instance X3 of sky130_fd_pr__pfet_01v8_hvt, params={'w': '1e+06u', 'l': '150000u'} connections=['d: [connection X3/d =>[signal: a_27_47# w=1]]', 'g: [connection X3/g =>[signal: A w=1]]', 's: [connection X3/s =>[signal: VPWR w=1]]', 'b: [connection X3/b =>[signal: VPB w=1]]']]
X_input1_3 input1_a_27_47# input1:A VPWR no_conn_1 sky130_fd_pr__pfet_01v8_hvt w=1e+06u l=150000u
** [instance X4 of sky130_fd_pr__nfet_01v8, params={'w': '650000u', 'l': '250000u'} connections=['d: [connection X4/d =>[signal: a_355_47# w=1]]', 'g: [connection X4/g =>[signal: a_244_47# w=1]]', 's: [connection X4/s =>[signal: VGND w=1]]', 'b: [connection X4/b =>[signal: VNB w=1]]']]
X_input1_4 input1_a_355_47# input1_a_244_47# VGND no_conn_0 sky130_fd_pr__nfet_01v8 w=650000u l=250000u
** [instance X5 of sky130_fd_pr__nfet_01v8, params={'w': '650000u', 'l': '250000u'} connections=['d: [connection X5/d =>[signal: VGND w=1]]', 'g: [connection X5/g =>[signal: a_27_47# w=1]]', 's: [connection X5/s =>[signal: a_244_47# w=1]]', 'b: [connection X5/b =>[signal: VNB w=1]]']]
X_input1_5 VGND input1_a_27_47# input1_a_244_47# no_conn_0 sky130_fd_pr__nfet_01v8 w=650000u l=250000u
** [instance X6 of sky130_fd_pr__nfet_01v8, params={'w': '420000u', 'l': '150000u'} connections=['d: [connection X6/d =>[signal: VGND w=1]]', 'g: [connection X6/g =>[signal: a_355_47# w=1]]', 's: [connection X6/s =>[signal: X w=1]]', 'b: [connection X6/b =>[signal: VNB w=1]]']]
X_input1_6 VGND input1_a_355_47# input1:X no_conn_0 sky130_fd_pr__nfet_01v8 w=420000u l=150000u
** [instance X7 of sky130_fd_pr__nfet_01v8, params={'w': '420000u', 'l': '150000u'} connections=['d: [connection X7/d =>[signal: a_27_47# w=1]]', 'g: [connection X7/g =>[signal: A w=1]]', 's: [connection X7/s =>[signal: VGND w=1]]', 'b: [connection X7/b =>[signal: VNB w=1]]']]
X_input1_7 input1_a_27_47# input1:A VGND no_conn_0 sky130_fd_pr__nfet_01v8 w=420000u l=150000u

** replacing input2 with the contents of sky130_fd_sc_hd__clkdlybuf4s25_1
** [instance X0 of sky130_fd_pr__pfet_01v8_hvt, params={'w': '820000u', 'l': '250000u'} connections=['d: [connection X0/d =>[signal: a_355_47# w=1]]', 'g: [connection X0/g =>[signal: a_244_47# w=1]]', 's: [connection X0/s =>[signal: VPWR w=1]]', 'b: [connection X0/b =>[signal: VPB w=1]]']]
X_input2_0 input2_a_355_47# input2_a_244_47# VPWR no_conn_3 sky130_fd_pr__pfet_01v8_hvt w=820000u l=250000u
** [instance X1 of sky130_fd_pr__pfet_01v8_hvt, params={'w': '820000u', 'l': '250000u'} connections=['d: [connection X1/d =>[signal: VPWR w=1]]', 'g: [connection X1/g =>[signal: a_27_47# w=1]]', 's: [connection X1/s =>[signal: a_244_47# w=1]]', 'b: [connection X1/b =>[signal: VPB w=1]]']]
X_input2_1 VPWR input2_a_27_47# input2_a_244_47# no_conn_3 sky130_fd_pr__pfet_01v8_hvt w=820000u l=250000u
** [instance X2 of sky130_fd_pr__pfet_01v8_hvt, params={'w': '1e+06u', 'l': '150000u'} connections=['d: [connection X2/d =>[signal: VPWR w=1]]', 'g: [connection X2/g =>[signal: a_355_47# w=1]]', 's: [connection X2/s =>[signal: X w=1]]', 'b: [connection X2/b =>[signal: VPB w=1]]']]
X_input2_2 VPWR input2_a_355_47# input2:X no_conn_3 sky130_fd_pr__pfet_01v8_hvt w=1e+06u l=150000u
** [instance X3 of sky130_fd_pr__pfet_01v8_hvt, params={'w': '1e+06u', 'l': '150000u'} connections=['d: [connection X3/d =>[signal: a_27_47# w=1]]', 'g: [connection X3/g =>[signal: A w=1]]', 's: [connection X3/s =>[signal: VPWR w=1]]', 'b: [connection X3/b =>[signal: VPB w=1]]']]
X_input2_3 input2_a_27_47# input2:A VPWR no_conn_3 sky130_fd_pr__pfet_01v8_hvt w=1e+06u l=150000u
** [instance X4 of sky130_fd_pr__nfet_01v8, params={'w': '650000u', 'l': '250000u'} connections=['d: [connection X4/d =>[signal: a_355_47# w=1]]', 'g: [connection X4/g =>[signal: a_244_47# w=1]]', 's: [connection X4/s =>[signal: VGND w=1]]', 'b: [connection X4/b =>[signal: VNB w=1]]']]
X_input2_4 input2_a_355_47# input2_a_244_47# VGND no_conn_2 sky130_fd_pr__nfet_01v8 w=650000u l=250000u
** [instance X5 of sky130_fd_pr__nfet_01v8, params={'w': '650000u', 'l': '250000u'} connections=['d: [connection X5/d =>[signal: VGND w=1]]', 'g: [connection X5/g =>[signal: a_27_47# w=1]]', 's: [connection X5/s =>[signal: a_244_47# w=1]]', 'b: [connection X5/b =>[signal: VNB w=1]]']]
X_input2_5 VGND input2_a_27_47# input2_a_244_47# no_conn_2 sky130_fd_pr__nfet_01v8 w=650000u l=250000u
** [instance X6 of sky130_fd_pr__nfet_01v8, params={'w': '420000u', 'l': '150000u'} connections=['d: [connection X6/d =>[signal: VGND w=1]]', 'g: [connection X6/g =>[signal: a_355_47# w=1]]', 's: [connection X6/s =>[signal: X w=1]]', 'b: [connection X6/b =>[signal: VNB w=1]]']]
X_input2_6 VGND input2_a_355_47# input2:X no_conn_2 sky130_fd_pr__nfet_01v8 w=420000u l=150000u
** [instance X7 of sky130_fd_pr__nfet_01v8, params={'w': '420000u', 'l': '150000u'} connections=['d: [connection X7/d =>[signal: a_27_47# w=1]]', 'g: [connection X7/g =>[signal: A w=1]]', 's: [connection X7/s =>[signal: VGND w=1]]', 'b: [connection X7/b =>[signal: VNB w=1]]']]
X_input2_7 input2_a_27_47# input2:A VGND no_conn_2 sky130_fd_pr__nfet_01v8 w=420000u l=150000u

** replacing input6 with the contents of sky130_fd_sc_hd__clkdlybuf4s25_1
** [instance X0 of sky130_fd_pr__pfet_01v8_hvt, params={'w': '820000u', 'l': '250000u'} connections=['d: [connection X0/d =>[signal: a_355_47# w=1]]', 'g: [connection X0/g =>[signal: a_244_47# w=1]]', 's: [connection X0/s =>[signal: VPWR w=1]]', 'b: [connection X0/b =>[signal: VPB w=1]]']]
X_input6_0 input6_a_355_47# input6_a_244_47# VPWR no_conn_5 sky130_fd_pr__pfet_01v8_hvt w=820000u l=250000u
** [instance X1 of sky130_fd_pr__pfet_01v8_hvt, params={'w': '820000u', 'l': '250000u'} connections=['d: [connection X1/d =>[signal: VPWR w=1]]', 'g: [connection X1/g =>[signal: a_27_47# w=1]]', 's: [connection X1/s =>[signal: a_244_47# w=1]]', 'b: [connection X1/b =>[signal: VPB w=1]]']]
X_input6_1 VPWR input6_a_27_47# input6_a_244_47# no_conn_5 sky130_fd_pr__pfet_01v8_hvt w=820000u l=250000u
** [instance X2 of sky130_fd_pr__pfet_01v8_hvt, params={'w': '1e+06u', 'l': '150000u'} connections=['d: [connection X2/d =>[signal: VPWR w=1]]', 'g: [connection X2/g =>[signal: a_355_47# w=1]]', 's: [connection X2/s =>[signal: X w=1]]', 'b: [connection X2/b =>[signal: VPB w=1]]']]
X_input6_2 VPWR input6_a_355_47# input6:X no_conn_5 sky130_fd_pr__pfet_01v8_hvt w=1e+06u l=150000u
** [instance X3 of sky130_fd_pr__pfet_01v8_hvt, params={'w': '1e+06u', 'l': '150000u'} connections=['d: [connection X3/d =>[signal: a_27_47# w=1]]', 'g: [connection X3/g =>[signal: A w=1]]', 's: [connection X3/s =>[signal: VPWR w=1]]', 'b: [connection X3/b =>[signal: VPB w=1]]']]
X_input6_3 input6_a_27_47# input6:A VPWR no_conn_5 sky130_fd_pr__pfet_01v8_hvt w=1e+06u l=150000u
** [instance X4 of sky130_fd_pr__nfet_01v8, params={'w': '650000u', 'l': '250000u'} connections=['d: [connection X4/d =>[signal: a_355_47# w=1]]', 'g: [connection X4/g =>[signal: a_244_47# w=1]]', 's: [connection X4/s =>[signal: VGND w=1]]', 'b: [connection X4/b =>[signal: VNB w=1]]']]
X_input6_4 input6_a_355_47# input6_a_244_47# VGND no_conn_4 sky130_fd_pr__nfet_01v8 w=650000u l=250000u
** [instance X5 of sky130_fd_pr__nfet_01v8, params={'w': '650000u', 'l': '250000u'} connections=['d: [connection X5/d =>[signal: VGND w=1]]', 'g: [connection X5/g =>[signal: a_27_47# w=1]]', 's: [connection X5/s =>[signal: a_244_47# w=1]]', 'b: [connection X5/b =>[signal: VNB w=1]]']]
X_input6_5 VGND input6_a_27_47# input6_a_244_47# no_conn_4 sky130_fd_pr__nfet_01v8 w=650000u l=250000u
** [instance X6 of sky130_fd_pr__nfet_01v8, params={'w': '420000u', 'l': '150000u'} connections=['d: [connection X6/d =>[signal: VGND w=1]]', 'g: [connection X6/g =>[signal: a_355_47# w=1]]', 's: [connection X6/s =>[signal: X w=1]]', 'b: [connection X6/b =>[signal: VNB w=1]]']]
X_input6_6 VGND input6_a_355_47# input6:X no_conn_4 sky130_fd_pr__nfet_01v8 w=420000u l=150000u
** [instance X7 of sky130_fd_pr__nfet_01v8, params={'w': '420000u', 'l': '150000u'} connections=['d: [connection X7/d =>[signal: a_27_47# w=1]]', 'g: [connection X7/g =>[signal: A w=1]]', 's: [connection X7/s =>[signal: VGND w=1]]', 'b: [connection X7/b =>[signal: VNB w=1]]']]
X_input6_7 input6_a_27_47# input6:A VGND no_conn_4 sky130_fd_pr__nfet_01v8 w=420000u l=150000u

** replacing _67_ with the contents of sky130_fd_sc_hd__dfxtp_2
** [instance X0 of sky130_fd_pr__pfet_01v8_hvt, params={'w': '420000u', 'l': '150000u'} connections=['d: [connection X0/d =>[signal: a_891_413# w=1]]', 'g: [connection X0/g =>[signal: a_193_47# w=1]]', 's: [connection X0/s =>[signal: a_975_413# w=1]]', 'b: [connection X0/b =>[signal: VPB w=1]]']]
X__67__0 _67__a_891_413# _67__a_193_47# _67__a_975_413# no_conn_7 sky130_fd_pr__pfet_01v8_hvt w=420000u l=150000u
** [instance X1 of sky130_fd_pr__nfet_01v8, params={'w': '650000u', 'l': '150000u'} connections=['d: [connection X1/d =>[signal: a_1059_315# w=1]]', 'g: [connection X1/g =>[signal: a_891_413# w=1]]', 's: [connection X1/s =>[signal: VGND w=1]]', 'b: [connection X1/b =>[signal: VNB w=1]]']]
X__67__1 _67__a_1059_315# _67__a_891_413# VGND no_conn_6 sky130_fd_pr__nfet_01v8 w=650000u l=150000u
** [instance X2 of sky130_fd_pr__pfet_01v8_hvt, params={'w': '420000u', 'l': '150000u'} connections=['d: [connection X2/d =>[signal: a_466_413# w=1]]', 'g: [connection X2/g =>[signal: a_27_47# w=1]]', 's: [connection X2/s =>[signal: a_561_413# w=1]]', 'b: [connection X2/b =>[signal: VPB w=1]]']]
X__67__2 _67__a_466_413# _67__a_27_47# _67__a_561_413# no_conn_7 sky130_fd_pr__pfet_01v8_hvt w=420000u l=150000u
** [instance X3 of sky130_fd_pr__pfet_01v8_hvt, params={'w': '420000u', 'l': '150000u'} connections=['d: [connection X3/d =>[signal: a_634_159# w=1]]', 'g: [connection X3/g =>[signal: a_27_47# w=1]]', 's: [connection X3/s =>[signal: a_891_413# w=1]]', 'b: [connection X3/b =>[signal: VPB w=1]]']]
X__67__3 _67__a_634_159# _67__a_27_47# _67__a_891_413# no_conn_7 sky130_fd_pr__pfet_01v8_hvt w=420000u l=150000u
** [instance X4 of sky130_fd_pr__pfet_01v8_hvt, params={'w': '420000u', 'l': '150000u'} connections=['d: [connection X4/d =>[signal: a_381_47# w=1]]', 'g: [connection X4/g =>[signal: a_193_47# w=1]]', 's: [connection X4/s =>[signal: a_466_413# w=1]]', 'b: [connection X4/b =>[signal: VPB w=1]]']]
X__67__4 _67__a_381_47# _67__a_193_47# _67__a_466_413# no_conn_7 sky130_fd_pr__pfet_01v8_hvt w=420000u l=150000u
** [instance X5 of sky130_fd_pr__pfet_01v8_hvt, params={'w': '420000u', 'l': '150000u'} connections=['d: [connection X5/d =>[signal: VPWR w=1]]', 'g: [connection X5/g =>[signal: D w=1]]', 's: [connection X5/s =>[signal: a_381_47# w=1]]', 'b: [connection X5/b =>[signal: VPB w=1]]']]
X__67__5 VPWR _67_:D _67__a_381_47# no_conn_7 sky130_fd_pr__pfet_01v8_hvt w=420000u l=150000u
** [instance X6 of sky130_fd_pr__pfet_01v8_hvt, params={'w': '750000u', 'l': '150000u'} connections=['d: [connection X6/d =>[signal: VPWR w=1]]', 'g: [connection X6/g =>[signal: a_466_413# w=1]]', 's: [connection X6/s =>[signal: a_634_159# w=1]]', 'b: [connection X6/b =>[signal: VPB w=1]]']]
X__67__6 VPWR _67__a_466_413# _67__a_634_159# no_conn_7 sky130_fd_pr__pfet_01v8_hvt w=750000u l=150000u
** [instance X7 of sky130_fd_pr__nfet_01v8, params={'w': '640000u', 'l': '150000u'} connections=['d: [connection X7/d =>[signal: VGND w=1]]', 'g: [connection X7/g =>[signal: a_466_413# w=1]]', 's: [connection X7/s =>[signal: a_634_159# w=1]]', 'b: [connection X7/b =>[signal: VNB w=1]]']]
X__67__7 VGND _67__a_466_413# _67__a_634_159# no_conn_6 sky130_fd_pr__nfet_01v8 w=640000u l=150000u
** [instance X8 of sky130_fd_pr__nfet_01v8, params={'w': '420000u', 'l': '150000u'} connections=['d: [connection X8/d =>[signal: a_1017_47# w=1]]', 'g: [connection X8/g =>[signal: a_1059_315# w=1]]', 's: [connection X8/s =>[signal: VGND w=1]]', 'b: [connection X8/b =>[signal: VNB w=1]]']]
X__67__8 _67__a_1017_47# _67__a_1059_315# VGND no_conn_6 sky130_fd_pr__nfet_01v8 w=420000u l=150000u
** [instance X9 of sky130_fd_pr__pfet_01v8_hvt, params={'w': '1e+06u', 'l': '150000u'} connections=['d: [connection X9/d =>[signal: a_1059_315# w=1]]', 'g: [connection X9/g =>[signal: a_891_413# w=1]]', 's: [connection X9/s =>[signal: VPWR w=1]]', 'b: [connection X9/b =>[signal: VPB w=1]]']]
X__67__9 _67__a_1059_315# _67__a_891_413# VPWR no_conn_7 sky130_fd_pr__pfet_01v8_hvt w=1e+06u l=150000u
** [instance X10 of sky130_fd_pr__pfet_01v8_hvt, params={'w': '1e+06u', 'l': '150000u'} connections=['d: [connection X10/d =>[signal: Q w=1]]', 'g: [connection X10/g =>[signal: a_1059_315# w=1]]', 's: [connection X10/s =>[signal: VPWR w=1]]', 'b: [connection X10/b =>[signal: VPB w=1]]']]
X__67__10 _67_:Q _67__a_1059_315# VPWR no_conn_7 sky130_fd_pr__pfet_01v8_hvt w=1e+06u l=150000u
** [instance X11 of sky130_fd_pr__pfet_01v8_hvt, params={'w': '420000u', 'l': '150000u'} connections=['d: [connection X11/d =>[signal: a_561_413# w=1]]', 'g: [connection X11/g =>[signal: a_634_159# w=1]]', 's: [connection X11/s =>[signal: VPWR w=1]]', 'b: [connection X11/b =>[signal: VPB w=1]]']]
X__67__11 _67__a_561_413# _67__a_634_159# VPWR no_conn_7 sky130_fd_pr__pfet_01v8_hvt w=420000u l=150000u
** [instance X12 of sky130_fd_pr__pfet_01v8_hvt, params={'w': '1e+06u', 'l': '150000u'} connections=['d: [connection X12/d =>[signal: VPWR w=1]]', 'g: [connection X12/g =>[signal: a_1059_315# w=1]]', 's: [connection X12/s =>[signal: Q w=1]]', 'b: [connection X12/b =>[signal: VPB w=1]]']]
X__67__12 VPWR _67__a_1059_315# _67_:Q no_conn_7 sky130_fd_pr__pfet_01v8_hvt w=1e+06u l=150000u
** [instance X13 of sky130_fd_pr__nfet_01v8, params={'w': '360000u', 'l': '150000u'} connections=['d: [connection X13/d =>[signal: a_891_413# w=1]]', 'g: [connection X13/g =>[signal: a_27_47# w=1]]', 's: [connection X13/s =>[signal: a_1017_47# w=1]]', 'b: [connection X13/b =>[signal: VNB w=1]]']]
X__67__13 _67__a_891_413# _67__a_27_47# _67__a_1017_47# no_conn_6 sky130_fd_pr__nfet_01v8 w=360000u l=150000u
** [instance X14 of sky130_fd_pr__nfet_01v8, params={'w': '360000u', 'l': '150000u'} connections=['d: [connection X14/d =>[signal: a_634_159# w=1]]', 'g: [connection X14/g =>[signal: a_193_47# w=1]]', 's: [connection X14/s =>[signal: a_891_413# w=1]]', 'b: [connection X14/b =>[signal: VNB w=1]]']]
X__67__14 _67__a_634_159# _67__a_193_47# _67__a_891_413# no_conn_6 sky130_fd_pr__nfet_01v8 w=360000u l=150000u
** [instance X15 of sky130_fd_pr__nfet_01v8, params={'w': '420000u', 'l': '150000u'} connections=['d: [connection X15/d =>[signal: a_592_47# w=1]]', 'g: [connection X15/g =>[signal: a_634_159# w=1]]', 's: [connection X15/s =>[signal: VGND w=1]]', 'b: [connection X15/b =>[signal: VNB w=1]]']]
X__67__15 _67__a_592_47# _67__a_634_159# VGND no_conn_6 sky130_fd_pr__nfet_01v8 w=420000u l=150000u
** [instance X16 of sky130_fd_pr__nfet_01v8, params={'w': '360000u', 'l': '150000u'} connections=['d: [connection X16/d =>[signal: a_466_413# w=1]]', 'g: [connection X16/g =>[signal: a_193_47# w=1]]', 's: [connection X16/s =>[signal: a_592_47# w=1]]', 'b: [connection X16/b =>[signal: VNB w=1]]']]
X__67__16 _67__a_466_413# _67__a_193_47# _67__a_592_47# no_conn_6 sky130_fd_pr__nfet_01v8 w=360000u l=150000u
** [instance X17 of sky130_fd_pr__nfet_01v8, params={'w': '420000u', 'l': '150000u'} connections=['d: [connection X17/d =>[signal: VGND w=1]]', 'g: [connection X17/g =>[signal: a_27_47# w=1]]', 's: [connection X17/s =>[signal: a_193_47# w=1]]', 'b: [connection X17/b =>[signal: VNB w=1]]']]
X__67__17 VGND _67__a_27_47# _67__a_193_47# no_conn_6 sky130_fd_pr__nfet_01v8 w=420000u l=150000u
** [instance X18 of sky130_fd_pr__nfet_01v8, params={'w': '360000u', 'l': '150000u'} connections=['d: [connection X18/d =>[signal: a_381_47# w=1]]', 'g: [connection X18/g =>[signal: a_27_47# w=1]]', 's: [connection X18/s =>[signal: a_466_413# w=1]]', 'b: [connection X18/b =>[signal: VNB w=1]]']]
X__67__18 _67__a_381_47# _67__a_27_47# _67__a_466_413# no_conn_6 sky130_fd_pr__nfet_01v8 w=360000u l=150000u
** [instance X19 of sky130_fd_pr__nfet_01v8, params={'w': '420000u', 'l': '150000u'} connections=['d: [connection X19/d =>[signal: a_27_47# w=1]]', 'g: [connection X19/g =>[signal: CLK w=1]]', 's: [connection X19/s =>[signal: VGND w=1]]', 'b: [connection X19/b =>[signal: VNB w=1]]']]
X__67__19 _67__a_27_47# _67_:CLK VGND no_conn_6 sky130_fd_pr__nfet_01v8 w=420000u l=150000u
** [instance X20 of sky130_fd_pr__pfet_01v8_hvt, params={'w': '640000u', 'l': '150000u'} connections=['d: [connection X20/d =>[signal: a_27_47# w=1]]', 'g: [connection X20/g =>[signal: CLK w=1]]', 's: [connection X20/s =>[signal: VPWR w=1]]', 'b: [connection X20/b =>[signal: VPB w=1]]']]
X__67__20 _67__a_27_47# _67_:CLK VPWR no_conn_7 sky130_fd_pr__pfet_01v8_hvt w=640000u l=150000u
** [instance X21 of sky130_fd_pr__nfet_01v8, params={'w': '650000u', 'l': '150000u'} connections=['d: [connection X21/d =>[signal: Q w=1]]', 'g: [connection X21/g =>[signal: a_1059_315# w=1]]', 's: [connection X21/s =>[signal: VGND w=1]]', 'b: [connection X21/b =>[signal: VNB w=1]]']]
X__67__21 _67_:Q _67__a_1059_315# VGND no_conn_6 sky130_fd_pr__nfet_01v8 w=650000u l=150000u
** [instance X22 of sky130_fd_pr__pfet_01v8_hvt, params={'w': '640000u', 'l': '150000u'} connections=['d: [connection X22/d =>[signal: VPWR w=1]]', 'g: [connection X22/g =>[signal: a_27_47# w=1]]', 's: [connection X22/s =>[signal: a_193_47# w=1]]', 'b: [connection X22/b =>[signal: VPB w=1]]']]
X__67__22 VPWR _67__a_27_47# _67__a_193_47# no_conn_7 sky130_fd_pr__pfet_01v8_hvt w=640000u l=150000u
** [instance X23 of sky130_fd_pr__nfet_01v8, params={'w': '420000u', 'l': '150000u'} connections=['d: [connection X23/d =>[signal: VGND w=1]]', 'g: [connection X23/g =>[signal: D w=1]]', 's: [connection X23/s =>[signal: a_381_47# w=1]]', 'b: [connection X23/b =>[signal: VNB w=1]]']]
X__67__23 VGND _67_:D _67__a_381_47# no_conn_6 sky130_fd_pr__nfet_01v8 w=420000u l=150000u
** [instance X24 of sky130_fd_pr__pfet_01v8_hvt, params={'w': '420000u', 'l': '150000u'} connections=['d: [connection X24/d =>[signal: a_975_413# w=1]]', 'g: [connection X24/g =>[signal: a_1059_315# w=1]]', 's: [connection X24/s =>[signal: VPWR w=1]]', 'b: [connection X24/b =>[signal: VPB w=1]]']]
X__67__24 _67__a_975_413# _67__a_1059_315# VPWR no_conn_7 sky130_fd_pr__pfet_01v8_hvt w=420000u l=150000u
** [instance X25 of sky130_fd_pr__nfet_01v8, params={'w': '650000u', 'l': '150000u'} connections=['d: [connection X25/d =>[signal: VGND w=1]]', 'g: [connection X25/g =>[signal: a_1059_315# w=1]]', 's: [connection X25/s =>[signal: Q w=1]]', 'b: [connection X25/b =>[signal: VNB w=1]]']]
X__67__25 VGND _67__a_1059_315# _67_:Q no_conn_6 sky130_fd_pr__nfet_01v8 w=650000u l=150000u

** replacing input3 with the contents of sky130_fd_sc_hd__clkdlybuf4s25_1
** [instance X0 of sky130_fd_pr__pfet_01v8_hvt, params={'w': '820000u', 'l': '250000u'} connections=['d: [connection X0/d =>[signal: a_355_47# w=1]]', 'g: [connection X0/g =>[signal: a_244_47# w=1]]', 's: [connection X0/s =>[signal: VPWR w=1]]', 'b: [connection X0/b =>[signal: VPB w=1]]']]
X_input3_0 input3_a_355_47# input3_a_244_47# VPWR no_conn_9 sky130_fd_pr__pfet_01v8_hvt w=820000u l=250000u
** [instance X1 of sky130_fd_pr__pfet_01v8_hvt, params={'w': '820000u', 'l': '250000u'} connections=['d: [connection X1/d =>[signal: VPWR w=1]]', 'g: [connection X1/g =>[signal: a_27_47# w=1]]', 's: [connection X1/s =>[signal: a_244_47# w=1]]', 'b: [connection X1/b =>[signal: VPB w=1]]']]
X_input3_1 VPWR input3_a_27_47# input3_a_244_47# no_conn_9 sky130_fd_pr__pfet_01v8_hvt w=820000u l=250000u
** [instance X2 of sky130_fd_pr__pfet_01v8_hvt, params={'w': '1e+06u', 'l': '150000u'} connections=['d: [connection X2/d =>[signal: VPWR w=1]]', 'g: [connection X2/g =>[signal: a_355_47# w=1]]', 's: [connection X2/s =>[signal: X w=1]]', 'b: [connection X2/b =>[signal: VPB w=1]]']]
X_input3_2 VPWR input3_a_355_47# input3:X no_conn_9 sky130_fd_pr__pfet_01v8_hvt w=1e+06u l=150000u
** [instance X3 of sky130_fd_pr__pfet_01v8_hvt, params={'w': '1e+06u', 'l': '150000u'} connections=['d: [connection X3/d =>[signal: a_27_47# w=1]]', 'g: [connection X3/g =>[signal: A w=1]]', 's: [connection X3/s =>[signal: VPWR w=1]]', 'b: [connection X3/b =>[signal: VPB w=1]]']]
X_input3_3 input3_a_27_47# input3:A VPWR no_conn_9 sky130_fd_pr__pfet_01v8_hvt w=1e+06u l=150000u
** [instance X4 of sky130_fd_pr__nfet_01v8, params={'w': '650000u', 'l': '250000u'} connections=['d: [connection X4/d =>[signal: a_355_47# w=1]]', 'g: [connection X4/g =>[signal: a_244_47# w=1]]', 's: [connection X4/s =>[signal: VGND w=1]]', 'b: [connection X4/b =>[signal: VNB w=1]]']]
X_input3_4 input3_a_355_47# input3_a_244_47# VGND no_conn_8 sky130_fd_pr__nfet_01v8 w=650000u l=250000u
** [instance X5 of sky130_fd_pr__nfet_01v8, params={'w': '650000u', 'l': '250000u'} connections=['d: [connection X5/d =>[signal: VGND w=1]]', 'g: [connection X5/g =>[signal: a_27_47# w=1]]', 's: [connection X5/s =>[signal: a_244_47# w=1]]', 'b: [connection X5/b =>[signal: VNB w=1]]']]
X_input3_5 VGND input3_a_27_47# input3_a_244_47# no_conn_8 sky130_fd_pr__nfet_01v8 w=650000u l=250000u
** [instance X6 of sky130_fd_pr__nfet_01v8, params={'w': '420000u', 'l': '150000u'} connections=['d: [connection X6/d =>[signal: VGND w=1]]', 'g: [connection X6/g =>[signal: a_355_47# w=1]]', 's: [connection X6/s =>[signal: X w=1]]', 'b: [connection X6/b =>[signal: VNB w=1]]']]
X_input3_6 VGND input3_a_355_47# input3:X no_conn_8 sky130_fd_pr__nfet_01v8 w=420000u l=150000u
** [instance X7 of sky130_fd_pr__nfet_01v8, params={'w': '420000u', 'l': '150000u'} connections=['d: [connection X7/d =>[signal: a_27_47# w=1]]', 'g: [connection X7/g =>[signal: A w=1]]', 's: [connection X7/s =>[signal: VGND w=1]]', 'b: [connection X7/b =>[signal: VNB w=1]]']]
X_input3_7 input3_a_27_47# input3:A VGND no_conn_8 sky130_fd_pr__nfet_01v8 w=420000u l=150000u

** replacing _50_ with the contents of sky130_fd_sc_hd__mux2_1
** [instance X0 of sky130_fd_pr__pfet_01v8_hvt, params={'w': '420000u', 'l': '150000u'} connections=['d: [connection X0/d =>[signal: VPWR w=1]]', 'g: [connection X0/g =>[signal: S w=1]]', 's: [connection X0/s =>[signal: a_218_374# w=1]]', 'b: [connection X0/b =>[signal: VPB w=1]]']]
X__50__0 VPWR _50_:S _50__a_218_374# no_conn_11 sky130_fd_pr__pfet_01v8_hvt w=420000u l=150000u
** [instance X1 of sky130_fd_pr__nfet_01v8, params={'w': '420000u', 'l': '150000u'} connections=['d: [connection X1/d =>[signal: a_76_199# w=1]]', 'g: [connection X1/g =>[signal: A0 w=1]]', 's: [connection X1/s =>[signal: a_439_47# w=1]]', 'b: [connection X1/b =>[signal: VNB w=1]]']]
X__50__1 _50__a_76_199# _50_:A0 _50__a_439_47# no_conn_10 sky130_fd_pr__nfet_01v8 w=420000u l=150000u
** [instance X2 of sky130_fd_pr__pfet_01v8_hvt, params={'w': '420000u', 'l': '150000u'} connections=['d: [connection X2/d =>[signal: a_535_374# w=1]]', 'g: [connection X2/g =>[signal: a_505_21# w=1]]', 's: [connection X2/s =>[signal: VPWR w=1]]', 'b: [connection X2/b =>[signal: VPB w=1]]']]
X__50__2 _50__a_535_374# _50__a_505_21# VPWR no_conn_11 sky130_fd_pr__pfet_01v8_hvt w=420000u l=150000u
** [instance X3 of sky130_fd_pr__pfet_01v8_hvt, params={'w': '420000u', 'l': '150000u'} connections=['d: [connection X3/d =>[signal: VPWR w=1]]', 'g: [connection X3/g =>[signal: S w=1]]', 's: [connection X3/s =>[signal: a_505_21# w=1]]', 'b: [connection X3/b =>[signal: VPB w=1]]']]
X__50__3 VPWR _50_:S _50__a_505_21# no_conn_11 sky130_fd_pr__pfet_01v8_hvt w=420000u l=150000u
** [instance X4 of sky130_fd_pr__pfet_01v8_hvt, params={'w': '420000u', 'l': '150000u'} connections=['d: [connection X4/d =>[signal: a_76_199# w=1]]', 'g: [connection X4/g =>[signal: A1 w=1]]', 's: [connection X4/s =>[signal: a_535_374# w=1]]', 'b: [connection X4/b =>[signal: VPB w=1]]']]
X__50__4 _50__a_76_199# _50_:A1 _50__a_535_374# no_conn_11 sky130_fd_pr__pfet_01v8_hvt w=420000u l=150000u
** [instance X5 of sky130_fd_pr__nfet_01v8, params={'w': '420000u', 'l': '150000u'} connections=['d: [connection X5/d =>[signal: a_218_47# w=1]]', 'g: [connection X5/g =>[signal: A1 w=1]]', 's: [connection X5/s =>[signal: a_76_199# w=1]]', 'b: [connection X5/b =>[signal: VNB w=1]]']]
X__50__5 _50__a_218_47# _50_:A1 _50__a_76_199# no_conn_10 sky130_fd_pr__nfet_01v8 w=420000u l=150000u
** [instance X6 of sky130_fd_pr__pfet_01v8_hvt, params={'w': '420000u', 'l': '150000u'} connections=['d: [connection X6/d =>[signal: a_218_374# w=1]]', 'g: [connection X6/g =>[signal: A0 w=1]]', 's: [connection X6/s =>[signal: a_76_199# w=1]]', 'b: [connection X6/b =>[signal: VPB w=1]]']]
X__50__6 _50__a_218_374# _50_:A0 _50__a_76_199# no_conn_11 sky130_fd_pr__pfet_01v8_hvt w=420000u l=150000u
** [instance X7 of sky130_fd_pr__nfet_01v8, params={'w': '650000u', 'l': '150000u'} connections=['d: [connection X7/d =>[signal: X w=1]]', 'g: [connection X7/g =>[signal: a_76_199# w=1]]', 's: [connection X7/s =>[signal: VGND w=1]]', 'b: [connection X7/b =>[signal: VNB w=1]]']]
X__50__7 _50_:X _50__a_76_199# VGND no_conn_10 sky130_fd_pr__nfet_01v8 w=650000u l=150000u
** [instance X8 of sky130_fd_pr__pfet_01v8_hvt, params={'w': '1e+06u', 'l': '150000u'} connections=['d: [connection X8/d =>[signal: X w=1]]', 'g: [connection X8/g =>[signal: a_76_199# w=1]]', 's: [connection X8/s =>[signal: VPWR w=1]]', 'b: [connection X8/b =>[signal: VPB w=1]]']]
X__50__8 _50_:X _50__a_76_199# VPWR no_conn_11 sky130_fd_pr__pfet_01v8_hvt w=1e+06u l=150000u
** [instance X9 of sky130_fd_pr__nfet_01v8, params={'w': '420000u', 'l': '150000u'} connections=['d: [connection X9/d =>[signal: VGND w=1]]', 'g: [connection X9/g =>[signal: S w=1]]', 's: [connection X9/s =>[signal: a_218_47# w=1]]', 'b: [connection X9/b =>[signal: VNB w=1]]']]
X__50__9 VGND _50_:S _50__a_218_47# no_conn_10 sky130_fd_pr__nfet_01v8 w=420000u l=150000u
** [instance X10 of sky130_fd_pr__nfet_01v8, params={'w': '420000u', 'l': '150000u'} connections=['d: [connection X10/d =>[signal: VGND w=1]]', 'g: [connection X10/g =>[signal: S w=1]]', 's: [connection X10/s =>[signal: a_505_21# w=1]]', 'b: [connection X10/b =>[signal: VNB w=1]]']]
X__50__10 VGND _50_:S _50__a_505_21# no_conn_10 sky130_fd_pr__nfet_01v8 w=420000u l=150000u
** [instance X11 of sky130_fd_pr__nfet_01v8, params={'w': '420000u', 'l': '150000u'} connections=['d: [connection X11/d =>[signal: a_439_47# w=1]]', 'g: [connection X11/g =>[signal: a_505_21# w=1]]', 's: [connection X11/s =>[signal: VGND w=1]]', 'b: [connection X11/b =>[signal: VNB w=1]]']]
X__50__11 _50__a_439_47# _50__a_505_21# VGND no_conn_10 sky130_fd_pr__nfet_01v8 w=420000u l=150000u

** replacing _56_ with the contents of sky130_fd_sc_hd__mux2_1
** [instance X0 of sky130_fd_pr__pfet_01v8_hvt, params={'w': '420000u', 'l': '150000u'} connections=['d: [connection X0/d =>[signal: VPWR w=1]]', 'g: [connection X0/g =>[signal: S w=1]]', 's: [connection X0/s =>[signal: a_218_374# w=1]]', 'b: [connection X0/b =>[signal: VPB w=1]]']]
X__56__0 VPWR _56_:S _56__a_218_374# no_conn_13 sky130_fd_pr__pfet_01v8_hvt w=420000u l=150000u
** [instance X1 of sky130_fd_pr__nfet_01v8, params={'w': '420000u', 'l': '150000u'} connections=['d: [connection X1/d =>[signal: a_76_199# w=1]]', 'g: [connection X1/g =>[signal: A0 w=1]]', 's: [connection X1/s =>[signal: a_439_47# w=1]]', 'b: [connection X1/b =>[signal: VNB w=1]]']]
X__56__1 _56__a_76_199# _56_:A0 _56__a_439_47# no_conn_12 sky130_fd_pr__nfet_01v8 w=420000u l=150000u
** [instance X2 of sky130_fd_pr__pfet_01v8_hvt, params={'w': '420000u', 'l': '150000u'} connections=['d: [connection X2/d =>[signal: a_535_374# w=1]]', 'g: [connection X2/g =>[signal: a_505_21# w=1]]', 's: [connection X2/s =>[signal: VPWR w=1]]', 'b: [connection X2/b =>[signal: VPB w=1]]']]
X__56__2 _56__a_535_374# _56__a_505_21# VPWR no_conn_13 sky130_fd_pr__pfet_01v8_hvt w=420000u l=150000u
** [instance X3 of sky130_fd_pr__pfet_01v8_hvt, params={'w': '420000u', 'l': '150000u'} connections=['d: [connection X3/d =>[signal: VPWR w=1]]', 'g: [connection X3/g =>[signal: S w=1]]', 's: [connection X3/s =>[signal: a_505_21# w=1]]', 'b: [connection X3/b =>[signal: VPB w=1]]']]
X__56__3 VPWR _56_:S _56__a_505_21# no_conn_13 sky130_fd_pr__pfet_01v8_hvt w=420000u l=150000u
** [instance X4 of sky130_fd_pr__pfet_01v8_hvt, params={'w': '420000u', 'l': '150000u'} connections=['d: [connection X4/d =>[signal: a_76_199# w=1]]', 'g: [connection X4/g =>[signal: A1 w=1]]', 's: [connection X4/s =>[signal: a_535_374# w=1]]', 'b: [connection X4/b =>[signal: VPB w=1]]']]
X__56__4 _56__a_76_199# _56_:A1 _56__a_535_374# no_conn_13 sky130_fd_pr__pfet_01v8_hvt w=420000u l=150000u
** [instance X5 of sky130_fd_pr__nfet_01v8, params={'w': '420000u', 'l': '150000u'} connections=['d: [connection X5/d =>[signal: a_218_47# w=1]]', 'g: [connection X5/g =>[signal: A1 w=1]]', 's: [connection X5/s =>[signal: a_76_199# w=1]]', 'b: [connection X5/b =>[signal: VNB w=1]]']]
X__56__5 _56__a_218_47# _56_:A1 _56__a_76_199# no_conn_12 sky130_fd_pr__nfet_01v8 w=420000u l=150000u
** [instance X6 of sky130_fd_pr__pfet_01v8_hvt, params={'w': '420000u', 'l': '150000u'} connections=['d: [connection X6/d =>[signal: a_218_374# w=1]]', 'g: [connection X6/g =>[signal: A0 w=1]]', 's: [connection X6/s =>[signal: a_76_199# w=1]]', 'b: [connection X6/b =>[signal: VPB w=1]]']]
X__56__6 _56__a_218_374# _56_:A0 _56__a_76_199# no_conn_13 sky130_fd_pr__pfet_01v8_hvt w=420000u l=150000u
** [instance X7 of sky130_fd_pr__nfet_01v8, params={'w': '650000u', 'l': '150000u'} connections=['d: [connection X7/d =>[signal: X w=1]]', 'g: [connection X7/g =>[signal: a_76_199# w=1]]', 's: [connection X7/s =>[signal: VGND w=1]]', 'b: [connection X7/b =>[signal: VNB w=1]]']]
X__56__7 _56_:X _56__a_76_199# VGND no_conn_12 sky130_fd_pr__nfet_01v8 w=650000u l=150000u
** [instance X8 of sky130_fd_pr__pfet_01v8_hvt, params={'w': '1e+06u', 'l': '150000u'} connections=['d: [connection X8/d =>[signal: X w=1]]', 'g: [connection X8/g =>[signal: a_76_199# w=1]]', 's: [connection X8/s =>[signal: VPWR w=1]]', 'b: [connection X8/b =>[signal: VPB w=1]]']]
X__56__8 _56_:X _56__a_76_199# VPWR no_conn_13 sky130_fd_pr__pfet_01v8_hvt w=1e+06u l=150000u
** [instance X9 of sky130_fd_pr__nfet_01v8, params={'w': '420000u', 'l': '150000u'} connections=['d: [connection X9/d =>[signal: VGND w=1]]', 'g: [connection X9/g =>[signal: S w=1]]', 's: [connection X9/s =>[signal: a_218_47# w=1]]', 'b: [connection X9/b =>[signal: VNB w=1]]']]
X__56__9 VGND _56_:S _56__a_218_47# no_conn_12 sky130_fd_pr__nfet_01v8 w=420000u l=150000u
** [instance X10 of sky130_fd_pr__nfet_01v8, params={'w': '420000u', 'l': '150000u'} connections=['d: [connection X10/d =>[signal: VGND w=1]]', 'g: [connection X10/g =>[signal: S w=1]]', 's: [connection X10/s =>[signal: a_505_21# w=1]]', 'b: [connection X10/b =>[signal: VNB w=1]]']]
X__56__10 VGND _56_:S _56__a_505_21# no_conn_12 sky130_fd_pr__nfet_01v8 w=420000u l=150000u
** [instance X11 of sky130_fd_pr__nfet_01v8, params={'w': '420000u', 'l': '150000u'} connections=['d: [connection X11/d =>[signal: a_439_47# w=1]]', 'g: [connection X11/g =>[signal: a_505_21# w=1]]', 's: [connection X11/s =>[signal: VGND w=1]]', 'b: [connection X11/b =>[signal: VNB w=1]]']]
X__56__11 _56__a_439_47# _56__a_505_21# VGND no_conn_12 sky130_fd_pr__nfet_01v8 w=420000u l=150000u

** replacing _57_ with the contents of sky130_fd_sc_hd__mux2_1
** [instance X0 of sky130_fd_pr__pfet_01v8_hvt, params={'w': '420000u', 'l': '150000u'} connections=['d: [connection X0/d =>[signal: VPWR w=1]]', 'g: [connection X0/g =>[signal: S w=1]]', 's: [connection X0/s =>[signal: a_218_374# w=1]]', 'b: [connection X0/b =>[signal: VPB w=1]]']]
X__57__0 VPWR _57_:S _57__a_218_374# no_conn_15 sky130_fd_pr__pfet_01v8_hvt w=420000u l=150000u
** [instance X1 of sky130_fd_pr__nfet_01v8, params={'w': '420000u', 'l': '150000u'} connections=['d: [connection X1/d =>[signal: a_76_199# w=1]]', 'g: [connection X1/g =>[signal: A0 w=1]]', 's: [connection X1/s =>[signal: a_439_47# w=1]]', 'b: [connection X1/b =>[signal: VNB w=1]]']]
X__57__1 _57__a_76_199# _57_:A0 _57__a_439_47# no_conn_14 sky130_fd_pr__nfet_01v8 w=420000u l=150000u
** [instance X2 of sky130_fd_pr__pfet_01v8_hvt, params={'w': '420000u', 'l': '150000u'} connections=['d: [connection X2/d =>[signal: a_535_374# w=1]]', 'g: [connection X2/g =>[signal: a_505_21# w=1]]', 's: [connection X2/s =>[signal: VPWR w=1]]', 'b: [connection X2/b =>[signal: VPB w=1]]']]
X__57__2 _57__a_535_374# _57__a_505_21# VPWR no_conn_15 sky130_fd_pr__pfet_01v8_hvt w=420000u l=150000u
** [instance X3 of sky130_fd_pr__pfet_01v8_hvt, params={'w': '420000u', 'l': '150000u'} connections=['d: [connection X3/d =>[signal: VPWR w=1]]', 'g: [connection X3/g =>[signal: S w=1]]', 's: [connection X3/s =>[signal: a_505_21# w=1]]', 'b: [connection X3/b =>[signal: VPB w=1]]']]
X__57__3 VPWR _57_:S _57__a_505_21# no_conn_15 sky130_fd_pr__pfet_01v8_hvt w=420000u l=150000u
** [instance X4 of sky130_fd_pr__pfet_01v8_hvt, params={'w': '420000u', 'l': '150000u'} connections=['d: [connection X4/d =>[signal: a_76_199# w=1]]', 'g: [connection X4/g =>[signal: A1 w=1]]', 's: [connection X4/s =>[signal: a_535_374# w=1]]', 'b: [connection X4/b =>[signal: VPB w=1]]']]
X__57__4 _57__a_76_199# _57_:A1 _57__a_535_374# no_conn_15 sky130_fd_pr__pfet_01v8_hvt w=420000u l=150000u
** [instance X5 of sky130_fd_pr__nfet_01v8, params={'w': '420000u', 'l': '150000u'} connections=['d: [connection X5/d =>[signal: a_218_47# w=1]]', 'g: [connection X5/g =>[signal: A1 w=1]]', 's: [connection X5/s =>[signal: a_76_199# w=1]]', 'b: [connection X5/b =>[signal: VNB w=1]]']]
X__57__5 _57__a_218_47# _57_:A1 _57__a_76_199# no_conn_14 sky130_fd_pr__nfet_01v8 w=420000u l=150000u
** [instance X6 of sky130_fd_pr__pfet_01v8_hvt, params={'w': '420000u', 'l': '150000u'} connections=['d: [connection X6/d =>[signal: a_218_374# w=1]]', 'g: [connection X6/g =>[signal: A0 w=1]]', 's: [connection X6/s =>[signal: a_76_199# w=1]]', 'b: [connection X6/b =>[signal: VPB w=1]]']]
X__57__6 _57__a_218_374# _57_:A0 _57__a_76_199# no_conn_15 sky130_fd_pr__pfet_01v8_hvt w=420000u l=150000u
** [instance X7 of sky130_fd_pr__nfet_01v8, params={'w': '650000u', 'l': '150000u'} connections=['d: [connection X7/d =>[signal: X w=1]]', 'g: [connection X7/g =>[signal: a_76_199# w=1]]', 's: [connection X7/s =>[signal: VGND w=1]]', 'b: [connection X7/b =>[signal: VNB w=1]]']]
X__57__7 _57_:X _57__a_76_199# VGND no_conn_14 sky130_fd_pr__nfet_01v8 w=650000u l=150000u
** [instance X8 of sky130_fd_pr__pfet_01v8_hvt, params={'w': '1e+06u', 'l': '150000u'} connections=['d: [connection X8/d =>[signal: X w=1]]', 'g: [connection X8/g =>[signal: a_76_199# w=1]]', 's: [connection X8/s =>[signal: VPWR w=1]]', 'b: [connection X8/b =>[signal: VPB w=1]]']]
X__57__8 _57_:X _57__a_76_199# VPWR no_conn_15 sky130_fd_pr__pfet_01v8_hvt w=1e+06u l=150000u
** [instance X9 of sky130_fd_pr__nfet_01v8, params={'w': '420000u', 'l': '150000u'} connections=['d: [connection X9/d =>[signal: VGND w=1]]', 'g: [connection X9/g =>[signal: S w=1]]', 's: [connection X9/s =>[signal: a_218_47# w=1]]', 'b: [connection X9/b =>[signal: VNB w=1]]']]
X__57__9 VGND _57_:S _57__a_218_47# no_conn_14 sky130_fd_pr__nfet_01v8 w=420000u l=150000u
** [instance X10 of sky130_fd_pr__nfet_01v8, params={'w': '420000u', 'l': '150000u'} connections=['d: [connection X10/d =>[signal: VGND w=1]]', 'g: [connection X10/g =>[signal: S w=1]]', 's: [connection X10/s =>[signal: a_505_21# w=1]]', 'b: [connection X10/b =>[signal: VNB w=1]]']]
X__57__10 VGND _57_:S _57__a_505_21# no_conn_14 sky130_fd_pr__nfet_01v8 w=420000u l=150000u
** [instance X11 of sky130_fd_pr__nfet_01v8, params={'w': '420000u', 'l': '150000u'} connections=['d: [connection X11/d =>[signal: a_439_47# w=1]]', 'g: [connection X11/g =>[signal: a_505_21# w=1]]', 's: [connection X11/s =>[signal: VGND w=1]]', 'b: [connection X11/b =>[signal: VNB w=1]]']]
X__57__11 _57__a_439_47# _57__a_505_21# VGND no_conn_14 sky130_fd_pr__nfet_01v8 w=420000u l=150000u

** replacing _74_ with the contents of sky130_fd_sc_hd__dfxtp_2
** [instance X0 of sky130_fd_pr__pfet_01v8_hvt, params={'w': '420000u', 'l': '150000u'} connections=['d: [connection X0/d =>[signal: a_891_413# w=1]]', 'g: [connection X0/g =>[signal: a_193_47# w=1]]', 's: [connection X0/s =>[signal: a_975_413# w=1]]', 'b: [connection X0/b =>[signal: VPB w=1]]']]
X__74__0 _74__a_891_413# _74__a_193_47# _74__a_975_413# no_conn_17 sky130_fd_pr__pfet_01v8_hvt w=420000u l=150000u
** [instance X1 of sky130_fd_pr__nfet_01v8, params={'w': '650000u', 'l': '150000u'} connections=['d: [connection X1/d =>[signal: a_1059_315# w=1]]', 'g: [connection X1/g =>[signal: a_891_413# w=1]]', 's: [connection X1/s =>[signal: VGND w=1]]', 'b: [connection X1/b =>[signal: VNB w=1]]']]
X__74__1 _74__a_1059_315# _74__a_891_413# VGND no_conn_16 sky130_fd_pr__nfet_01v8 w=650000u l=150000u
** [instance X2 of sky130_fd_pr__pfet_01v8_hvt, params={'w': '420000u', 'l': '150000u'} connections=['d: [connection X2/d =>[signal: a_466_413# w=1]]', 'g: [connection X2/g =>[signal: a_27_47# w=1]]', 's: [connection X2/s =>[signal: a_561_413# w=1]]', 'b: [connection X2/b =>[signal: VPB w=1]]']]
X__74__2 _74__a_466_413# _74__a_27_47# _74__a_561_413# no_conn_17 sky130_fd_pr__pfet_01v8_hvt w=420000u l=150000u
** [instance X3 of sky130_fd_pr__pfet_01v8_hvt, params={'w': '420000u', 'l': '150000u'} connections=['d: [connection X3/d =>[signal: a_634_159# w=1]]', 'g: [connection X3/g =>[signal: a_27_47# w=1]]', 's: [connection X3/s =>[signal: a_891_413# w=1]]', 'b: [connection X3/b =>[signal: VPB w=1]]']]
X__74__3 _74__a_634_159# _74__a_27_47# _74__a_891_413# no_conn_17 sky130_fd_pr__pfet_01v8_hvt w=420000u l=150000u
** [instance X4 of sky130_fd_pr__pfet_01v8_hvt, params={'w': '420000u', 'l': '150000u'} connections=['d: [connection X4/d =>[signal: a_381_47# w=1]]', 'g: [connection X4/g =>[signal: a_193_47# w=1]]', 's: [connection X4/s =>[signal: a_466_413# w=1]]', 'b: [connection X4/b =>[signal: VPB w=1]]']]
X__74__4 _74__a_381_47# _74__a_193_47# _74__a_466_413# no_conn_17 sky130_fd_pr__pfet_01v8_hvt w=420000u l=150000u
** [instance X5 of sky130_fd_pr__pfet_01v8_hvt, params={'w': '420000u', 'l': '150000u'} connections=['d: [connection X5/d =>[signal: VPWR w=1]]', 'g: [connection X5/g =>[signal: D w=1]]', 's: [connection X5/s =>[signal: a_381_47# w=1]]', 'b: [connection X5/b =>[signal: VPB w=1]]']]
X__74__5 VPWR _74_:D _74__a_381_47# no_conn_17 sky130_fd_pr__pfet_01v8_hvt w=420000u l=150000u
** [instance X6 of sky130_fd_pr__pfet_01v8_hvt, params={'w': '750000u', 'l': '150000u'} connections=['d: [connection X6/d =>[signal: VPWR w=1]]', 'g: [connection X6/g =>[signal: a_466_413# w=1]]', 's: [connection X6/s =>[signal: a_634_159# w=1]]', 'b: [connection X6/b =>[signal: VPB w=1]]']]
X__74__6 VPWR _74__a_466_413# _74__a_634_159# no_conn_17 sky130_fd_pr__pfet_01v8_hvt w=750000u l=150000u
** [instance X7 of sky130_fd_pr__nfet_01v8, params={'w': '640000u', 'l': '150000u'} connections=['d: [connection X7/d =>[signal: VGND w=1]]', 'g: [connection X7/g =>[signal: a_466_413# w=1]]', 's: [connection X7/s =>[signal: a_634_159# w=1]]', 'b: [connection X7/b =>[signal: VNB w=1]]']]
X__74__7 VGND _74__a_466_413# _74__a_634_159# no_conn_16 sky130_fd_pr__nfet_01v8 w=640000u l=150000u
** [instance X8 of sky130_fd_pr__nfet_01v8, params={'w': '420000u', 'l': '150000u'} connections=['d: [connection X8/d =>[signal: a_1017_47# w=1]]', 'g: [connection X8/g =>[signal: a_1059_315# w=1]]', 's: [connection X8/s =>[signal: VGND w=1]]', 'b: [connection X8/b =>[signal: VNB w=1]]']]
X__74__8 _74__a_1017_47# _74__a_1059_315# VGND no_conn_16 sky130_fd_pr__nfet_01v8 w=420000u l=150000u
** [instance X9 of sky130_fd_pr__pfet_01v8_hvt, params={'w': '1e+06u', 'l': '150000u'} connections=['d: [connection X9/d =>[signal: a_1059_315# w=1]]', 'g: [connection X9/g =>[signal: a_891_413# w=1]]', 's: [connection X9/s =>[signal: VPWR w=1]]', 'b: [connection X9/b =>[signal: VPB w=1]]']]
X__74__9 _74__a_1059_315# _74__a_891_413# VPWR no_conn_17 sky130_fd_pr__pfet_01v8_hvt w=1e+06u l=150000u
** [instance X10 of sky130_fd_pr__pfet_01v8_hvt, params={'w': '1e+06u', 'l': '150000u'} connections=['d: [connection X10/d =>[signal: Q w=1]]', 'g: [connection X10/g =>[signal: a_1059_315# w=1]]', 's: [connection X10/s =>[signal: VPWR w=1]]', 'b: [connection X10/b =>[signal: VPB w=1]]']]
X__74__10 _74_:Q _74__a_1059_315# VPWR no_conn_17 sky130_fd_pr__pfet_01v8_hvt w=1e+06u l=150000u
** [instance X11 of sky130_fd_pr__pfet_01v8_hvt, params={'w': '420000u', 'l': '150000u'} connections=['d: [connection X11/d =>[signal: a_561_413# w=1]]', 'g: [connection X11/g =>[signal: a_634_159# w=1]]', 's: [connection X11/s =>[signal: VPWR w=1]]', 'b: [connection X11/b =>[signal: VPB w=1]]']]
X__74__11 _74__a_561_413# _74__a_634_159# VPWR no_conn_17 sky130_fd_pr__pfet_01v8_hvt w=420000u l=150000u
** [instance X12 of sky130_fd_pr__pfet_01v8_hvt, params={'w': '1e+06u', 'l': '150000u'} connections=['d: [connection X12/d =>[signal: VPWR w=1]]', 'g: [connection X12/g =>[signal: a_1059_315# w=1]]', 's: [connection X12/s =>[signal: Q w=1]]', 'b: [connection X12/b =>[signal: VPB w=1]]']]
X__74__12 VPWR _74__a_1059_315# _74_:Q no_conn_17 sky130_fd_pr__pfet_01v8_hvt w=1e+06u l=150000u
** [instance X13 of sky130_fd_pr__nfet_01v8, params={'w': '360000u', 'l': '150000u'} connections=['d: [connection X13/d =>[signal: a_891_413# w=1]]', 'g: [connection X13/g =>[signal: a_27_47# w=1]]', 's: [connection X13/s =>[signal: a_1017_47# w=1]]', 'b: [connection X13/b =>[signal: VNB w=1]]']]
X__74__13 _74__a_891_413# _74__a_27_47# _74__a_1017_47# no_conn_16 sky130_fd_pr__nfet_01v8 w=360000u l=150000u
** [instance X14 of sky130_fd_pr__nfet_01v8, params={'w': '360000u', 'l': '150000u'} connections=['d: [connection X14/d =>[signal: a_634_159# w=1]]', 'g: [connection X14/g =>[signal: a_193_47# w=1]]', 's: [connection X14/s =>[signal: a_891_413# w=1]]', 'b: [connection X14/b =>[signal: VNB w=1]]']]
X__74__14 _74__a_634_159# _74__a_193_47# _74__a_891_413# no_conn_16 sky130_fd_pr__nfet_01v8 w=360000u l=150000u
** [instance X15 of sky130_fd_pr__nfet_01v8, params={'w': '420000u', 'l': '150000u'} connections=['d: [connection X15/d =>[signal: a_592_47# w=1]]', 'g: [connection X15/g =>[signal: a_634_159# w=1]]', 's: [connection X15/s =>[signal: VGND w=1]]', 'b: [connection X15/b =>[signal: VNB w=1]]']]
X__74__15 _74__a_592_47# _74__a_634_159# VGND no_conn_16 sky130_fd_pr__nfet_01v8 w=420000u l=150000u
** [instance X16 of sky130_fd_pr__nfet_01v8, params={'w': '360000u', 'l': '150000u'} connections=['d: [connection X16/d =>[signal: a_466_413# w=1]]', 'g: [connection X16/g =>[signal: a_193_47# w=1]]', 's: [connection X16/s =>[signal: a_592_47# w=1]]', 'b: [connection X16/b =>[signal: VNB w=1]]']]
X__74__16 _74__a_466_413# _74__a_193_47# _74__a_592_47# no_conn_16 sky130_fd_pr__nfet_01v8 w=360000u l=150000u
** [instance X17 of sky130_fd_pr__nfet_01v8, params={'w': '420000u', 'l': '150000u'} connections=['d: [connection X17/d =>[signal: VGND w=1]]', 'g: [connection X17/g =>[signal: a_27_47# w=1]]', 's: [connection X17/s =>[signal: a_193_47# w=1]]', 'b: [connection X17/b =>[signal: VNB w=1]]']]
X__74__17 VGND _74__a_27_47# _74__a_193_47# no_conn_16 sky130_fd_pr__nfet_01v8 w=420000u l=150000u
** [instance X18 of sky130_fd_pr__nfet_01v8, params={'w': '360000u', 'l': '150000u'} connections=['d: [connection X18/d =>[signal: a_381_47# w=1]]', 'g: [connection X18/g =>[signal: a_27_47# w=1]]', 's: [connection X18/s =>[signal: a_466_413# w=1]]', 'b: [connection X18/b =>[signal: VNB w=1]]']]
X__74__18 _74__a_381_47# _74__a_27_47# _74__a_466_413# no_conn_16 sky130_fd_pr__nfet_01v8 w=360000u l=150000u
** [instance X19 of sky130_fd_pr__nfet_01v8, params={'w': '420000u', 'l': '150000u'} connections=['d: [connection X19/d =>[signal: a_27_47# w=1]]', 'g: [connection X19/g =>[signal: CLK w=1]]', 's: [connection X19/s =>[signal: VGND w=1]]', 'b: [connection X19/b =>[signal: VNB w=1]]']]
X__74__19 _74__a_27_47# _74_:CLK VGND no_conn_16 sky130_fd_pr__nfet_01v8 w=420000u l=150000u
** [instance X20 of sky130_fd_pr__pfet_01v8_hvt, params={'w': '640000u', 'l': '150000u'} connections=['d: [connection X20/d =>[signal: a_27_47# w=1]]', 'g: [connection X20/g =>[signal: CLK w=1]]', 's: [connection X20/s =>[signal: VPWR w=1]]', 'b: [connection X20/b =>[signal: VPB w=1]]']]
X__74__20 _74__a_27_47# _74_:CLK VPWR no_conn_17 sky130_fd_pr__pfet_01v8_hvt w=640000u l=150000u
** [instance X21 of sky130_fd_pr__nfet_01v8, params={'w': '650000u', 'l': '150000u'} connections=['d: [connection X21/d =>[signal: Q w=1]]', 'g: [connection X21/g =>[signal: a_1059_315# w=1]]', 's: [connection X21/s =>[signal: VGND w=1]]', 'b: [connection X21/b =>[signal: VNB w=1]]']]
X__74__21 _74_:Q _74__a_1059_315# VGND no_conn_16 sky130_fd_pr__nfet_01v8 w=650000u l=150000u
** [instance X22 of sky130_fd_pr__pfet_01v8_hvt, params={'w': '640000u', 'l': '150000u'} connections=['d: [connection X22/d =>[signal: VPWR w=1]]', 'g: [connection X22/g =>[signal: a_27_47# w=1]]', 's: [connection X22/s =>[signal: a_193_47# w=1]]', 'b: [connection X22/b =>[signal: VPB w=1]]']]
X__74__22 VPWR _74__a_27_47# _74__a_193_47# no_conn_17 sky130_fd_pr__pfet_01v8_hvt w=640000u l=150000u
** [instance X23 of sky130_fd_pr__nfet_01v8, params={'w': '420000u', 'l': '150000u'} connections=['d: [connection X23/d =>[signal: VGND w=1]]', 'g: [connection X23/g =>[signal: D w=1]]', 's: [connection X23/s =>[signal: a_381_47# w=1]]', 'b: [connection X23/b =>[signal: VNB w=1]]']]
X__74__23 VGND _74_:D _74__a_381_47# no_conn_16 sky130_fd_pr__nfet_01v8 w=420000u l=150000u
** [instance X24 of sky130_fd_pr__pfet_01v8_hvt, params={'w': '420000u', 'l': '150000u'} connections=['d: [connection X24/d =>[signal: a_975_413# w=1]]', 'g: [connection X24/g =>[signal: a_1059_315# w=1]]', 's: [connection X24/s =>[signal: VPWR w=1]]', 'b: [connection X24/b =>[signal: VPB w=1]]']]
X__74__24 _74__a_975_413# _74__a_1059_315# VPWR no_conn_17 sky130_fd_pr__pfet_01v8_hvt w=420000u l=150000u
** [instance X25 of sky130_fd_pr__nfet_01v8, params={'w': '650000u', 'l': '150000u'} connections=['d: [connection X25/d =>[signal: VGND w=1]]', 'g: [connection X25/g =>[signal: a_1059_315# w=1]]', 's: [connection X25/s =>[signal: Q w=1]]', 'b: [connection X25/b =>[signal: VNB w=1]]']]
X__74__25 VGND _74__a_1059_315# _74_:Q no_conn_16 sky130_fd_pr__nfet_01v8 w=650000u l=150000u

** replacing _77_ with the contents of sky130_fd_sc_hd__dfxtp_2
** [instance X0 of sky130_fd_pr__pfet_01v8_hvt, params={'w': '420000u', 'l': '150000u'} connections=['d: [connection X0/d =>[signal: a_891_413# w=1]]', 'g: [connection X0/g =>[signal: a_193_47# w=1]]', 's: [connection X0/s =>[signal: a_975_413# w=1]]', 'b: [connection X0/b =>[signal: VPB w=1]]']]
X__77__0 _77__a_891_413# _77__a_193_47# _77__a_975_413# no_conn_19 sky130_fd_pr__pfet_01v8_hvt w=420000u l=150000u
** [instance X1 of sky130_fd_pr__nfet_01v8, params={'w': '650000u', 'l': '150000u'} connections=['d: [connection X1/d =>[signal: a_1059_315# w=1]]', 'g: [connection X1/g =>[signal: a_891_413# w=1]]', 's: [connection X1/s =>[signal: VGND w=1]]', 'b: [connection X1/b =>[signal: VNB w=1]]']]
X__77__1 _77__a_1059_315# _77__a_891_413# VGND no_conn_18 sky130_fd_pr__nfet_01v8 w=650000u l=150000u
** [instance X2 of sky130_fd_pr__pfet_01v8_hvt, params={'w': '420000u', 'l': '150000u'} connections=['d: [connection X2/d =>[signal: a_466_413# w=1]]', 'g: [connection X2/g =>[signal: a_27_47# w=1]]', 's: [connection X2/s =>[signal: a_561_413# w=1]]', 'b: [connection X2/b =>[signal: VPB w=1]]']]
X__77__2 _77__a_466_413# _77__a_27_47# _77__a_561_413# no_conn_19 sky130_fd_pr__pfet_01v8_hvt w=420000u l=150000u
** [instance X3 of sky130_fd_pr__pfet_01v8_hvt, params={'w': '420000u', 'l': '150000u'} connections=['d: [connection X3/d =>[signal: a_634_159# w=1]]', 'g: [connection X3/g =>[signal: a_27_47# w=1]]', 's: [connection X3/s =>[signal: a_891_413# w=1]]', 'b: [connection X3/b =>[signal: VPB w=1]]']]
X__77__3 _77__a_634_159# _77__a_27_47# _77__a_891_413# no_conn_19 sky130_fd_pr__pfet_01v8_hvt w=420000u l=150000u
** [instance X4 of sky130_fd_pr__pfet_01v8_hvt, params={'w': '420000u', 'l': '150000u'} connections=['d: [connection X4/d =>[signal: a_381_47# w=1]]', 'g: [connection X4/g =>[signal: a_193_47# w=1]]', 's: [connection X4/s =>[signal: a_466_413# w=1]]', 'b: [connection X4/b =>[signal: VPB w=1]]']]
X__77__4 _77__a_381_47# _77__a_193_47# _77__a_466_413# no_conn_19 sky130_fd_pr__pfet_01v8_hvt w=420000u l=150000u
** [instance X5 of sky130_fd_pr__pfet_01v8_hvt, params={'w': '420000u', 'l': '150000u'} connections=['d: [connection X5/d =>[signal: VPWR w=1]]', 'g: [connection X5/g =>[signal: D w=1]]', 's: [connection X5/s =>[signal: a_381_47# w=1]]', 'b: [connection X5/b =>[signal: VPB w=1]]']]
X__77__5 VPWR _77_:D _77__a_381_47# no_conn_19 sky130_fd_pr__pfet_01v8_hvt w=420000u l=150000u
** [instance X6 of sky130_fd_pr__pfet_01v8_hvt, params={'w': '750000u', 'l': '150000u'} connections=['d: [connection X6/d =>[signal: VPWR w=1]]', 'g: [connection X6/g =>[signal: a_466_413# w=1]]', 's: [connection X6/s =>[signal: a_634_159# w=1]]', 'b: [connection X6/b =>[signal: VPB w=1]]']]
X__77__6 VPWR _77__a_466_413# _77__a_634_159# no_conn_19 sky130_fd_pr__pfet_01v8_hvt w=750000u l=150000u
** [instance X7 of sky130_fd_pr__nfet_01v8, params={'w': '640000u', 'l': '150000u'} connections=['d: [connection X7/d =>[signal: VGND w=1]]', 'g: [connection X7/g =>[signal: a_466_413# w=1]]', 's: [connection X7/s =>[signal: a_634_159# w=1]]', 'b: [connection X7/b =>[signal: VNB w=1]]']]
X__77__7 VGND _77__a_466_413# _77__a_634_159# no_conn_18 sky130_fd_pr__nfet_01v8 w=640000u l=150000u
** [instance X8 of sky130_fd_pr__nfet_01v8, params={'w': '420000u', 'l': '150000u'} connections=['d: [connection X8/d =>[signal: a_1017_47# w=1]]', 'g: [connection X8/g =>[signal: a_1059_315# w=1]]', 's: [connection X8/s =>[signal: VGND w=1]]', 'b: [connection X8/b =>[signal: VNB w=1]]']]
X__77__8 _77__a_1017_47# _77__a_1059_315# VGND no_conn_18 sky130_fd_pr__nfet_01v8 w=420000u l=150000u
** [instance X9 of sky130_fd_pr__pfet_01v8_hvt, params={'w': '1e+06u', 'l': '150000u'} connections=['d: [connection X9/d =>[signal: a_1059_315# w=1]]', 'g: [connection X9/g =>[signal: a_891_413# w=1]]', 's: [connection X9/s =>[signal: VPWR w=1]]', 'b: [connection X9/b =>[signal: VPB w=1]]']]
X__77__9 _77__a_1059_315# _77__a_891_413# VPWR no_conn_19 sky130_fd_pr__pfet_01v8_hvt w=1e+06u l=150000u
** [instance X10 of sky130_fd_pr__pfet_01v8_hvt, params={'w': '1e+06u', 'l': '150000u'} connections=['d: [connection X10/d =>[signal: Q w=1]]', 'g: [connection X10/g =>[signal: a_1059_315# w=1]]', 's: [connection X10/s =>[signal: VPWR w=1]]', 'b: [connection X10/b =>[signal: VPB w=1]]']]
X__77__10 _77_:Q _77__a_1059_315# VPWR no_conn_19 sky130_fd_pr__pfet_01v8_hvt w=1e+06u l=150000u
** [instance X11 of sky130_fd_pr__pfet_01v8_hvt, params={'w': '420000u', 'l': '150000u'} connections=['d: [connection X11/d =>[signal: a_561_413# w=1]]', 'g: [connection X11/g =>[signal: a_634_159# w=1]]', 's: [connection X11/s =>[signal: VPWR w=1]]', 'b: [connection X11/b =>[signal: VPB w=1]]']]
X__77__11 _77__a_561_413# _77__a_634_159# VPWR no_conn_19 sky130_fd_pr__pfet_01v8_hvt w=420000u l=150000u
** [instance X12 of sky130_fd_pr__pfet_01v8_hvt, params={'w': '1e+06u', 'l': '150000u'} connections=['d: [connection X12/d =>[signal: VPWR w=1]]', 'g: [connection X12/g =>[signal: a_1059_315# w=1]]', 's: [connection X12/s =>[signal: Q w=1]]', 'b: [connection X12/b =>[signal: VPB w=1]]']]
X__77__12 VPWR _77__a_1059_315# _77_:Q no_conn_19 sky130_fd_pr__pfet_01v8_hvt w=1e+06u l=150000u
** [instance X13 of sky130_fd_pr__nfet_01v8, params={'w': '360000u', 'l': '150000u'} connections=['d: [connection X13/d =>[signal: a_891_413# w=1]]', 'g: [connection X13/g =>[signal: a_27_47# w=1]]', 's: [connection X13/s =>[signal: a_1017_47# w=1]]', 'b: [connection X13/b =>[signal: VNB w=1]]']]
X__77__13 _77__a_891_413# _77__a_27_47# _77__a_1017_47# no_conn_18 sky130_fd_pr__nfet_01v8 w=360000u l=150000u
** [instance X14 of sky130_fd_pr__nfet_01v8, params={'w': '360000u', 'l': '150000u'} connections=['d: [connection X14/d =>[signal: a_634_159# w=1]]', 'g: [connection X14/g =>[signal: a_193_47# w=1]]', 's: [connection X14/s =>[signal: a_891_413# w=1]]', 'b: [connection X14/b =>[signal: VNB w=1]]']]
X__77__14 _77__a_634_159# _77__a_193_47# _77__a_891_413# no_conn_18 sky130_fd_pr__nfet_01v8 w=360000u l=150000u
** [instance X15 of sky130_fd_pr__nfet_01v8, params={'w': '420000u', 'l': '150000u'} connections=['d: [connection X15/d =>[signal: a_592_47# w=1]]', 'g: [connection X15/g =>[signal: a_634_159# w=1]]', 's: [connection X15/s =>[signal: VGND w=1]]', 'b: [connection X15/b =>[signal: VNB w=1]]']]
X__77__15 _77__a_592_47# _77__a_634_159# VGND no_conn_18 sky130_fd_pr__nfet_01v8 w=420000u l=150000u
** [instance X16 of sky130_fd_pr__nfet_01v8, params={'w': '360000u', 'l': '150000u'} connections=['d: [connection X16/d =>[signal: a_466_413# w=1]]', 'g: [connection X16/g =>[signal: a_193_47# w=1]]', 's: [connection X16/s =>[signal: a_592_47# w=1]]', 'b: [connection X16/b =>[signal: VNB w=1]]']]
X__77__16 _77__a_466_413# _77__a_193_47# _77__a_592_47# no_conn_18 sky130_fd_pr__nfet_01v8 w=360000u l=150000u
** [instance X17 of sky130_fd_pr__nfet_01v8, params={'w': '420000u', 'l': '150000u'} connections=['d: [connection X17/d =>[signal: VGND w=1]]', 'g: [connection X17/g =>[signal: a_27_47# w=1]]', 's: [connection X17/s =>[signal: a_193_47# w=1]]', 'b: [connection X17/b =>[signal: VNB w=1]]']]
X__77__17 VGND _77__a_27_47# _77__a_193_47# no_conn_18 sky130_fd_pr__nfet_01v8 w=420000u l=150000u
** [instance X18 of sky130_fd_pr__nfet_01v8, params={'w': '360000u', 'l': '150000u'} connections=['d: [connection X18/d =>[signal: a_381_47# w=1]]', 'g: [connection X18/g =>[signal: a_27_47# w=1]]', 's: [connection X18/s =>[signal: a_466_413# w=1]]', 'b: [connection X18/b =>[signal: VNB w=1]]']]
X__77__18 _77__a_381_47# _77__a_27_47# _77__a_466_413# no_conn_18 sky130_fd_pr__nfet_01v8 w=360000u l=150000u
** [instance X19 of sky130_fd_pr__nfet_01v8, params={'w': '420000u', 'l': '150000u'} connections=['d: [connection X19/d =>[signal: a_27_47# w=1]]', 'g: [connection X19/g =>[signal: CLK w=1]]', 's: [connection X19/s =>[signal: VGND w=1]]', 'b: [connection X19/b =>[signal: VNB w=1]]']]
X__77__19 _77__a_27_47# _77_:CLK VGND no_conn_18 sky130_fd_pr__nfet_01v8 w=420000u l=150000u
** [instance X20 of sky130_fd_pr__pfet_01v8_hvt, params={'w': '640000u', 'l': '150000u'} connections=['d: [connection X20/d =>[signal: a_27_47# w=1]]', 'g: [connection X20/g =>[signal: CLK w=1]]', 's: [connection X20/s =>[signal: VPWR w=1]]', 'b: [connection X20/b =>[signal: VPB w=1]]']]
X__77__20 _77__a_27_47# _77_:CLK VPWR no_conn_19 sky130_fd_pr__pfet_01v8_hvt w=640000u l=150000u
** [instance X21 of sky130_fd_pr__nfet_01v8, params={'w': '650000u', 'l': '150000u'} connections=['d: [connection X21/d =>[signal: Q w=1]]', 'g: [connection X21/g =>[signal: a_1059_315# w=1]]', 's: [connection X21/s =>[signal: VGND w=1]]', 'b: [connection X21/b =>[signal: VNB w=1]]']]
X__77__21 _77_:Q _77__a_1059_315# VGND no_conn_18 sky130_fd_pr__nfet_01v8 w=650000u l=150000u
** [instance X22 of sky130_fd_pr__pfet_01v8_hvt, params={'w': '640000u', 'l': '150000u'} connections=['d: [connection X22/d =>[signal: VPWR w=1]]', 'g: [connection X22/g =>[signal: a_27_47# w=1]]', 's: [connection X22/s =>[signal: a_193_47# w=1]]', 'b: [connection X22/b =>[signal: VPB w=1]]']]
X__77__22 VPWR _77__a_27_47# _77__a_193_47# no_conn_19 sky130_fd_pr__pfet_01v8_hvt w=640000u l=150000u
** [instance X23 of sky130_fd_pr__nfet_01v8, params={'w': '420000u', 'l': '150000u'} connections=['d: [connection X23/d =>[signal: VGND w=1]]', 'g: [connection X23/g =>[signal: D w=1]]', 's: [connection X23/s =>[signal: a_381_47# w=1]]', 'b: [connection X23/b =>[signal: VNB w=1]]']]
X__77__23 VGND _77_:D _77__a_381_47# no_conn_18 sky130_fd_pr__nfet_01v8 w=420000u l=150000u
** [instance X24 of sky130_fd_pr__pfet_01v8_hvt, params={'w': '420000u', 'l': '150000u'} connections=['d: [connection X24/d =>[signal: a_975_413# w=1]]', 'g: [connection X24/g =>[signal: a_1059_315# w=1]]', 's: [connection X24/s =>[signal: VPWR w=1]]', 'b: [connection X24/b =>[signal: VPB w=1]]']]
X__77__24 _77__a_975_413# _77__a_1059_315# VPWR no_conn_19 sky130_fd_pr__pfet_01v8_hvt w=420000u l=150000u
** [instance X25 of sky130_fd_pr__nfet_01v8, params={'w': '650000u', 'l': '150000u'} connections=['d: [connection X25/d =>[signal: VGND w=1]]', 'g: [connection X25/g =>[signal: a_1059_315# w=1]]', 's: [connection X25/s =>[signal: Q w=1]]', 'b: [connection X25/b =>[signal: VNB w=1]]']]
X__77__25 VGND _77__a_1059_315# _77_:Q no_conn_18 sky130_fd_pr__nfet_01v8 w=650000u l=150000u

** replacing hold22 with the contents of sky130_fd_sc_hd__dlygate4sd3_1
** [instance X0 of sky130_fd_pr__nfet_01v8, params={'w': '420000u', 'l': '500000u'} connections=['d: [connection X0/d =>[signal: a_391_47# w=1]]', 'g: [connection X0/g =>[signal: a_285_47# w=1]]', 's: [connection X0/s =>[signal: VGND w=1]]', 'b: [connection X0/b =>[signal: VNB w=1]]']]
X_hold22_0 hold22_a_391_47# hold22_a_285_47# VGND no_conn_20 sky130_fd_pr__nfet_01v8 w=420000u l=500000u
** [instance X1 of sky130_fd_pr__pfet_01v8_hvt, params={'w': '420000u', 'l': '500000u'} connections=['d: [connection X1/d =>[signal: VPWR w=1]]', 'g: [connection X1/g =>[signal: a_49_47# w=1]]', 's: [connection X1/s =>[signal: a_285_47# w=1]]', 'b: [connection X1/b =>[signal: VPB w=1]]']]
X_hold22_1 VPWR hold22_a_49_47# hold22_a_285_47# no_conn_21 sky130_fd_pr__pfet_01v8_hvt w=420000u l=500000u
** [instance X2 of sky130_fd_pr__nfet_01v8, params={'w': '420000u', 'l': '150000u'} connections=['d: [connection X2/d =>[signal: a_49_47# w=1]]', 'g: [connection X2/g =>[signal: A w=1]]', 's: [connection X2/s =>[signal: VGND w=1]]', 'b: [connection X2/b =>[signal: VNB w=1]]']]
X_hold22_2 hold22_a_49_47# hold22:A VGND no_conn_20 sky130_fd_pr__nfet_01v8 w=420000u l=150000u
** [instance X3 of sky130_fd_pr__pfet_01v8_hvt, params={'w': '1e+06u', 'l': '150000u'} connections=['d: [connection X3/d =>[signal: VPWR w=1]]', 'g: [connection X3/g =>[signal: a_391_47# w=1]]', 's: [connection X3/s =>[signal: X w=1]]', 'b: [connection X3/b =>[signal: VPB w=1]]']]
X_hold22_3 VPWR hold22_a_391_47# hold22:X no_conn_21 sky130_fd_pr__pfet_01v8_hvt w=1e+06u l=150000u
** [instance X4 of sky130_fd_pr__nfet_01v8, params={'w': '650000u', 'l': '150000u'} connections=['d: [connection X4/d =>[signal: VGND w=1]]', 'g: [connection X4/g =>[signal: a_391_47# w=1]]', 's: [connection X4/s =>[signal: X w=1]]', 'b: [connection X4/b =>[signal: VNB w=1]]']]
X_hold22_4 VGND hold22_a_391_47# hold22:X no_conn_20 sky130_fd_pr__nfet_01v8 w=650000u l=150000u
** [instance X5 of sky130_fd_pr__nfet_01v8, params={'w': '420000u', 'l': '500000u'} connections=['d: [connection X5/d =>[signal: VGND w=1]]', 'g: [connection X5/g =>[signal: a_49_47# w=1]]', 's: [connection X5/s =>[signal: a_285_47# w=1]]', 'b: [connection X5/b =>[signal: VNB w=1]]']]
X_hold22_5 VGND hold22_a_49_47# hold22_a_285_47# no_conn_20 sky130_fd_pr__nfet_01v8 w=420000u l=500000u
** [instance X6 of sky130_fd_pr__pfet_01v8_hvt, params={'w': '420000u', 'l': '500000u'} connections=['d: [connection X6/d =>[signal: a_391_47# w=1]]', 'g: [connection X6/g =>[signal: a_285_47# w=1]]', 's: [connection X6/s =>[signal: VPWR w=1]]', 'b: [connection X6/b =>[signal: VPB w=1]]']]
X_hold22_6 hold22_a_391_47# hold22_a_285_47# VPWR no_conn_21 sky130_fd_pr__pfet_01v8_hvt w=420000u l=500000u
** [instance X7 of sky130_fd_pr__pfet_01v8_hvt, params={'w': '420000u', 'l': '150000u'} connections=['d: [connection X7/d =>[signal: a_49_47# w=1]]', 'g: [connection X7/g =>[signal: A w=1]]', 's: [connection X7/s =>[signal: VPWR w=1]]', 'b: [connection X7/b =>[signal: VPB w=1]]']]
X_hold22_7 hold22_a_49_47# hold22:A VPWR no_conn_21 sky130_fd_pr__pfet_01v8_hvt w=420000u l=150000u

** replacing input7 with the contents of sky130_fd_sc_hd__clkdlybuf4s25_1
** [instance X0 of sky130_fd_pr__pfet_01v8_hvt, params={'w': '820000u', 'l': '250000u'} connections=['d: [connection X0/d =>[signal: a_355_47# w=1]]', 'g: [connection X0/g =>[signal: a_244_47# w=1]]', 's: [connection X0/s =>[signal: VPWR w=1]]', 'b: [connection X0/b =>[signal: VPB w=1]]']]
X_input7_0 input7_a_355_47# input7_a_244_47# VPWR no_conn_23 sky130_fd_pr__pfet_01v8_hvt w=820000u l=250000u
** [instance X1 of sky130_fd_pr__pfet_01v8_hvt, params={'w': '820000u', 'l': '250000u'} connections=['d: [connection X1/d =>[signal: VPWR w=1]]', 'g: [connection X1/g =>[signal: a_27_47# w=1]]', 's: [connection X1/s =>[signal: a_244_47# w=1]]', 'b: [connection X1/b =>[signal: VPB w=1]]']]
X_input7_1 VPWR input7_a_27_47# input7_a_244_47# no_conn_23 sky130_fd_pr__pfet_01v8_hvt w=820000u l=250000u
** [instance X2 of sky130_fd_pr__pfet_01v8_hvt, params={'w': '1e+06u', 'l': '150000u'} connections=['d: [connection X2/d =>[signal: VPWR w=1]]', 'g: [connection X2/g =>[signal: a_355_47# w=1]]', 's: [connection X2/s =>[signal: X w=1]]', 'b: [connection X2/b =>[signal: VPB w=1]]']]
X_input7_2 VPWR input7_a_355_47# input7:X no_conn_23 sky130_fd_pr__pfet_01v8_hvt w=1e+06u l=150000u
** [instance X3 of sky130_fd_pr__pfet_01v8_hvt, params={'w': '1e+06u', 'l': '150000u'} connections=['d: [connection X3/d =>[signal: a_27_47# w=1]]', 'g: [connection X3/g =>[signal: A w=1]]', 's: [connection X3/s =>[signal: VPWR w=1]]', 'b: [connection X3/b =>[signal: VPB w=1]]']]
X_input7_3 input7_a_27_47# input7:A VPWR no_conn_23 sky130_fd_pr__pfet_01v8_hvt w=1e+06u l=150000u
** [instance X4 of sky130_fd_pr__nfet_01v8, params={'w': '650000u', 'l': '250000u'} connections=['d: [connection X4/d =>[signal: a_355_47# w=1]]', 'g: [connection X4/g =>[signal: a_244_47# w=1]]', 's: [connection X4/s =>[signal: VGND w=1]]', 'b: [connection X4/b =>[signal: VNB w=1]]']]
X_input7_4 input7_a_355_47# input7_a_244_47# VGND no_conn_22 sky130_fd_pr__nfet_01v8 w=650000u l=250000u
** [instance X5 of sky130_fd_pr__nfet_01v8, params={'w': '650000u', 'l': '250000u'} connections=['d: [connection X5/d =>[signal: VGND w=1]]', 'g: [connection X5/g =>[signal: a_27_47# w=1]]', 's: [connection X5/s =>[signal: a_244_47# w=1]]', 'b: [connection X5/b =>[signal: VNB w=1]]']]
X_input7_5 VGND input7_a_27_47# input7_a_244_47# no_conn_22 sky130_fd_pr__nfet_01v8 w=650000u l=250000u
** [instance X6 of sky130_fd_pr__nfet_01v8, params={'w': '420000u', 'l': '150000u'} connections=['d: [connection X6/d =>[signal: VGND w=1]]', 'g: [connection X6/g =>[signal: a_355_47# w=1]]', 's: [connection X6/s =>[signal: X w=1]]', 'b: [connection X6/b =>[signal: VNB w=1]]']]
X_input7_6 VGND input7_a_355_47# input7:X no_conn_22 sky130_fd_pr__nfet_01v8 w=420000u l=150000u
** [instance X7 of sky130_fd_pr__nfet_01v8, params={'w': '420000u', 'l': '150000u'} connections=['d: [connection X7/d =>[signal: a_27_47# w=1]]', 'g: [connection X7/g =>[signal: A w=1]]', 's: [connection X7/s =>[signal: VGND w=1]]', 'b: [connection X7/b =>[signal: VNB w=1]]']]
X_input7_7 input7_a_27_47# input7:A VGND no_conn_22 sky130_fd_pr__nfet_01v8 w=420000u l=150000u

** replacing input4 with the contents of sky130_fd_sc_hd__clkdlybuf4s25_1
** [instance X0 of sky130_fd_pr__pfet_01v8_hvt, params={'w': '820000u', 'l': '250000u'} connections=['d: [connection X0/d =>[signal: a_355_47# w=1]]', 'g: [connection X0/g =>[signal: a_244_47# w=1]]', 's: [connection X0/s =>[signal: VPWR w=1]]', 'b: [connection X0/b =>[signal: VPB w=1]]']]
X_input4_0 input4_a_355_47# input4_a_244_47# VPWR no_conn_25 sky130_fd_pr__pfet_01v8_hvt w=820000u l=250000u
** [instance X1 of sky130_fd_pr__pfet_01v8_hvt, params={'w': '820000u', 'l': '250000u'} connections=['d: [connection X1/d =>[signal: VPWR w=1]]', 'g: [connection X1/g =>[signal: a_27_47# w=1]]', 's: [connection X1/s =>[signal: a_244_47# w=1]]', 'b: [connection X1/b =>[signal: VPB w=1]]']]
X_input4_1 VPWR input4_a_27_47# input4_a_244_47# no_conn_25 sky130_fd_pr__pfet_01v8_hvt w=820000u l=250000u
** [instance X2 of sky130_fd_pr__pfet_01v8_hvt, params={'w': '1e+06u', 'l': '150000u'} connections=['d: [connection X2/d =>[signal: VPWR w=1]]', 'g: [connection X2/g =>[signal: a_355_47# w=1]]', 's: [connection X2/s =>[signal: X w=1]]', 'b: [connection X2/b =>[signal: VPB w=1]]']]
X_input4_2 VPWR input4_a_355_47# input4:X no_conn_25 sky130_fd_pr__pfet_01v8_hvt w=1e+06u l=150000u
** [instance X3 of sky130_fd_pr__pfet_01v8_hvt, params={'w': '1e+06u', 'l': '150000u'} connections=['d: [connection X3/d =>[signal: a_27_47# w=1]]', 'g: [connection X3/g =>[signal: A w=1]]', 's: [connection X3/s =>[signal: VPWR w=1]]', 'b: [connection X3/b =>[signal: VPB w=1]]']]
X_input4_3 input4_a_27_47# input4:A VPWR no_conn_25 sky130_fd_pr__pfet_01v8_hvt w=1e+06u l=150000u
** [instance X4 of sky130_fd_pr__nfet_01v8, params={'w': '650000u', 'l': '250000u'} connections=['d: [connection X4/d =>[signal: a_355_47# w=1]]', 'g: [connection X4/g =>[signal: a_244_47# w=1]]', 's: [connection X4/s =>[signal: VGND w=1]]', 'b: [connection X4/b =>[signal: VNB w=1]]']]
X_input4_4 input4_a_355_47# input4_a_244_47# VGND no_conn_24 sky130_fd_pr__nfet_01v8 w=650000u l=250000u
** [instance X5 of sky130_fd_pr__nfet_01v8, params={'w': '650000u', 'l': '250000u'} connections=['d: [connection X5/d =>[signal: VGND w=1]]', 'g: [connection X5/g =>[signal: a_27_47# w=1]]', 's: [connection X5/s =>[signal: a_244_47# w=1]]', 'b: [connection X5/b =>[signal: VNB w=1]]']]
X_input4_5 VGND input4_a_27_47# input4_a_244_47# no_conn_24 sky130_fd_pr__nfet_01v8 w=650000u l=250000u
** [instance X6 of sky130_fd_pr__nfet_01v8, params={'w': '420000u', 'l': '150000u'} connections=['d: [connection X6/d =>[signal: VGND w=1]]', 'g: [connection X6/g =>[signal: a_355_47# w=1]]', 's: [connection X6/s =>[signal: X w=1]]', 'b: [connection X6/b =>[signal: VNB w=1]]']]
X_input4_6 VGND input4_a_355_47# input4:X no_conn_24 sky130_fd_pr__nfet_01v8 w=420000u l=150000u
** [instance X7 of sky130_fd_pr__nfet_01v8, params={'w': '420000u', 'l': '150000u'} connections=['d: [connection X7/d =>[signal: a_27_47# w=1]]', 'g: [connection X7/g =>[signal: A w=1]]', 's: [connection X7/s =>[signal: VGND w=1]]', 'b: [connection X7/b =>[signal: VNB w=1]]']]
X_input4_7 input4_a_27_47# input4:A VGND no_conn_24 sky130_fd_pr__nfet_01v8 w=420000u l=150000u

** replacing hold28 with the contents of sky130_fd_sc_hd__dlygate4sd3_1
** [instance X0 of sky130_fd_pr__nfet_01v8, params={'w': '420000u', 'l': '500000u'} connections=['d: [connection X0/d =>[signal: a_391_47# w=1]]', 'g: [connection X0/g =>[signal: a_285_47# w=1]]', 's: [connection X0/s =>[signal: VGND w=1]]', 'b: [connection X0/b =>[signal: VNB w=1]]']]
X_hold28_0 hold28_a_391_47# hold28_a_285_47# VGND no_conn_26 sky130_fd_pr__nfet_01v8 w=420000u l=500000u
** [instance X1 of sky130_fd_pr__pfet_01v8_hvt, params={'w': '420000u', 'l': '500000u'} connections=['d: [connection X1/d =>[signal: VPWR w=1]]', 'g: [connection X1/g =>[signal: a_49_47# w=1]]', 's: [connection X1/s =>[signal: a_285_47# w=1]]', 'b: [connection X1/b =>[signal: VPB w=1]]']]
X_hold28_1 VPWR hold28_a_49_47# hold28_a_285_47# no_conn_27 sky130_fd_pr__pfet_01v8_hvt w=420000u l=500000u
** [instance X2 of sky130_fd_pr__nfet_01v8, params={'w': '420000u', 'l': '150000u'} connections=['d: [connection X2/d =>[signal: a_49_47# w=1]]', 'g: [connection X2/g =>[signal: A w=1]]', 's: [connection X2/s =>[signal: VGND w=1]]', 'b: [connection X2/b =>[signal: VNB w=1]]']]
X_hold28_2 hold28_a_49_47# hold28:A VGND no_conn_26 sky130_fd_pr__nfet_01v8 w=420000u l=150000u
** [instance X3 of sky130_fd_pr__pfet_01v8_hvt, params={'w': '1e+06u', 'l': '150000u'} connections=['d: [connection X3/d =>[signal: VPWR w=1]]', 'g: [connection X3/g =>[signal: a_391_47# w=1]]', 's: [connection X3/s =>[signal: X w=1]]', 'b: [connection X3/b =>[signal: VPB w=1]]']]
X_hold28_3 VPWR hold28_a_391_47# hold28:X no_conn_27 sky130_fd_pr__pfet_01v8_hvt w=1e+06u l=150000u
** [instance X4 of sky130_fd_pr__nfet_01v8, params={'w': '650000u', 'l': '150000u'} connections=['d: [connection X4/d =>[signal: VGND w=1]]', 'g: [connection X4/g =>[signal: a_391_47# w=1]]', 's: [connection X4/s =>[signal: X w=1]]', 'b: [connection X4/b =>[signal: VNB w=1]]']]
X_hold28_4 VGND hold28_a_391_47# hold28:X no_conn_26 sky130_fd_pr__nfet_01v8 w=650000u l=150000u
** [instance X5 of sky130_fd_pr__nfet_01v8, params={'w': '420000u', 'l': '500000u'} connections=['d: [connection X5/d =>[signal: VGND w=1]]', 'g: [connection X5/g =>[signal: a_49_47# w=1]]', 's: [connection X5/s =>[signal: a_285_47# w=1]]', 'b: [connection X5/b =>[signal: VNB w=1]]']]
X_hold28_5 VGND hold28_a_49_47# hold28_a_285_47# no_conn_26 sky130_fd_pr__nfet_01v8 w=420000u l=500000u
** [instance X6 of sky130_fd_pr__pfet_01v8_hvt, params={'w': '420000u', 'l': '500000u'} connections=['d: [connection X6/d =>[signal: a_391_47# w=1]]', 'g: [connection X6/g =>[signal: a_285_47# w=1]]', 's: [connection X6/s =>[signal: VPWR w=1]]', 'b: [connection X6/b =>[signal: VPB w=1]]']]
X_hold28_6 hold28_a_391_47# hold28_a_285_47# VPWR no_conn_27 sky130_fd_pr__pfet_01v8_hvt w=420000u l=500000u
** [instance X7 of sky130_fd_pr__pfet_01v8_hvt, params={'w': '420000u', 'l': '150000u'} connections=['d: [connection X7/d =>[signal: a_49_47# w=1]]', 'g: [connection X7/g =>[signal: A w=1]]', 's: [connection X7/s =>[signal: VPWR w=1]]', 'b: [connection X7/b =>[signal: VPB w=1]]']]
X_hold28_7 hold28_a_49_47# hold28:A VPWR no_conn_27 sky130_fd_pr__pfet_01v8_hvt w=420000u l=150000u

** replacing input5 with the contents of sky130_fd_sc_hd__clkdlybuf4s25_1
** [instance X0 of sky130_fd_pr__pfet_01v8_hvt, params={'w': '820000u', 'l': '250000u'} connections=['d: [connection X0/d =>[signal: a_355_47# w=1]]', 'g: [connection X0/g =>[signal: a_244_47# w=1]]', 's: [connection X0/s =>[signal: VPWR w=1]]', 'b: [connection X0/b =>[signal: VPB w=1]]']]
X_input5_0 input5_a_355_47# input5_a_244_47# VPWR no_conn_29 sky130_fd_pr__pfet_01v8_hvt w=820000u l=250000u
** [instance X1 of sky130_fd_pr__pfet_01v8_hvt, params={'w': '820000u', 'l': '250000u'} connections=['d: [connection X1/d =>[signal: VPWR w=1]]', 'g: [connection X1/g =>[signal: a_27_47# w=1]]', 's: [connection X1/s =>[signal: a_244_47# w=1]]', 'b: [connection X1/b =>[signal: VPB w=1]]']]
X_input5_1 VPWR input5_a_27_47# input5_a_244_47# no_conn_29 sky130_fd_pr__pfet_01v8_hvt w=820000u l=250000u
** [instance X2 of sky130_fd_pr__pfet_01v8_hvt, params={'w': '1e+06u', 'l': '150000u'} connections=['d: [connection X2/d =>[signal: VPWR w=1]]', 'g: [connection X2/g =>[signal: a_355_47# w=1]]', 's: [connection X2/s =>[signal: X w=1]]', 'b: [connection X2/b =>[signal: VPB w=1]]']]
X_input5_2 VPWR input5_a_355_47# input5:X no_conn_29 sky130_fd_pr__pfet_01v8_hvt w=1e+06u l=150000u
** [instance X3 of sky130_fd_pr__pfet_01v8_hvt, params={'w': '1e+06u', 'l': '150000u'} connections=['d: [connection X3/d =>[signal: a_27_47# w=1]]', 'g: [connection X3/g =>[signal: A w=1]]', 's: [connection X3/s =>[signal: VPWR w=1]]', 'b: [connection X3/b =>[signal: VPB w=1]]']]
X_input5_3 input5_a_27_47# input5:A VPWR no_conn_29 sky130_fd_pr__pfet_01v8_hvt w=1e+06u l=150000u
** [instance X4 of sky130_fd_pr__nfet_01v8, params={'w': '650000u', 'l': '250000u'} connections=['d: [connection X4/d =>[signal: a_355_47# w=1]]', 'g: [connection X4/g =>[signal: a_244_47# w=1]]', 's: [connection X4/s =>[signal: VGND w=1]]', 'b: [connection X4/b =>[signal: VNB w=1]]']]
X_input5_4 input5_a_355_47# input5_a_244_47# VGND no_conn_28 sky130_fd_pr__nfet_01v8 w=650000u l=250000u
** [instance X5 of sky130_fd_pr__nfet_01v8, params={'w': '650000u', 'l': '250000u'} connections=['d: [connection X5/d =>[signal: VGND w=1]]', 'g: [connection X5/g =>[signal: a_27_47# w=1]]', 's: [connection X5/s =>[signal: a_244_47# w=1]]', 'b: [connection X5/b =>[signal: VNB w=1]]']]
X_input5_5 VGND input5_a_27_47# input5_a_244_47# no_conn_28 sky130_fd_pr__nfet_01v8 w=650000u l=250000u
** [instance X6 of sky130_fd_pr__nfet_01v8, params={'w': '420000u', 'l': '150000u'} connections=['d: [connection X6/d =>[signal: VGND w=1]]', 'g: [connection X6/g =>[signal: a_355_47# w=1]]', 's: [connection X6/s =>[signal: X w=1]]', 'b: [connection X6/b =>[signal: VNB w=1]]']]
X_input5_6 VGND input5_a_355_47# input5:X no_conn_28 sky130_fd_pr__nfet_01v8 w=420000u l=150000u
** [instance X7 of sky130_fd_pr__nfet_01v8, params={'w': '420000u', 'l': '150000u'} connections=['d: [connection X7/d =>[signal: a_27_47# w=1]]', 'g: [connection X7/g =>[signal: A w=1]]', 's: [connection X7/s =>[signal: VGND w=1]]', 'b: [connection X7/b =>[signal: VNB w=1]]']]
X_input5_7 input5_a_27_47# input5:A VGND no_conn_28 sky130_fd_pr__nfet_01v8 w=420000u l=150000u

** replacing input8 with the contents of sky130_fd_sc_hd__clkdlybuf4s25_1
** [instance X0 of sky130_fd_pr__pfet_01v8_hvt, params={'w': '820000u', 'l': '250000u'} connections=['d: [connection X0/d =>[signal: a_355_47# w=1]]', 'g: [connection X0/g =>[signal: a_244_47# w=1]]', 's: [connection X0/s =>[signal: VPWR w=1]]', 'b: [connection X0/b =>[signal: VPB w=1]]']]
X_input8_0 input8_a_355_47# input8_a_244_47# VPWR no_conn_31 sky130_fd_pr__pfet_01v8_hvt w=820000u l=250000u
** [instance X1 of sky130_fd_pr__pfet_01v8_hvt, params={'w': '820000u', 'l': '250000u'} connections=['d: [connection X1/d =>[signal: VPWR w=1]]', 'g: [connection X1/g =>[signal: a_27_47# w=1]]', 's: [connection X1/s =>[signal: a_244_47# w=1]]', 'b: [connection X1/b =>[signal: VPB w=1]]']]
X_input8_1 VPWR input8_a_27_47# input8_a_244_47# no_conn_31 sky130_fd_pr__pfet_01v8_hvt w=820000u l=250000u
** [instance X2 of sky130_fd_pr__pfet_01v8_hvt, params={'w': '1e+06u', 'l': '150000u'} connections=['d: [connection X2/d =>[signal: VPWR w=1]]', 'g: [connection X2/g =>[signal: a_355_47# w=1]]', 's: [connection X2/s =>[signal: X w=1]]', 'b: [connection X2/b =>[signal: VPB w=1]]']]
X_input8_2 VPWR input8_a_355_47# input8:X no_conn_31 sky130_fd_pr__pfet_01v8_hvt w=1e+06u l=150000u
** [instance X3 of sky130_fd_pr__pfet_01v8_hvt, params={'w': '1e+06u', 'l': '150000u'} connections=['d: [connection X3/d =>[signal: a_27_47# w=1]]', 'g: [connection X3/g =>[signal: A w=1]]', 's: [connection X3/s =>[signal: VPWR w=1]]', 'b: [connection X3/b =>[signal: VPB w=1]]']]
X_input8_3 input8_a_27_47# input8:A VPWR no_conn_31 sky130_fd_pr__pfet_01v8_hvt w=1e+06u l=150000u
** [instance X4 of sky130_fd_pr__nfet_01v8, params={'w': '650000u', 'l': '250000u'} connections=['d: [connection X4/d =>[signal: a_355_47# w=1]]', 'g: [connection X4/g =>[signal: a_244_47# w=1]]', 's: [connection X4/s =>[signal: VGND w=1]]', 'b: [connection X4/b =>[signal: VNB w=1]]']]
X_input8_4 input8_a_355_47# input8_a_244_47# VGND no_conn_30 sky130_fd_pr__nfet_01v8 w=650000u l=250000u
** [instance X5 of sky130_fd_pr__nfet_01v8, params={'w': '650000u', 'l': '250000u'} connections=['d: [connection X5/d =>[signal: VGND w=1]]', 'g: [connection X5/g =>[signal: a_27_47# w=1]]', 's: [connection X5/s =>[signal: a_244_47# w=1]]', 'b: [connection X5/b =>[signal: VNB w=1]]']]
X_input8_5 VGND input8_a_27_47# input8_a_244_47# no_conn_30 sky130_fd_pr__nfet_01v8 w=650000u l=250000u
** [instance X6 of sky130_fd_pr__nfet_01v8, params={'w': '420000u', 'l': '150000u'} connections=['d: [connection X6/d =>[signal: VGND w=1]]', 'g: [connection X6/g =>[signal: a_355_47# w=1]]', 's: [connection X6/s =>[signal: X w=1]]', 'b: [connection X6/b =>[signal: VNB w=1]]']]
X_input8_6 VGND input8_a_355_47# input8:X no_conn_30 sky130_fd_pr__nfet_01v8 w=420000u l=150000u
** [instance X7 of sky130_fd_pr__nfet_01v8, params={'w': '420000u', 'l': '150000u'} connections=['d: [connection X7/d =>[signal: a_27_47# w=1]]', 'g: [connection X7/g =>[signal: A w=1]]', 's: [connection X7/s =>[signal: VGND w=1]]', 'b: [connection X7/b =>[signal: VNB w=1]]']]
X_input8_7 input8_a_27_47# input8:A VGND no_conn_30 sky130_fd_pr__nfet_01v8 w=420000u l=150000u

** replacing output11 with the contents of sky130_fd_sc_hd__clkdlybuf4s25_1
** [instance X0 of sky130_fd_pr__pfet_01v8_hvt, params={'w': '820000u', 'l': '250000u'} connections=['d: [connection X0/d =>[signal: a_355_47# w=1]]', 'g: [connection X0/g =>[signal: a_244_47# w=1]]', 's: [connection X0/s =>[signal: VPWR w=1]]', 'b: [connection X0/b =>[signal: VPB w=1]]']]
X_output11_0 output11_a_355_47# output11_a_244_47# VPWR no_conn_33 sky130_fd_pr__pfet_01v8_hvt w=820000u l=250000u
** [instance X1 of sky130_fd_pr__pfet_01v8_hvt, params={'w': '820000u', 'l': '250000u'} connections=['d: [connection X1/d =>[signal: VPWR w=1]]', 'g: [connection X1/g =>[signal: a_27_47# w=1]]', 's: [connection X1/s =>[signal: a_244_47# w=1]]', 'b: [connection X1/b =>[signal: VPB w=1]]']]
X_output11_1 VPWR output11_a_27_47# output11_a_244_47# no_conn_33 sky130_fd_pr__pfet_01v8_hvt w=820000u l=250000u
** [instance X2 of sky130_fd_pr__pfet_01v8_hvt, params={'w': '1e+06u', 'l': '150000u'} connections=['d: [connection X2/d =>[signal: VPWR w=1]]', 'g: [connection X2/g =>[signal: a_355_47# w=1]]', 's: [connection X2/s =>[signal: X w=1]]', 'b: [connection X2/b =>[signal: VPB w=1]]']]
X_output11_2 VPWR output11_a_355_47# output11:X no_conn_33 sky130_fd_pr__pfet_01v8_hvt w=1e+06u l=150000u
** [instance X3 of sky130_fd_pr__pfet_01v8_hvt, params={'w': '1e+06u', 'l': '150000u'} connections=['d: [connection X3/d =>[signal: a_27_47# w=1]]', 'g: [connection X3/g =>[signal: A w=1]]', 's: [connection X3/s =>[signal: VPWR w=1]]', 'b: [connection X3/b =>[signal: VPB w=1]]']]
X_output11_3 output11_a_27_47# output11:A VPWR no_conn_33 sky130_fd_pr__pfet_01v8_hvt w=1e+06u l=150000u
** [instance X4 of sky130_fd_pr__nfet_01v8, params={'w': '650000u', 'l': '250000u'} connections=['d: [connection X4/d =>[signal: a_355_47# w=1]]', 'g: [connection X4/g =>[signal: a_244_47# w=1]]', 's: [connection X4/s =>[signal: VGND w=1]]', 'b: [connection X4/b =>[signal: VNB w=1]]']]
X_output11_4 output11_a_355_47# output11_a_244_47# VGND no_conn_32 sky130_fd_pr__nfet_01v8 w=650000u l=250000u
** [instance X5 of sky130_fd_pr__nfet_01v8, params={'w': '650000u', 'l': '250000u'} connections=['d: [connection X5/d =>[signal: VGND w=1]]', 'g: [connection X5/g =>[signal: a_27_47# w=1]]', 's: [connection X5/s =>[signal: a_244_47# w=1]]', 'b: [connection X5/b =>[signal: VNB w=1]]']]
X_output11_5 VGND output11_a_27_47# output11_a_244_47# no_conn_32 sky130_fd_pr__nfet_01v8 w=650000u l=250000u
** [instance X6 of sky130_fd_pr__nfet_01v8, params={'w': '420000u', 'l': '150000u'} connections=['d: [connection X6/d =>[signal: VGND w=1]]', 'g: [connection X6/g =>[signal: a_355_47# w=1]]', 's: [connection X6/s =>[signal: X w=1]]', 'b: [connection X6/b =>[signal: VNB w=1]]']]
X_output11_6 VGND output11_a_355_47# output11:X no_conn_32 sky130_fd_pr__nfet_01v8 w=420000u l=150000u
** [instance X7 of sky130_fd_pr__nfet_01v8, params={'w': '420000u', 'l': '150000u'} connections=['d: [connection X7/d =>[signal: a_27_47# w=1]]', 'g: [connection X7/g =>[signal: A w=1]]', 's: [connection X7/s =>[signal: VGND w=1]]', 'b: [connection X7/b =>[signal: VNB w=1]]']]
X_output11_7 output11_a_27_47# output11:A VGND no_conn_32 sky130_fd_pr__nfet_01v8 w=420000u l=150000u

** replacing output9 with the contents of sky130_fd_sc_hd__clkdlybuf4s25_1
** [instance X0 of sky130_fd_pr__pfet_01v8_hvt, params={'w': '820000u', 'l': '250000u'} connections=['d: [connection X0/d =>[signal: a_355_47# w=1]]', 'g: [connection X0/g =>[signal: a_244_47# w=1]]', 's: [connection X0/s =>[signal: VPWR w=1]]', 'b: [connection X0/b =>[signal: VPB w=1]]']]
X_output9_0 output9_a_355_47# output9_a_244_47# VPWR no_conn_35 sky130_fd_pr__pfet_01v8_hvt w=820000u l=250000u
** [instance X1 of sky130_fd_pr__pfet_01v8_hvt, params={'w': '820000u', 'l': '250000u'} connections=['d: [connection X1/d =>[signal: VPWR w=1]]', 'g: [connection X1/g =>[signal: a_27_47# w=1]]', 's: [connection X1/s =>[signal: a_244_47# w=1]]', 'b: [connection X1/b =>[signal: VPB w=1]]']]
X_output9_1 VPWR output9_a_27_47# output9_a_244_47# no_conn_35 sky130_fd_pr__pfet_01v8_hvt w=820000u l=250000u
** [instance X2 of sky130_fd_pr__pfet_01v8_hvt, params={'w': '1e+06u', 'l': '150000u'} connections=['d: [connection X2/d =>[signal: VPWR w=1]]', 'g: [connection X2/g =>[signal: a_355_47# w=1]]', 's: [connection X2/s =>[signal: X w=1]]', 'b: [connection X2/b =>[signal: VPB w=1]]']]
X_output9_2 VPWR output9_a_355_47# output9:X no_conn_35 sky130_fd_pr__pfet_01v8_hvt w=1e+06u l=150000u
** [instance X3 of sky130_fd_pr__pfet_01v8_hvt, params={'w': '1e+06u', 'l': '150000u'} connections=['d: [connection X3/d =>[signal: a_27_47# w=1]]', 'g: [connection X3/g =>[signal: A w=1]]', 's: [connection X3/s =>[signal: VPWR w=1]]', 'b: [connection X3/b =>[signal: VPB w=1]]']]
X_output9_3 output9_a_27_47# output9:A VPWR no_conn_35 sky130_fd_pr__pfet_01v8_hvt w=1e+06u l=150000u
** [instance X4 of sky130_fd_pr__nfet_01v8, params={'w': '650000u', 'l': '250000u'} connections=['d: [connection X4/d =>[signal: a_355_47# w=1]]', 'g: [connection X4/g =>[signal: a_244_47# w=1]]', 's: [connection X4/s =>[signal: VGND w=1]]', 'b: [connection X4/b =>[signal: VNB w=1]]']]
X_output9_4 output9_a_355_47# output9_a_244_47# VGND no_conn_34 sky130_fd_pr__nfet_01v8 w=650000u l=250000u
** [instance X5 of sky130_fd_pr__nfet_01v8, params={'w': '650000u', 'l': '250000u'} connections=['d: [connection X5/d =>[signal: VGND w=1]]', 'g: [connection X5/g =>[signal: a_27_47# w=1]]', 's: [connection X5/s =>[signal: a_244_47# w=1]]', 'b: [connection X5/b =>[signal: VNB w=1]]']]
X_output9_5 VGND output9_a_27_47# output9_a_244_47# no_conn_34 sky130_fd_pr__nfet_01v8 w=650000u l=250000u
** [instance X6 of sky130_fd_pr__nfet_01v8, params={'w': '420000u', 'l': '150000u'} connections=['d: [connection X6/d =>[signal: VGND w=1]]', 'g: [connection X6/g =>[signal: a_355_47# w=1]]', 's: [connection X6/s =>[signal: X w=1]]', 'b: [connection X6/b =>[signal: VNB w=1]]']]
X_output9_6 VGND output9_a_355_47# output9:X no_conn_34 sky130_fd_pr__nfet_01v8 w=420000u l=150000u
** [instance X7 of sky130_fd_pr__nfet_01v8, params={'w': '420000u', 'l': '150000u'} connections=['d: [connection X7/d =>[signal: a_27_47# w=1]]', 'g: [connection X7/g =>[signal: A w=1]]', 's: [connection X7/s =>[signal: VGND w=1]]', 'b: [connection X7/b =>[signal: VNB w=1]]']]
X_output9_7 output9_a_27_47# output9:A VGND no_conn_34 sky130_fd_pr__nfet_01v8 w=420000u l=150000u

** replacing output10 with the contents of sky130_fd_sc_hd__clkdlybuf4s25_1
** [instance X0 of sky130_fd_pr__pfet_01v8_hvt, params={'w': '820000u', 'l': '250000u'} connections=['d: [connection X0/d =>[signal: a_355_47# w=1]]', 'g: [connection X0/g =>[signal: a_244_47# w=1]]', 's: [connection X0/s =>[signal: VPWR w=1]]', 'b: [connection X0/b =>[signal: VPB w=1]]']]
X_output10_0 output10_a_355_47# output10_a_244_47# VPWR no_conn_37 sky130_fd_pr__pfet_01v8_hvt w=820000u l=250000u
** [instance X1 of sky130_fd_pr__pfet_01v8_hvt, params={'w': '820000u', 'l': '250000u'} connections=['d: [connection X1/d =>[signal: VPWR w=1]]', 'g: [connection X1/g =>[signal: a_27_47# w=1]]', 's: [connection X1/s =>[signal: a_244_47# w=1]]', 'b: [connection X1/b =>[signal: VPB w=1]]']]
X_output10_1 VPWR output10_a_27_47# output10_a_244_47# no_conn_37 sky130_fd_pr__pfet_01v8_hvt w=820000u l=250000u
** [instance X2 of sky130_fd_pr__pfet_01v8_hvt, params={'w': '1e+06u', 'l': '150000u'} connections=['d: [connection X2/d =>[signal: VPWR w=1]]', 'g: [connection X2/g =>[signal: a_355_47# w=1]]', 's: [connection X2/s =>[signal: X w=1]]', 'b: [connection X2/b =>[signal: VPB w=1]]']]
X_output10_2 VPWR output10_a_355_47# output10:X no_conn_37 sky130_fd_pr__pfet_01v8_hvt w=1e+06u l=150000u
** [instance X3 of sky130_fd_pr__pfet_01v8_hvt, params={'w': '1e+06u', 'l': '150000u'} connections=['d: [connection X3/d =>[signal: a_27_47# w=1]]', 'g: [connection X3/g =>[signal: A w=1]]', 's: [connection X3/s =>[signal: VPWR w=1]]', 'b: [connection X3/b =>[signal: VPB w=1]]']]
X_output10_3 output10_a_27_47# output10:A VPWR no_conn_37 sky130_fd_pr__pfet_01v8_hvt w=1e+06u l=150000u
** [instance X4 of sky130_fd_pr__nfet_01v8, params={'w': '650000u', 'l': '250000u'} connections=['d: [connection X4/d =>[signal: a_355_47# w=1]]', 'g: [connection X4/g =>[signal: a_244_47# w=1]]', 's: [connection X4/s =>[signal: VGND w=1]]', 'b: [connection X4/b =>[signal: VNB w=1]]']]
X_output10_4 output10_a_355_47# output10_a_244_47# VGND no_conn_36 sky130_fd_pr__nfet_01v8 w=650000u l=250000u
** [instance X5 of sky130_fd_pr__nfet_01v8, params={'w': '650000u', 'l': '250000u'} connections=['d: [connection X5/d =>[signal: VGND w=1]]', 'g: [connection X5/g =>[signal: a_27_47# w=1]]', 's: [connection X5/s =>[signal: a_244_47# w=1]]', 'b: [connection X5/b =>[signal: VNB w=1]]']]
X_output10_5 VGND output10_a_27_47# output10_a_244_47# no_conn_36 sky130_fd_pr__nfet_01v8 w=650000u l=250000u
** [instance X6 of sky130_fd_pr__nfet_01v8, params={'w': '420000u', 'l': '150000u'} connections=['d: [connection X6/d =>[signal: VGND w=1]]', 'g: [connection X6/g =>[signal: a_355_47# w=1]]', 's: [connection X6/s =>[signal: X w=1]]', 'b: [connection X6/b =>[signal: VNB w=1]]']]
X_output10_6 VGND output10_a_355_47# output10:X no_conn_36 sky130_fd_pr__nfet_01v8 w=420000u l=150000u
** [instance X7 of sky130_fd_pr__nfet_01v8, params={'w': '420000u', 'l': '150000u'} connections=['d: [connection X7/d =>[signal: a_27_47# w=1]]', 'g: [connection X7/g =>[signal: A w=1]]', 's: [connection X7/s =>[signal: VGND w=1]]', 'b: [connection X7/b =>[signal: VNB w=1]]']]
X_output10_7 output10_a_27_47# output10:A VGND no_conn_36 sky130_fd_pr__nfet_01v8 w=420000u l=150000u

** replacing clkbuf_0_scan_clk with the contents of sky130_fd_sc_hd__clkbuf_16
** [instance X0 of sky130_fd_pr__pfet_01v8_hvt, params={'w': '1e+06u', 'l': '150000u'} connections=['d: [connection X0/d =>[signal: VPWR w=1]]', 'g: [connection X0/g =>[signal: a_110_47# w=1]]', 's: [connection X0/s =>[signal: X w=1]]', 'b: [connection X0/b =>[signal: VPB w=1]]']]
X_clkbuf_0_scan_clk_0 VPWR clkbuf_0_scan_clk_a_110_47# clkbuf_0_scan_clk:X no_conn_39 sky130_fd_pr__pfet_01v8_hvt w=1e+06u l=150000u
** [instance X1 of sky130_fd_pr__nfet_01v8, params={'w': '420000u', 'l': '150000u'} connections=['d: [connection X1/d =>[signal: X w=1]]', 'g: [connection X1/g =>[signal: a_110_47# w=1]]', 's: [connection X1/s =>[signal: VGND w=1]]', 'b: [connection X1/b =>[signal: VNB w=1]]']]
X_clkbuf_0_scan_clk_1 clkbuf_0_scan_clk:X clkbuf_0_scan_clk_a_110_47# VGND no_conn_38 sky130_fd_pr__nfet_01v8 w=420000u l=150000u
** [instance X2 of sky130_fd_pr__nfet_01v8, params={'w': '420000u', 'l': '150000u'} connections=['d: [connection X2/d =>[signal: X w=1]]', 'g: [connection X2/g =>[signal: a_110_47# w=1]]', 's: [connection X2/s =>[signal: VGND w=1]]', 'b: [connection X2/b =>[signal: VNB w=1]]']]
X_clkbuf_0_scan_clk_2 clkbuf_0_scan_clk:X clkbuf_0_scan_clk_a_110_47# VGND no_conn_38 sky130_fd_pr__nfet_01v8 w=420000u l=150000u
** [instance X3 of sky130_fd_pr__pfet_01v8_hvt, params={'w': '1e+06u', 'l': '150000u'} connections=['d: [connection X3/d =>[signal: a_110_47# w=1]]', 'g: [connection X3/g =>[signal: A w=1]]', 's: [connection X3/s =>[signal: VPWR w=1]]', 'b: [connection X3/b =>[signal: VPB w=1]]']]
X_clkbuf_0_scan_clk_3 clkbuf_0_scan_clk_a_110_47# clkbuf_0_scan_clk:A VPWR no_conn_39 sky130_fd_pr__pfet_01v8_hvt w=1e+06u l=150000u
** [instance X4 of sky130_fd_pr__pfet_01v8_hvt, params={'w': '1e+06u', 'l': '150000u'} connections=['d: [connection X4/d =>[signal: VPWR w=1]]', 'g: [connection X4/g =>[signal: a_110_47# w=1]]', 's: [connection X4/s =>[signal: X w=1]]', 'b: [connection X4/b =>[signal: VPB w=1]]']]
X_clkbuf_0_scan_clk_4 VPWR clkbuf_0_scan_clk_a_110_47# clkbuf_0_scan_clk:X no_conn_39 sky130_fd_pr__pfet_01v8_hvt w=1e+06u l=150000u
** [instance X5 of sky130_fd_pr__pfet_01v8_hvt, params={'w': '1e+06u', 'l': '150000u'} connections=['d: [connection X5/d =>[signal: X w=1]]', 'g: [connection X5/g =>[signal: a_110_47# w=1]]', 's: [connection X5/s =>[signal: VPWR w=1]]', 'b: [connection X5/b =>[signal: VPB w=1]]']]
X_clkbuf_0_scan_clk_5 clkbuf_0_scan_clk:X clkbuf_0_scan_clk_a_110_47# VPWR no_conn_39 sky130_fd_pr__pfet_01v8_hvt w=1e+06u l=150000u
** [instance X6 of sky130_fd_pr__nfet_01v8, params={'w': '420000u', 'l': '150000u'} connections=['d: [connection X6/d =>[signal: a_110_47# w=1]]', 'g: [connection X6/g =>[signal: A w=1]]', 's: [connection X6/s =>[signal: VGND w=1]]', 'b: [connection X6/b =>[signal: VNB w=1]]']]
X_clkbuf_0_scan_clk_6 clkbuf_0_scan_clk_a_110_47# clkbuf_0_scan_clk:A VGND no_conn_38 sky130_fd_pr__nfet_01v8 w=420000u l=150000u
** [instance X7 of sky130_fd_pr__pfet_01v8_hvt, params={'w': '1e+06u', 'l': '150000u'} connections=['d: [connection X7/d =>[signal: VPWR w=1]]', 'g: [connection X7/g =>[signal: A w=1]]', 's: [connection X7/s =>[signal: a_110_47# w=1]]', 'b: [connection X7/b =>[signal: VPB w=1]]']]
X_clkbuf_0_scan_clk_7 VPWR clkbuf_0_scan_clk:A clkbuf_0_scan_clk_a_110_47# no_conn_39 sky130_fd_pr__pfet_01v8_hvt w=1e+06u l=150000u
** [instance X8 of sky130_fd_pr__nfet_01v8, params={'w': '420000u', 'l': '150000u'} connections=['d: [connection X8/d =>[signal: VGND w=1]]', 'g: [connection X8/g =>[signal: a_110_47# w=1]]', 's: [connection X8/s =>[signal: X w=1]]', 'b: [connection X8/b =>[signal: VNB w=1]]']]
X_clkbuf_0_scan_clk_8 VGND clkbuf_0_scan_clk_a_110_47# clkbuf_0_scan_clk:X no_conn_38 sky130_fd_pr__nfet_01v8 w=420000u l=150000u
** [instance X9 of sky130_fd_pr__nfet_01v8, params={'w': '420000u', 'l': '150000u'} connections=['d: [connection X9/d =>[signal: VGND w=1]]', 'g: [connection X9/g =>[signal: A w=1]]', 's: [connection X9/s =>[signal: a_110_47# w=1]]', 'b: [connection X9/b =>[signal: VNB w=1]]']]
X_clkbuf_0_scan_clk_9 VGND clkbuf_0_scan_clk:A clkbuf_0_scan_clk_a_110_47# no_conn_38 sky130_fd_pr__nfet_01v8 w=420000u l=150000u
** [instance X10 of sky130_fd_pr__nfet_01v8, params={'w': '420000u', 'l': '150000u'} connections=['d: [connection X10/d =>[signal: X w=1]]', 'g: [connection X10/g =>[signal: a_110_47# w=1]]', 's: [connection X10/s =>[signal: VGND w=1]]', 'b: [connection X10/b =>[signal: VNB w=1]]']]
X_clkbuf_0_scan_clk_10 clkbuf_0_scan_clk:X clkbuf_0_scan_clk_a_110_47# VGND no_conn_38 sky130_fd_pr__nfet_01v8 w=420000u l=150000u
** [instance X11 of sky130_fd_pr__nfet_01v8, params={'w': '420000u', 'l': '150000u'} connections=['d: [connection X11/d =>[signal: X w=1]]', 'g: [connection X11/g =>[signal: a_110_47# w=1]]', 's: [connection X11/s =>[signal: VGND w=1]]', 'b: [connection X11/b =>[signal: VNB w=1]]']]
X_clkbuf_0_scan_clk_11 clkbuf_0_scan_clk:X clkbuf_0_scan_clk_a_110_47# VGND no_conn_38 sky130_fd_pr__nfet_01v8 w=420000u l=150000u
** [instance X12 of sky130_fd_pr__pfet_01v8_hvt, params={'w': '1e+06u', 'l': '150000u'} connections=['d: [connection X12/d =>[signal: a_110_47# w=1]]', 'g: [connection X12/g =>[signal: A w=1]]', 's: [connection X12/s =>[signal: VPWR w=1]]', 'b: [connection X12/b =>[signal: VPB w=1]]']]
X_clkbuf_0_scan_clk_12 clkbuf_0_scan_clk_a_110_47# clkbuf_0_scan_clk:A VPWR no_conn_39 sky130_fd_pr__pfet_01v8_hvt w=1e+06u l=150000u
** [instance X13 of sky130_fd_pr__pfet_01v8_hvt, params={'w': '1e+06u', 'l': '150000u'} connections=['d: [connection X13/d =>[signal: VPWR w=1]]', 'g: [connection X13/g =>[signal: a_110_47# w=1]]', 's: [connection X13/s =>[signal: X w=1]]', 'b: [connection X13/b =>[signal: VPB w=1]]']]
X_clkbuf_0_scan_clk_13 VPWR clkbuf_0_scan_clk_a_110_47# clkbuf_0_scan_clk:X no_conn_39 sky130_fd_pr__pfet_01v8_hvt w=1e+06u l=150000u
** [instance X14 of sky130_fd_pr__nfet_01v8, params={'w': '420000u', 'l': '150000u'} connections=['d: [connection X14/d =>[signal: X w=1]]', 'g: [connection X14/g =>[signal: a_110_47# w=1]]', 's: [connection X14/s =>[signal: VGND w=1]]', 'b: [connection X14/b =>[signal: VNB w=1]]']]
X_clkbuf_0_scan_clk_14 clkbuf_0_scan_clk:X clkbuf_0_scan_clk_a_110_47# VGND no_conn_38 sky130_fd_pr__nfet_01v8 w=420000u l=150000u
** [instance X15 of sky130_fd_pr__pfet_01v8_hvt, params={'w': '1e+06u', 'l': '150000u'} connections=['d: [connection X15/d =>[signal: VPWR w=1]]', 'g: [connection X15/g =>[signal: A w=1]]', 's: [connection X15/s =>[signal: a_110_47# w=1]]', 'b: [connection X15/b =>[signal: VPB w=1]]']]
X_clkbuf_0_scan_clk_15 VPWR clkbuf_0_scan_clk:A clkbuf_0_scan_clk_a_110_47# no_conn_39 sky130_fd_pr__pfet_01v8_hvt w=1e+06u l=150000u
** [instance X16 of sky130_fd_pr__nfet_01v8, params={'w': '420000u', 'l': '150000u'} connections=['d: [connection X16/d =>[signal: VGND w=1]]', 'g: [connection X16/g =>[signal: a_110_47# w=1]]', 's: [connection X16/s =>[signal: X w=1]]', 'b: [connection X16/b =>[signal: VNB w=1]]']]
X_clkbuf_0_scan_clk_16 VGND clkbuf_0_scan_clk_a_110_47# clkbuf_0_scan_clk:X no_conn_38 sky130_fd_pr__nfet_01v8 w=420000u l=150000u
** [instance X17 of sky130_fd_pr__nfet_01v8, params={'w': '420000u', 'l': '150000u'} connections=['d: [connection X17/d =>[signal: X w=1]]', 'g: [connection X17/g =>[signal: a_110_47# w=1]]', 's: [connection X17/s =>[signal: VGND w=1]]', 'b: [connection X17/b =>[signal: VNB w=1]]']]
X_clkbuf_0_scan_clk_17 clkbuf_0_scan_clk:X clkbuf_0_scan_clk_a_110_47# VGND no_conn_38 sky130_fd_pr__nfet_01v8 w=420000u l=150000u
** [instance X18 of sky130_fd_pr__nfet_01v8, params={'w': '420000u', 'l': '150000u'} connections=['d: [connection X18/d =>[signal: VGND w=1]]', 'g: [connection X18/g =>[signal: a_110_47# w=1]]', 's: [connection X18/s =>[signal: X w=1]]', 'b: [connection X18/b =>[signal: VNB w=1]]']]
X_clkbuf_0_scan_clk_18 VGND clkbuf_0_scan_clk_a_110_47# clkbuf_0_scan_clk:X no_conn_38 sky130_fd_pr__nfet_01v8 w=420000u l=150000u
** [instance X19 of sky130_fd_pr__nfet_01v8, params={'w': '420000u', 'l': '150000u'} connections=['d: [connection X19/d =>[signal: VGND w=1]]', 'g: [connection X19/g =>[signal: a_110_47# w=1]]', 's: [connection X19/s =>[signal: X w=1]]', 'b: [connection X19/b =>[signal: VNB w=1]]']]
X_clkbuf_0_scan_clk_19 VGND clkbuf_0_scan_clk_a_110_47# clkbuf_0_scan_clk:X no_conn_38 sky130_fd_pr__nfet_01v8 w=420000u l=150000u
** [instance X20 of sky130_fd_pr__pfet_01v8_hvt, params={'w': '1e+06u', 'l': '150000u'} connections=['d: [connection X20/d =>[signal: X w=1]]', 'g: [connection X20/g =>[signal: a_110_47# w=1]]', 's: [connection X20/s =>[signal: VPWR w=1]]', 'b: [connection X20/b =>[signal: VPB w=1]]']]
X_clkbuf_0_scan_clk_20 clkbuf_0_scan_clk:X clkbuf_0_scan_clk_a_110_47# VPWR no_conn_39 sky130_fd_pr__pfet_01v8_hvt w=1e+06u l=150000u
** [instance X21 of sky130_fd_pr__pfet_01v8_hvt, params={'w': '1e+06u', 'l': '150000u'} connections=['d: [connection X21/d =>[signal: X w=1]]', 'g: [connection X21/g =>[signal: a_110_47# w=1]]', 's: [connection X21/s =>[signal: VPWR w=1]]', 'b: [connection X21/b =>[signal: VPB w=1]]']]
X_clkbuf_0_scan_clk_21 clkbuf_0_scan_clk:X clkbuf_0_scan_clk_a_110_47# VPWR no_conn_39 sky130_fd_pr__pfet_01v8_hvt w=1e+06u l=150000u
** [instance X22 of sky130_fd_pr__pfet_01v8_hvt, params={'w': '1e+06u', 'l': '150000u'} connections=['d: [connection X22/d =>[signal: X w=1]]', 'g: [connection X22/g =>[signal: a_110_47# w=1]]', 's: [connection X22/s =>[signal: VPWR w=1]]', 'b: [connection X22/b =>[signal: VPB w=1]]']]
X_clkbuf_0_scan_clk_22 clkbuf_0_scan_clk:X clkbuf_0_scan_clk_a_110_47# VPWR no_conn_39 sky130_fd_pr__pfet_01v8_hvt w=1e+06u l=150000u
** [instance X23 of sky130_fd_pr__pfet_01v8_hvt, params={'w': '1e+06u', 'l': '150000u'} connections=['d: [connection X23/d =>[signal: VPWR w=1]]', 'g: [connection X23/g =>[signal: a_110_47# w=1]]', 's: [connection X23/s =>[signal: X w=1]]', 'b: [connection X23/b =>[signal: VPB w=1]]']]
X_clkbuf_0_scan_clk_23 VPWR clkbuf_0_scan_clk_a_110_47# clkbuf_0_scan_clk:X no_conn_39 sky130_fd_pr__pfet_01v8_hvt w=1e+06u l=150000u
** [instance X24 of sky130_fd_pr__pfet_01v8_hvt, params={'w': '1e+06u', 'l': '150000u'} connections=['d: [connection X24/d =>[signal: VPWR w=1]]', 'g: [connection X24/g =>[signal: a_110_47# w=1]]', 's: [connection X24/s =>[signal: X w=1]]', 'b: [connection X24/b =>[signal: VPB w=1]]']]
X_clkbuf_0_scan_clk_24 VPWR clkbuf_0_scan_clk_a_110_47# clkbuf_0_scan_clk:X no_conn_39 sky130_fd_pr__pfet_01v8_hvt w=1e+06u l=150000u
** [instance X25 of sky130_fd_pr__nfet_01v8, params={'w': '420000u', 'l': '150000u'} connections=['d: [connection X25/d =>[signal: VGND w=1]]', 'g: [connection X25/g =>[signal: a_110_47# w=1]]', 's: [connection X25/s =>[signal: X w=1]]', 'b: [connection X25/b =>[signal: VNB w=1]]']]
X_clkbuf_0_scan_clk_25 VGND clkbuf_0_scan_clk_a_110_47# clkbuf_0_scan_clk:X no_conn_38 sky130_fd_pr__nfet_01v8 w=420000u l=150000u
** [instance X26 of sky130_fd_pr__pfet_01v8_hvt, params={'w': '1e+06u', 'l': '150000u'} connections=['d: [connection X26/d =>[signal: X w=1]]', 'g: [connection X26/g =>[signal: a_110_47# w=1]]', 's: [connection X26/s =>[signal: VPWR w=1]]', 'b: [connection X26/b =>[signal: VPB w=1]]']]
X_clkbuf_0_scan_clk_26 clkbuf_0_scan_clk:X clkbuf_0_scan_clk_a_110_47# VPWR no_conn_39 sky130_fd_pr__pfet_01v8_hvt w=1e+06u l=150000u
** [instance X27 of sky130_fd_pr__nfet_01v8, params={'w': '420000u', 'l': '150000u'} connections=['d: [connection X27/d =>[signal: X w=1]]', 'g: [connection X27/g =>[signal: a_110_47# w=1]]', 's: [connection X27/s =>[signal: VGND w=1]]', 'b: [connection X27/b =>[signal: VNB w=1]]']]
X_clkbuf_0_scan_clk_27 clkbuf_0_scan_clk:X clkbuf_0_scan_clk_a_110_47# VGND no_conn_38 sky130_fd_pr__nfet_01v8 w=420000u l=150000u
** [instance X28 of sky130_fd_pr__pfet_01v8_hvt, params={'w': '1e+06u', 'l': '150000u'} connections=['d: [connection X28/d =>[signal: VPWR w=1]]', 'g: [connection X28/g =>[signal: a_110_47# w=1]]', 's: [connection X28/s =>[signal: X w=1]]', 'b: [connection X28/b =>[signal: VPB w=1]]']]
X_clkbuf_0_scan_clk_28 VPWR clkbuf_0_scan_clk_a_110_47# clkbuf_0_scan_clk:X no_conn_39 sky130_fd_pr__pfet_01v8_hvt w=1e+06u l=150000u
** [instance X29 of sky130_fd_pr__nfet_01v8, params={'w': '420000u', 'l': '150000u'} connections=['d: [connection X29/d =>[signal: VGND w=1]]', 'g: [connection X29/g =>[signal: a_110_47# w=1]]', 's: [connection X29/s =>[signal: X w=1]]', 'b: [connection X29/b =>[signal: VNB w=1]]']]
X_clkbuf_0_scan_clk_29 VGND clkbuf_0_scan_clk_a_110_47# clkbuf_0_scan_clk:X no_conn_38 sky130_fd_pr__nfet_01v8 w=420000u l=150000u
** [instance X30 of sky130_fd_pr__nfet_01v8, params={'w': '420000u', 'l': '150000u'} connections=['d: [connection X30/d =>[signal: X w=1]]', 'g: [connection X30/g =>[signal: a_110_47# w=1]]', 's: [connection X30/s =>[signal: VGND w=1]]', 'b: [connection X30/b =>[signal: VNB w=1]]']]
X_clkbuf_0_scan_clk_30 clkbuf_0_scan_clk:X clkbuf_0_scan_clk_a_110_47# VGND no_conn_38 sky130_fd_pr__nfet_01v8 w=420000u l=150000u
** [instance X31 of sky130_fd_pr__pfet_01v8_hvt, params={'w': '1e+06u', 'l': '150000u'} connections=['d: [connection X31/d =>[signal: X w=1]]', 'g: [connection X31/g =>[signal: a_110_47# w=1]]', 's: [connection X31/s =>[signal: VPWR w=1]]', 'b: [connection X31/b =>[signal: VPB w=1]]']]
X_clkbuf_0_scan_clk_31 clkbuf_0_scan_clk:X clkbuf_0_scan_clk_a_110_47# VPWR no_conn_39 sky130_fd_pr__pfet_01v8_hvt w=1e+06u l=150000u
** [instance X32 of sky130_fd_pr__pfet_01v8_hvt, params={'w': '1e+06u', 'l': '150000u'} connections=['d: [connection X32/d =>[signal: X w=1]]', 'g: [connection X32/g =>[signal: a_110_47# w=1]]', 's: [connection X32/s =>[signal: VPWR w=1]]', 'b: [connection X32/b =>[signal: VPB w=1]]']]
X_clkbuf_0_scan_clk_32 clkbuf_0_scan_clk:X clkbuf_0_scan_clk_a_110_47# VPWR no_conn_39 sky130_fd_pr__pfet_01v8_hvt w=1e+06u l=150000u
** [instance X33 of sky130_fd_pr__pfet_01v8_hvt, params={'w': '1e+06u', 'l': '150000u'} connections=['d: [connection X33/d =>[signal: X w=1]]', 'g: [connection X33/g =>[signal: a_110_47# w=1]]', 's: [connection X33/s =>[signal: VPWR w=1]]', 'b: [connection X33/b =>[signal: VPB w=1]]']]
X_clkbuf_0_scan_clk_33 clkbuf_0_scan_clk:X clkbuf_0_scan_clk_a_110_47# VPWR no_conn_39 sky130_fd_pr__pfet_01v8_hvt w=1e+06u l=150000u
** [instance X34 of sky130_fd_pr__nfet_01v8, params={'w': '420000u', 'l': '150000u'} connections=['d: [connection X34/d =>[signal: a_110_47# w=1]]', 'g: [connection X34/g =>[signal: A w=1]]', 's: [connection X34/s =>[signal: VGND w=1]]', 'b: [connection X34/b =>[signal: VNB w=1]]']]
X_clkbuf_0_scan_clk_34 clkbuf_0_scan_clk_a_110_47# clkbuf_0_scan_clk:A VGND no_conn_38 sky130_fd_pr__nfet_01v8 w=420000u l=150000u
** [instance X35 of sky130_fd_pr__pfet_01v8_hvt, params={'w': '1e+06u', 'l': '150000u'} connections=['d: [connection X35/d =>[signal: VPWR w=1]]', 'g: [connection X35/g =>[signal: a_110_47# w=1]]', 's: [connection X35/s =>[signal: X w=1]]', 'b: [connection X35/b =>[signal: VPB w=1]]']]
X_clkbuf_0_scan_clk_35 VPWR clkbuf_0_scan_clk_a_110_47# clkbuf_0_scan_clk:X no_conn_39 sky130_fd_pr__pfet_01v8_hvt w=1e+06u l=150000u
** [instance X36 of sky130_fd_pr__nfet_01v8, params={'w': '420000u', 'l': '150000u'} connections=['d: [connection X36/d =>[signal: VGND w=1]]', 'g: [connection X36/g =>[signal: A w=1]]', 's: [connection X36/s =>[signal: a_110_47# w=1]]', 'b: [connection X36/b =>[signal: VNB w=1]]']]
X_clkbuf_0_scan_clk_36 VGND clkbuf_0_scan_clk:A clkbuf_0_scan_clk_a_110_47# no_conn_38 sky130_fd_pr__nfet_01v8 w=420000u l=150000u
** [instance X37 of sky130_fd_pr__pfet_01v8_hvt, params={'w': '1e+06u', 'l': '150000u'} connections=['d: [connection X37/d =>[signal: VPWR w=1]]', 'g: [connection X37/g =>[signal: a_110_47# w=1]]', 's: [connection X37/s =>[signal: X w=1]]', 'b: [connection X37/b =>[signal: VPB w=1]]']]
X_clkbuf_0_scan_clk_37 VPWR clkbuf_0_scan_clk_a_110_47# clkbuf_0_scan_clk:X no_conn_39 sky130_fd_pr__pfet_01v8_hvt w=1e+06u l=150000u
** [instance X38 of sky130_fd_pr__nfet_01v8, params={'w': '420000u', 'l': '150000u'} connections=['d: [connection X38/d =>[signal: VGND w=1]]', 'g: [connection X38/g =>[signal: a_110_47# w=1]]', 's: [connection X38/s =>[signal: X w=1]]', 'b: [connection X38/b =>[signal: VNB w=1]]']]
X_clkbuf_0_scan_clk_38 VGND clkbuf_0_scan_clk_a_110_47# clkbuf_0_scan_clk:X no_conn_38 sky130_fd_pr__nfet_01v8 w=420000u l=150000u
** [instance X39 of sky130_fd_pr__nfet_01v8, params={'w': '420000u', 'l': '150000u'} connections=['d: [connection X39/d =>[signal: VGND w=1]]', 'g: [connection X39/g =>[signal: a_110_47# w=1]]', 's: [connection X39/s =>[signal: X w=1]]', 'b: [connection X39/b =>[signal: VNB w=1]]']]
X_clkbuf_0_scan_clk_39 VGND clkbuf_0_scan_clk_a_110_47# clkbuf_0_scan_clk:X no_conn_38 sky130_fd_pr__nfet_01v8 w=420000u l=150000u

** replacing _66_ with the contents of sky130_fd_sc_hd__dfxtp_2
** [instance X0 of sky130_fd_pr__pfet_01v8_hvt, params={'w': '420000u', 'l': '150000u'} connections=['d: [connection X0/d =>[signal: a_891_413# w=1]]', 'g: [connection X0/g =>[signal: a_193_47# w=1]]', 's: [connection X0/s =>[signal: a_975_413# w=1]]', 'b: [connection X0/b =>[signal: VPB w=1]]']]
X__66__0 _66__a_891_413# _66__a_193_47# _66__a_975_413# no_conn_41 sky130_fd_pr__pfet_01v8_hvt w=420000u l=150000u
** [instance X1 of sky130_fd_pr__nfet_01v8, params={'w': '650000u', 'l': '150000u'} connections=['d: [connection X1/d =>[signal: a_1059_315# w=1]]', 'g: [connection X1/g =>[signal: a_891_413# w=1]]', 's: [connection X1/s =>[signal: VGND w=1]]', 'b: [connection X1/b =>[signal: VNB w=1]]']]
X__66__1 _66__a_1059_315# _66__a_891_413# VGND no_conn_40 sky130_fd_pr__nfet_01v8 w=650000u l=150000u
** [instance X2 of sky130_fd_pr__pfet_01v8_hvt, params={'w': '420000u', 'l': '150000u'} connections=['d: [connection X2/d =>[signal: a_466_413# w=1]]', 'g: [connection X2/g =>[signal: a_27_47# w=1]]', 's: [connection X2/s =>[signal: a_561_413# w=1]]', 'b: [connection X2/b =>[signal: VPB w=1]]']]
X__66__2 _66__a_466_413# _66__a_27_47# _66__a_561_413# no_conn_41 sky130_fd_pr__pfet_01v8_hvt w=420000u l=150000u
** [instance X3 of sky130_fd_pr__pfet_01v8_hvt, params={'w': '420000u', 'l': '150000u'} connections=['d: [connection X3/d =>[signal: a_634_159# w=1]]', 'g: [connection X3/g =>[signal: a_27_47# w=1]]', 's: [connection X3/s =>[signal: a_891_413# w=1]]', 'b: [connection X3/b =>[signal: VPB w=1]]']]
X__66__3 _66__a_634_159# _66__a_27_47# _66__a_891_413# no_conn_41 sky130_fd_pr__pfet_01v8_hvt w=420000u l=150000u
** [instance X4 of sky130_fd_pr__pfet_01v8_hvt, params={'w': '420000u', 'l': '150000u'} connections=['d: [connection X4/d =>[signal: a_381_47# w=1]]', 'g: [connection X4/g =>[signal: a_193_47# w=1]]', 's: [connection X4/s =>[signal: a_466_413# w=1]]', 'b: [connection X4/b =>[signal: VPB w=1]]']]
X__66__4 _66__a_381_47# _66__a_193_47# _66__a_466_413# no_conn_41 sky130_fd_pr__pfet_01v8_hvt w=420000u l=150000u
** [instance X5 of sky130_fd_pr__pfet_01v8_hvt, params={'w': '420000u', 'l': '150000u'} connections=['d: [connection X5/d =>[signal: VPWR w=1]]', 'g: [connection X5/g =>[signal: D w=1]]', 's: [connection X5/s =>[signal: a_381_47# w=1]]', 'b: [connection X5/b =>[signal: VPB w=1]]']]
X__66__5 VPWR _66_:D _66__a_381_47# no_conn_41 sky130_fd_pr__pfet_01v8_hvt w=420000u l=150000u
** [instance X6 of sky130_fd_pr__pfet_01v8_hvt, params={'w': '750000u', 'l': '150000u'} connections=['d: [connection X6/d =>[signal: VPWR w=1]]', 'g: [connection X6/g =>[signal: a_466_413# w=1]]', 's: [connection X6/s =>[signal: a_634_159# w=1]]', 'b: [connection X6/b =>[signal: VPB w=1]]']]
X__66__6 VPWR _66__a_466_413# _66__a_634_159# no_conn_41 sky130_fd_pr__pfet_01v8_hvt w=750000u l=150000u
** [instance X7 of sky130_fd_pr__nfet_01v8, params={'w': '640000u', 'l': '150000u'} connections=['d: [connection X7/d =>[signal: VGND w=1]]', 'g: [connection X7/g =>[signal: a_466_413# w=1]]', 's: [connection X7/s =>[signal: a_634_159# w=1]]', 'b: [connection X7/b =>[signal: VNB w=1]]']]
X__66__7 VGND _66__a_466_413# _66__a_634_159# no_conn_40 sky130_fd_pr__nfet_01v8 w=640000u l=150000u
** [instance X8 of sky130_fd_pr__nfet_01v8, params={'w': '420000u', 'l': '150000u'} connections=['d: [connection X8/d =>[signal: a_1017_47# w=1]]', 'g: [connection X8/g =>[signal: a_1059_315# w=1]]', 's: [connection X8/s =>[signal: VGND w=1]]', 'b: [connection X8/b =>[signal: VNB w=1]]']]
X__66__8 _66__a_1017_47# _66__a_1059_315# VGND no_conn_40 sky130_fd_pr__nfet_01v8 w=420000u l=150000u
** [instance X9 of sky130_fd_pr__pfet_01v8_hvt, params={'w': '1e+06u', 'l': '150000u'} connections=['d: [connection X9/d =>[signal: a_1059_315# w=1]]', 'g: [connection X9/g =>[signal: a_891_413# w=1]]', 's: [connection X9/s =>[signal: VPWR w=1]]', 'b: [connection X9/b =>[signal: VPB w=1]]']]
X__66__9 _66__a_1059_315# _66__a_891_413# VPWR no_conn_41 sky130_fd_pr__pfet_01v8_hvt w=1e+06u l=150000u
** [instance X10 of sky130_fd_pr__pfet_01v8_hvt, params={'w': '1e+06u', 'l': '150000u'} connections=['d: [connection X10/d =>[signal: Q w=1]]', 'g: [connection X10/g =>[signal: a_1059_315# w=1]]', 's: [connection X10/s =>[signal: VPWR w=1]]', 'b: [connection X10/b =>[signal: VPB w=1]]']]
X__66__10 _66_:Q _66__a_1059_315# VPWR no_conn_41 sky130_fd_pr__pfet_01v8_hvt w=1e+06u l=150000u
** [instance X11 of sky130_fd_pr__pfet_01v8_hvt, params={'w': '420000u', 'l': '150000u'} connections=['d: [connection X11/d =>[signal: a_561_413# w=1]]', 'g: [connection X11/g =>[signal: a_634_159# w=1]]', 's: [connection X11/s =>[signal: VPWR w=1]]', 'b: [connection X11/b =>[signal: VPB w=1]]']]
X__66__11 _66__a_561_413# _66__a_634_159# VPWR no_conn_41 sky130_fd_pr__pfet_01v8_hvt w=420000u l=150000u
** [instance X12 of sky130_fd_pr__pfet_01v8_hvt, params={'w': '1e+06u', 'l': '150000u'} connections=['d: [connection X12/d =>[signal: VPWR w=1]]', 'g: [connection X12/g =>[signal: a_1059_315# w=1]]', 's: [connection X12/s =>[signal: Q w=1]]', 'b: [connection X12/b =>[signal: VPB w=1]]']]
X__66__12 VPWR _66__a_1059_315# _66_:Q no_conn_41 sky130_fd_pr__pfet_01v8_hvt w=1e+06u l=150000u
** [instance X13 of sky130_fd_pr__nfet_01v8, params={'w': '360000u', 'l': '150000u'} connections=['d: [connection X13/d =>[signal: a_891_413# w=1]]', 'g: [connection X13/g =>[signal: a_27_47# w=1]]', 's: [connection X13/s =>[signal: a_1017_47# w=1]]', 'b: [connection X13/b =>[signal: VNB w=1]]']]
X__66__13 _66__a_891_413# _66__a_27_47# _66__a_1017_47# no_conn_40 sky130_fd_pr__nfet_01v8 w=360000u l=150000u
** [instance X14 of sky130_fd_pr__nfet_01v8, params={'w': '360000u', 'l': '150000u'} connections=['d: [connection X14/d =>[signal: a_634_159# w=1]]', 'g: [connection X14/g =>[signal: a_193_47# w=1]]', 's: [connection X14/s =>[signal: a_891_413# w=1]]', 'b: [connection X14/b =>[signal: VNB w=1]]']]
X__66__14 _66__a_634_159# _66__a_193_47# _66__a_891_413# no_conn_40 sky130_fd_pr__nfet_01v8 w=360000u l=150000u
** [instance X15 of sky130_fd_pr__nfet_01v8, params={'w': '420000u', 'l': '150000u'} connections=['d: [connection X15/d =>[signal: a_592_47# w=1]]', 'g: [connection X15/g =>[signal: a_634_159# w=1]]', 's: [connection X15/s =>[signal: VGND w=1]]', 'b: [connection X15/b =>[signal: VNB w=1]]']]
X__66__15 _66__a_592_47# _66__a_634_159# VGND no_conn_40 sky130_fd_pr__nfet_01v8 w=420000u l=150000u
** [instance X16 of sky130_fd_pr__nfet_01v8, params={'w': '360000u', 'l': '150000u'} connections=['d: [connection X16/d =>[signal: a_466_413# w=1]]', 'g: [connection X16/g =>[signal: a_193_47# w=1]]', 's: [connection X16/s =>[signal: a_592_47# w=1]]', 'b: [connection X16/b =>[signal: VNB w=1]]']]
X__66__16 _66__a_466_413# _66__a_193_47# _66__a_592_47# no_conn_40 sky130_fd_pr__nfet_01v8 w=360000u l=150000u
** [instance X17 of sky130_fd_pr__nfet_01v8, params={'w': '420000u', 'l': '150000u'} connections=['d: [connection X17/d =>[signal: VGND w=1]]', 'g: [connection X17/g =>[signal: a_27_47# w=1]]', 's: [connection X17/s =>[signal: a_193_47# w=1]]', 'b: [connection X17/b =>[signal: VNB w=1]]']]
X__66__17 VGND _66__a_27_47# _66__a_193_47# no_conn_40 sky130_fd_pr__nfet_01v8 w=420000u l=150000u
** [instance X18 of sky130_fd_pr__nfet_01v8, params={'w': '360000u', 'l': '150000u'} connections=['d: [connection X18/d =>[signal: a_381_47# w=1]]', 'g: [connection X18/g =>[signal: a_27_47# w=1]]', 's: [connection X18/s =>[signal: a_466_413# w=1]]', 'b: [connection X18/b =>[signal: VNB w=1]]']]
X__66__18 _66__a_381_47# _66__a_27_47# _66__a_466_413# no_conn_40 sky130_fd_pr__nfet_01v8 w=360000u l=150000u
** [instance X19 of sky130_fd_pr__nfet_01v8, params={'w': '420000u', 'l': '150000u'} connections=['d: [connection X19/d =>[signal: a_27_47# w=1]]', 'g: [connection X19/g =>[signal: CLK w=1]]', 's: [connection X19/s =>[signal: VGND w=1]]', 'b: [connection X19/b =>[signal: VNB w=1]]']]
X__66__19 _66__a_27_47# _66_:CLK VGND no_conn_40 sky130_fd_pr__nfet_01v8 w=420000u l=150000u
** [instance X20 of sky130_fd_pr__pfet_01v8_hvt, params={'w': '640000u', 'l': '150000u'} connections=['d: [connection X20/d =>[signal: a_27_47# w=1]]', 'g: [connection X20/g =>[signal: CLK w=1]]', 's: [connection X20/s =>[signal: VPWR w=1]]', 'b: [connection X20/b =>[signal: VPB w=1]]']]
X__66__20 _66__a_27_47# _66_:CLK VPWR no_conn_41 sky130_fd_pr__pfet_01v8_hvt w=640000u l=150000u
** [instance X21 of sky130_fd_pr__nfet_01v8, params={'w': '650000u', 'l': '150000u'} connections=['d: [connection X21/d =>[signal: Q w=1]]', 'g: [connection X21/g =>[signal: a_1059_315# w=1]]', 's: [connection X21/s =>[signal: VGND w=1]]', 'b: [connection X21/b =>[signal: VNB w=1]]']]
X__66__21 _66_:Q _66__a_1059_315# VGND no_conn_40 sky130_fd_pr__nfet_01v8 w=650000u l=150000u
** [instance X22 of sky130_fd_pr__pfet_01v8_hvt, params={'w': '640000u', 'l': '150000u'} connections=['d: [connection X22/d =>[signal: VPWR w=1]]', 'g: [connection X22/g =>[signal: a_27_47# w=1]]', 's: [connection X22/s =>[signal: a_193_47# w=1]]', 'b: [connection X22/b =>[signal: VPB w=1]]']]
X__66__22 VPWR _66__a_27_47# _66__a_193_47# no_conn_41 sky130_fd_pr__pfet_01v8_hvt w=640000u l=150000u
** [instance X23 of sky130_fd_pr__nfet_01v8, params={'w': '420000u', 'l': '150000u'} connections=['d: [connection X23/d =>[signal: VGND w=1]]', 'g: [connection X23/g =>[signal: D w=1]]', 's: [connection X23/s =>[signal: a_381_47# w=1]]', 'b: [connection X23/b =>[signal: VNB w=1]]']]
X__66__23 VGND _66_:D _66__a_381_47# no_conn_40 sky130_fd_pr__nfet_01v8 w=420000u l=150000u
** [instance X24 of sky130_fd_pr__pfet_01v8_hvt, params={'w': '420000u', 'l': '150000u'} connections=['d: [connection X24/d =>[signal: a_975_413# w=1]]', 'g: [connection X24/g =>[signal: a_1059_315# w=1]]', 's: [connection X24/s =>[signal: VPWR w=1]]', 'b: [connection X24/b =>[signal: VPB w=1]]']]
X__66__24 _66__a_975_413# _66__a_1059_315# VPWR no_conn_41 sky130_fd_pr__pfet_01v8_hvt w=420000u l=150000u
** [instance X25 of sky130_fd_pr__nfet_01v8, params={'w': '650000u', 'l': '150000u'} connections=['d: [connection X25/d =>[signal: VGND w=1]]', 'g: [connection X25/g =>[signal: a_1059_315# w=1]]', 's: [connection X25/s =>[signal: Q w=1]]', 'b: [connection X25/b =>[signal: VNB w=1]]']]
X__66__25 VGND _66__a_1059_315# _66_:Q no_conn_40 sky130_fd_pr__nfet_01v8 w=650000u l=150000u

** replacing _64_ with the contents of sky130_fd_sc_hd__dfxtp_2
** [instance X0 of sky130_fd_pr__pfet_01v8_hvt, params={'w': '420000u', 'l': '150000u'} connections=['d: [connection X0/d =>[signal: a_891_413# w=1]]', 'g: [connection X0/g =>[signal: a_193_47# w=1]]', 's: [connection X0/s =>[signal: a_975_413# w=1]]', 'b: [connection X0/b =>[signal: VPB w=1]]']]
X__64__0 _64__a_891_413# _64__a_193_47# _64__a_975_413# no_conn_43 sky130_fd_pr__pfet_01v8_hvt w=420000u l=150000u
** [instance X1 of sky130_fd_pr__nfet_01v8, params={'w': '650000u', 'l': '150000u'} connections=['d: [connection X1/d =>[signal: a_1059_315# w=1]]', 'g: [connection X1/g =>[signal: a_891_413# w=1]]', 's: [connection X1/s =>[signal: VGND w=1]]', 'b: [connection X1/b =>[signal: VNB w=1]]']]
X__64__1 _64__a_1059_315# _64__a_891_413# VGND no_conn_42 sky130_fd_pr__nfet_01v8 w=650000u l=150000u
** [instance X2 of sky130_fd_pr__pfet_01v8_hvt, params={'w': '420000u', 'l': '150000u'} connections=['d: [connection X2/d =>[signal: a_466_413# w=1]]', 'g: [connection X2/g =>[signal: a_27_47# w=1]]', 's: [connection X2/s =>[signal: a_561_413# w=1]]', 'b: [connection X2/b =>[signal: VPB w=1]]']]
X__64__2 _64__a_466_413# _64__a_27_47# _64__a_561_413# no_conn_43 sky130_fd_pr__pfet_01v8_hvt w=420000u l=150000u
** [instance X3 of sky130_fd_pr__pfet_01v8_hvt, params={'w': '420000u', 'l': '150000u'} connections=['d: [connection X3/d =>[signal: a_634_159# w=1]]', 'g: [connection X3/g =>[signal: a_27_47# w=1]]', 's: [connection X3/s =>[signal: a_891_413# w=1]]', 'b: [connection X3/b =>[signal: VPB w=1]]']]
X__64__3 _64__a_634_159# _64__a_27_47# _64__a_891_413# no_conn_43 sky130_fd_pr__pfet_01v8_hvt w=420000u l=150000u
** [instance X4 of sky130_fd_pr__pfet_01v8_hvt, params={'w': '420000u', 'l': '150000u'} connections=['d: [connection X4/d =>[signal: a_381_47# w=1]]', 'g: [connection X4/g =>[signal: a_193_47# w=1]]', 's: [connection X4/s =>[signal: a_466_413# w=1]]', 'b: [connection X4/b =>[signal: VPB w=1]]']]
X__64__4 _64__a_381_47# _64__a_193_47# _64__a_466_413# no_conn_43 sky130_fd_pr__pfet_01v8_hvt w=420000u l=150000u
** [instance X5 of sky130_fd_pr__pfet_01v8_hvt, params={'w': '420000u', 'l': '150000u'} connections=['d: [connection X5/d =>[signal: VPWR w=1]]', 'g: [connection X5/g =>[signal: D w=1]]', 's: [connection X5/s =>[signal: a_381_47# w=1]]', 'b: [connection X5/b =>[signal: VPB w=1]]']]
X__64__5 VPWR _64_:D _64__a_381_47# no_conn_43 sky130_fd_pr__pfet_01v8_hvt w=420000u l=150000u
** [instance X6 of sky130_fd_pr__pfet_01v8_hvt, params={'w': '750000u', 'l': '150000u'} connections=['d: [connection X6/d =>[signal: VPWR w=1]]', 'g: [connection X6/g =>[signal: a_466_413# w=1]]', 's: [connection X6/s =>[signal: a_634_159# w=1]]', 'b: [connection X6/b =>[signal: VPB w=1]]']]
X__64__6 VPWR _64__a_466_413# _64__a_634_159# no_conn_43 sky130_fd_pr__pfet_01v8_hvt w=750000u l=150000u
** [instance X7 of sky130_fd_pr__nfet_01v8, params={'w': '640000u', 'l': '150000u'} connections=['d: [connection X7/d =>[signal: VGND w=1]]', 'g: [connection X7/g =>[signal: a_466_413# w=1]]', 's: [connection X7/s =>[signal: a_634_159# w=1]]', 'b: [connection X7/b =>[signal: VNB w=1]]']]
X__64__7 VGND _64__a_466_413# _64__a_634_159# no_conn_42 sky130_fd_pr__nfet_01v8 w=640000u l=150000u
** [instance X8 of sky130_fd_pr__nfet_01v8, params={'w': '420000u', 'l': '150000u'} connections=['d: [connection X8/d =>[signal: a_1017_47# w=1]]', 'g: [connection X8/g =>[signal: a_1059_315# w=1]]', 's: [connection X8/s =>[signal: VGND w=1]]', 'b: [connection X8/b =>[signal: VNB w=1]]']]
X__64__8 _64__a_1017_47# _64__a_1059_315# VGND no_conn_42 sky130_fd_pr__nfet_01v8 w=420000u l=150000u
** [instance X9 of sky130_fd_pr__pfet_01v8_hvt, params={'w': '1e+06u', 'l': '150000u'} connections=['d: [connection X9/d =>[signal: a_1059_315# w=1]]', 'g: [connection X9/g =>[signal: a_891_413# w=1]]', 's: [connection X9/s =>[signal: VPWR w=1]]', 'b: [connection X9/b =>[signal: VPB w=1]]']]
X__64__9 _64__a_1059_315# _64__a_891_413# VPWR no_conn_43 sky130_fd_pr__pfet_01v8_hvt w=1e+06u l=150000u
** [instance X10 of sky130_fd_pr__pfet_01v8_hvt, params={'w': '1e+06u', 'l': '150000u'} connections=['d: [connection X10/d =>[signal: Q w=1]]', 'g: [connection X10/g =>[signal: a_1059_315# w=1]]', 's: [connection X10/s =>[signal: VPWR w=1]]', 'b: [connection X10/b =>[signal: VPB w=1]]']]
X__64__10 _64_:Q _64__a_1059_315# VPWR no_conn_43 sky130_fd_pr__pfet_01v8_hvt w=1e+06u l=150000u
** [instance X11 of sky130_fd_pr__pfet_01v8_hvt, params={'w': '420000u', 'l': '150000u'} connections=['d: [connection X11/d =>[signal: a_561_413# w=1]]', 'g: [connection X11/g =>[signal: a_634_159# w=1]]', 's: [connection X11/s =>[signal: VPWR w=1]]', 'b: [connection X11/b =>[signal: VPB w=1]]']]
X__64__11 _64__a_561_413# _64__a_634_159# VPWR no_conn_43 sky130_fd_pr__pfet_01v8_hvt w=420000u l=150000u
** [instance X12 of sky130_fd_pr__pfet_01v8_hvt, params={'w': '1e+06u', 'l': '150000u'} connections=['d: [connection X12/d =>[signal: VPWR w=1]]', 'g: [connection X12/g =>[signal: a_1059_315# w=1]]', 's: [connection X12/s =>[signal: Q w=1]]', 'b: [connection X12/b =>[signal: VPB w=1]]']]
X__64__12 VPWR _64__a_1059_315# _64_:Q no_conn_43 sky130_fd_pr__pfet_01v8_hvt w=1e+06u l=150000u
** [instance X13 of sky130_fd_pr__nfet_01v8, params={'w': '360000u', 'l': '150000u'} connections=['d: [connection X13/d =>[signal: a_891_413# w=1]]', 'g: [connection X13/g =>[signal: a_27_47# w=1]]', 's: [connection X13/s =>[signal: a_1017_47# w=1]]', 'b: [connection X13/b =>[signal: VNB w=1]]']]
X__64__13 _64__a_891_413# _64__a_27_47# _64__a_1017_47# no_conn_42 sky130_fd_pr__nfet_01v8 w=360000u l=150000u
** [instance X14 of sky130_fd_pr__nfet_01v8, params={'w': '360000u', 'l': '150000u'} connections=['d: [connection X14/d =>[signal: a_634_159# w=1]]', 'g: [connection X14/g =>[signal: a_193_47# w=1]]', 's: [connection X14/s =>[signal: a_891_413# w=1]]', 'b: [connection X14/b =>[signal: VNB w=1]]']]
X__64__14 _64__a_634_159# _64__a_193_47# _64__a_891_413# no_conn_42 sky130_fd_pr__nfet_01v8 w=360000u l=150000u
** [instance X15 of sky130_fd_pr__nfet_01v8, params={'w': '420000u', 'l': '150000u'} connections=['d: [connection X15/d =>[signal: a_592_47# w=1]]', 'g: [connection X15/g =>[signal: a_634_159# w=1]]', 's: [connection X15/s =>[signal: VGND w=1]]', 'b: [connection X15/b =>[signal: VNB w=1]]']]
X__64__15 _64__a_592_47# _64__a_634_159# VGND no_conn_42 sky130_fd_pr__nfet_01v8 w=420000u l=150000u
** [instance X16 of sky130_fd_pr__nfet_01v8, params={'w': '360000u', 'l': '150000u'} connections=['d: [connection X16/d =>[signal: a_466_413# w=1]]', 'g: [connection X16/g =>[signal: a_193_47# w=1]]', 's: [connection X16/s =>[signal: a_592_47# w=1]]', 'b: [connection X16/b =>[signal: VNB w=1]]']]
X__64__16 _64__a_466_413# _64__a_193_47# _64__a_592_47# no_conn_42 sky130_fd_pr__nfet_01v8 w=360000u l=150000u
** [instance X17 of sky130_fd_pr__nfet_01v8, params={'w': '420000u', 'l': '150000u'} connections=['d: [connection X17/d =>[signal: VGND w=1]]', 'g: [connection X17/g =>[signal: a_27_47# w=1]]', 's: [connection X17/s =>[signal: a_193_47# w=1]]', 'b: [connection X17/b =>[signal: VNB w=1]]']]
X__64__17 VGND _64__a_27_47# _64__a_193_47# no_conn_42 sky130_fd_pr__nfet_01v8 w=420000u l=150000u
** [instance X18 of sky130_fd_pr__nfet_01v8, params={'w': '360000u', 'l': '150000u'} connections=['d: [connection X18/d =>[signal: a_381_47# w=1]]', 'g: [connection X18/g =>[signal: a_27_47# w=1]]', 's: [connection X18/s =>[signal: a_466_413# w=1]]', 'b: [connection X18/b =>[signal: VNB w=1]]']]
X__64__18 _64__a_381_47# _64__a_27_47# _64__a_466_413# no_conn_42 sky130_fd_pr__nfet_01v8 w=360000u l=150000u
** [instance X19 of sky130_fd_pr__nfet_01v8, params={'w': '420000u', 'l': '150000u'} connections=['d: [connection X19/d =>[signal: a_27_47# w=1]]', 'g: [connection X19/g =>[signal: CLK w=1]]', 's: [connection X19/s =>[signal: VGND w=1]]', 'b: [connection X19/b =>[signal: VNB w=1]]']]
X__64__19 _64__a_27_47# _64_:CLK VGND no_conn_42 sky130_fd_pr__nfet_01v8 w=420000u l=150000u
** [instance X20 of sky130_fd_pr__pfet_01v8_hvt, params={'w': '640000u', 'l': '150000u'} connections=['d: [connection X20/d =>[signal: a_27_47# w=1]]', 'g: [connection X20/g =>[signal: CLK w=1]]', 's: [connection X20/s =>[signal: VPWR w=1]]', 'b: [connection X20/b =>[signal: VPB w=1]]']]
X__64__20 _64__a_27_47# _64_:CLK VPWR no_conn_43 sky130_fd_pr__pfet_01v8_hvt w=640000u l=150000u
** [instance X21 of sky130_fd_pr__nfet_01v8, params={'w': '650000u', 'l': '150000u'} connections=['d: [connection X21/d =>[signal: Q w=1]]', 'g: [connection X21/g =>[signal: a_1059_315# w=1]]', 's: [connection X21/s =>[signal: VGND w=1]]', 'b: [connection X21/b =>[signal: VNB w=1]]']]
X__64__21 _64_:Q _64__a_1059_315# VGND no_conn_42 sky130_fd_pr__nfet_01v8 w=650000u l=150000u
** [instance X22 of sky130_fd_pr__pfet_01v8_hvt, params={'w': '640000u', 'l': '150000u'} connections=['d: [connection X22/d =>[signal: VPWR w=1]]', 'g: [connection X22/g =>[signal: a_27_47# w=1]]', 's: [connection X22/s =>[signal: a_193_47# w=1]]', 'b: [connection X22/b =>[signal: VPB w=1]]']]
X__64__22 VPWR _64__a_27_47# _64__a_193_47# no_conn_43 sky130_fd_pr__pfet_01v8_hvt w=640000u l=150000u
** [instance X23 of sky130_fd_pr__nfet_01v8, params={'w': '420000u', 'l': '150000u'} connections=['d: [connection X23/d =>[signal: VGND w=1]]', 'g: [connection X23/g =>[signal: D w=1]]', 's: [connection X23/s =>[signal: a_381_47# w=1]]', 'b: [connection X23/b =>[signal: VNB w=1]]']]
X__64__23 VGND _64_:D _64__a_381_47# no_conn_42 sky130_fd_pr__nfet_01v8 w=420000u l=150000u
** [instance X24 of sky130_fd_pr__pfet_01v8_hvt, params={'w': '420000u', 'l': '150000u'} connections=['d: [connection X24/d =>[signal: a_975_413# w=1]]', 'g: [connection X24/g =>[signal: a_1059_315# w=1]]', 's: [connection X24/s =>[signal: VPWR w=1]]', 'b: [connection X24/b =>[signal: VPB w=1]]']]
X__64__24 _64__a_975_413# _64__a_1059_315# VPWR no_conn_43 sky130_fd_pr__pfet_01v8_hvt w=420000u l=150000u
** [instance X25 of sky130_fd_pr__nfet_01v8, params={'w': '650000u', 'l': '150000u'} connections=['d: [connection X25/d =>[signal: VGND w=1]]', 'g: [connection X25/g =>[signal: a_1059_315# w=1]]', 's: [connection X25/s =>[signal: Q w=1]]', 'b: [connection X25/b =>[signal: VNB w=1]]']]
X__64__25 VGND _64__a_1059_315# _64_:Q no_conn_42 sky130_fd_pr__nfet_01v8 w=650000u l=150000u

** replacing _58_ with the contents of sky130_fd_sc_hd__mux2_1
** [instance X0 of sky130_fd_pr__pfet_01v8_hvt, params={'w': '420000u', 'l': '150000u'} connections=['d: [connection X0/d =>[signal: VPWR w=1]]', 'g: [connection X0/g =>[signal: S w=1]]', 's: [connection X0/s =>[signal: a_218_374# w=1]]', 'b: [connection X0/b =>[signal: VPB w=1]]']]
X__58__0 VPWR _58_:S _58__a_218_374# no_conn_45 sky130_fd_pr__pfet_01v8_hvt w=420000u l=150000u
** [instance X1 of sky130_fd_pr__nfet_01v8, params={'w': '420000u', 'l': '150000u'} connections=['d: [connection X1/d =>[signal: a_76_199# w=1]]', 'g: [connection X1/g =>[signal: A0 w=1]]', 's: [connection X1/s =>[signal: a_439_47# w=1]]', 'b: [connection X1/b =>[signal: VNB w=1]]']]
X__58__1 _58__a_76_199# _58_:A0 _58__a_439_47# no_conn_44 sky130_fd_pr__nfet_01v8 w=420000u l=150000u
** [instance X2 of sky130_fd_pr__pfet_01v8_hvt, params={'w': '420000u', 'l': '150000u'} connections=['d: [connection X2/d =>[signal: a_535_374# w=1]]', 'g: [connection X2/g =>[signal: a_505_21# w=1]]', 's: [connection X2/s =>[signal: VPWR w=1]]', 'b: [connection X2/b =>[signal: VPB w=1]]']]
X__58__2 _58__a_535_374# _58__a_505_21# VPWR no_conn_45 sky130_fd_pr__pfet_01v8_hvt w=420000u l=150000u
** [instance X3 of sky130_fd_pr__pfet_01v8_hvt, params={'w': '420000u', 'l': '150000u'} connections=['d: [connection X3/d =>[signal: VPWR w=1]]', 'g: [connection X3/g =>[signal: S w=1]]', 's: [connection X3/s =>[signal: a_505_21# w=1]]', 'b: [connection X3/b =>[signal: VPB w=1]]']]
X__58__3 VPWR _58_:S _58__a_505_21# no_conn_45 sky130_fd_pr__pfet_01v8_hvt w=420000u l=150000u
** [instance X4 of sky130_fd_pr__pfet_01v8_hvt, params={'w': '420000u', 'l': '150000u'} connections=['d: [connection X4/d =>[signal: a_76_199# w=1]]', 'g: [connection X4/g =>[signal: A1 w=1]]', 's: [connection X4/s =>[signal: a_535_374# w=1]]', 'b: [connection X4/b =>[signal: VPB w=1]]']]
X__58__4 _58__a_76_199# _58_:A1 _58__a_535_374# no_conn_45 sky130_fd_pr__pfet_01v8_hvt w=420000u l=150000u
** [instance X5 of sky130_fd_pr__nfet_01v8, params={'w': '420000u', 'l': '150000u'} connections=['d: [connection X5/d =>[signal: a_218_47# w=1]]', 'g: [connection X5/g =>[signal: A1 w=1]]', 's: [connection X5/s =>[signal: a_76_199# w=1]]', 'b: [connection X5/b =>[signal: VNB w=1]]']]
X__58__5 _58__a_218_47# _58_:A1 _58__a_76_199# no_conn_44 sky130_fd_pr__nfet_01v8 w=420000u l=150000u
** [instance X6 of sky130_fd_pr__pfet_01v8_hvt, params={'w': '420000u', 'l': '150000u'} connections=['d: [connection X6/d =>[signal: a_218_374# w=1]]', 'g: [connection X6/g =>[signal: A0 w=1]]', 's: [connection X6/s =>[signal: a_76_199# w=1]]', 'b: [connection X6/b =>[signal: VPB w=1]]']]
X__58__6 _58__a_218_374# _58_:A0 _58__a_76_199# no_conn_45 sky130_fd_pr__pfet_01v8_hvt w=420000u l=150000u
** [instance X7 of sky130_fd_pr__nfet_01v8, params={'w': '650000u', 'l': '150000u'} connections=['d: [connection X7/d =>[signal: X w=1]]', 'g: [connection X7/g =>[signal: a_76_199# w=1]]', 's: [connection X7/s =>[signal: VGND w=1]]', 'b: [connection X7/b =>[signal: VNB w=1]]']]
X__58__7 _58_:X _58__a_76_199# VGND no_conn_44 sky130_fd_pr__nfet_01v8 w=650000u l=150000u
** [instance X8 of sky130_fd_pr__pfet_01v8_hvt, params={'w': '1e+06u', 'l': '150000u'} connections=['d: [connection X8/d =>[signal: X w=1]]', 'g: [connection X8/g =>[signal: a_76_199# w=1]]', 's: [connection X8/s =>[signal: VPWR w=1]]', 'b: [connection X8/b =>[signal: VPB w=1]]']]
X__58__8 _58_:X _58__a_76_199# VPWR no_conn_45 sky130_fd_pr__pfet_01v8_hvt w=1e+06u l=150000u
** [instance X9 of sky130_fd_pr__nfet_01v8, params={'w': '420000u', 'l': '150000u'} connections=['d: [connection X9/d =>[signal: VGND w=1]]', 'g: [connection X9/g =>[signal: S w=1]]', 's: [connection X9/s =>[signal: a_218_47# w=1]]', 'b: [connection X9/b =>[signal: VNB w=1]]']]
X__58__9 VGND _58_:S _58__a_218_47# no_conn_44 sky130_fd_pr__nfet_01v8 w=420000u l=150000u
** [instance X10 of sky130_fd_pr__nfet_01v8, params={'w': '420000u', 'l': '150000u'} connections=['d: [connection X10/d =>[signal: VGND w=1]]', 'g: [connection X10/g =>[signal: S w=1]]', 's: [connection X10/s =>[signal: a_505_21# w=1]]', 'b: [connection X10/b =>[signal: VNB w=1]]']]
X__58__10 VGND _58_:S _58__a_505_21# no_conn_44 sky130_fd_pr__nfet_01v8 w=420000u l=150000u
** [instance X11 of sky130_fd_pr__nfet_01v8, params={'w': '420000u', 'l': '150000u'} connections=['d: [connection X11/d =>[signal: a_439_47# w=1]]', 'g: [connection X11/g =>[signal: a_505_21# w=1]]', 's: [connection X11/s =>[signal: VGND w=1]]', 'b: [connection X11/b =>[signal: VNB w=1]]']]
X__58__11 _58__a_439_47# _58__a_505_21# VGND no_conn_44 sky130_fd_pr__nfet_01v8 w=420000u l=150000u

** replacing _39_ with the contents of sky130_fd_sc_hd__mux2_1
** [instance X0 of sky130_fd_pr__pfet_01v8_hvt, params={'w': '420000u', 'l': '150000u'} connections=['d: [connection X0/d =>[signal: VPWR w=1]]', 'g: [connection X0/g =>[signal: S w=1]]', 's: [connection X0/s =>[signal: a_218_374# w=1]]', 'b: [connection X0/b =>[signal: VPB w=1]]']]
X__39__0 VPWR _39_:S _39__a_218_374# no_conn_47 sky130_fd_pr__pfet_01v8_hvt w=420000u l=150000u
** [instance X1 of sky130_fd_pr__nfet_01v8, params={'w': '420000u', 'l': '150000u'} connections=['d: [connection X1/d =>[signal: a_76_199# w=1]]', 'g: [connection X1/g =>[signal: A0 w=1]]', 's: [connection X1/s =>[signal: a_439_47# w=1]]', 'b: [connection X1/b =>[signal: VNB w=1]]']]
X__39__1 _39__a_76_199# _39_:A0 _39__a_439_47# no_conn_46 sky130_fd_pr__nfet_01v8 w=420000u l=150000u
** [instance X2 of sky130_fd_pr__pfet_01v8_hvt, params={'w': '420000u', 'l': '150000u'} connections=['d: [connection X2/d =>[signal: a_535_374# w=1]]', 'g: [connection X2/g =>[signal: a_505_21# w=1]]', 's: [connection X2/s =>[signal: VPWR w=1]]', 'b: [connection X2/b =>[signal: VPB w=1]]']]
X__39__2 _39__a_535_374# _39__a_505_21# VPWR no_conn_47 sky130_fd_pr__pfet_01v8_hvt w=420000u l=150000u
** [instance X3 of sky130_fd_pr__pfet_01v8_hvt, params={'w': '420000u', 'l': '150000u'} connections=['d: [connection X3/d =>[signal: VPWR w=1]]', 'g: [connection X3/g =>[signal: S w=1]]', 's: [connection X3/s =>[signal: a_505_21# w=1]]', 'b: [connection X3/b =>[signal: VPB w=1]]']]
X__39__3 VPWR _39_:S _39__a_505_21# no_conn_47 sky130_fd_pr__pfet_01v8_hvt w=420000u l=150000u
** [instance X4 of sky130_fd_pr__pfet_01v8_hvt, params={'w': '420000u', 'l': '150000u'} connections=['d: [connection X4/d =>[signal: a_76_199# w=1]]', 'g: [connection X4/g =>[signal: A1 w=1]]', 's: [connection X4/s =>[signal: a_535_374# w=1]]', 'b: [connection X4/b =>[signal: VPB w=1]]']]
X__39__4 _39__a_76_199# _39_:A1 _39__a_535_374# no_conn_47 sky130_fd_pr__pfet_01v8_hvt w=420000u l=150000u
** [instance X5 of sky130_fd_pr__nfet_01v8, params={'w': '420000u', 'l': '150000u'} connections=['d: [connection X5/d =>[signal: a_218_47# w=1]]', 'g: [connection X5/g =>[signal: A1 w=1]]', 's: [connection X5/s =>[signal: a_76_199# w=1]]', 'b: [connection X5/b =>[signal: VNB w=1]]']]
X__39__5 _39__a_218_47# _39_:A1 _39__a_76_199# no_conn_46 sky130_fd_pr__nfet_01v8 w=420000u l=150000u
** [instance X6 of sky130_fd_pr__pfet_01v8_hvt, params={'w': '420000u', 'l': '150000u'} connections=['d: [connection X6/d =>[signal: a_218_374# w=1]]', 'g: [connection X6/g =>[signal: A0 w=1]]', 's: [connection X6/s =>[signal: a_76_199# w=1]]', 'b: [connection X6/b =>[signal: VPB w=1]]']]
X__39__6 _39__a_218_374# _39_:A0 _39__a_76_199# no_conn_47 sky130_fd_pr__pfet_01v8_hvt w=420000u l=150000u
** [instance X7 of sky130_fd_pr__nfet_01v8, params={'w': '650000u', 'l': '150000u'} connections=['d: [connection X7/d =>[signal: X w=1]]', 'g: [connection X7/g =>[signal: a_76_199# w=1]]', 's: [connection X7/s =>[signal: VGND w=1]]', 'b: [connection X7/b =>[signal: VNB w=1]]']]
X__39__7 _39_:X _39__a_76_199# VGND no_conn_46 sky130_fd_pr__nfet_01v8 w=650000u l=150000u
** [instance X8 of sky130_fd_pr__pfet_01v8_hvt, params={'w': '1e+06u', 'l': '150000u'} connections=['d: [connection X8/d =>[signal: X w=1]]', 'g: [connection X8/g =>[signal: a_76_199# w=1]]', 's: [connection X8/s =>[signal: VPWR w=1]]', 'b: [connection X8/b =>[signal: VPB w=1]]']]
X__39__8 _39_:X _39__a_76_199# VPWR no_conn_47 sky130_fd_pr__pfet_01v8_hvt w=1e+06u l=150000u
** [instance X9 of sky130_fd_pr__nfet_01v8, params={'w': '420000u', 'l': '150000u'} connections=['d: [connection X9/d =>[signal: VGND w=1]]', 'g: [connection X9/g =>[signal: S w=1]]', 's: [connection X9/s =>[signal: a_218_47# w=1]]', 'b: [connection X9/b =>[signal: VNB w=1]]']]
X__39__9 VGND _39_:S _39__a_218_47# no_conn_46 sky130_fd_pr__nfet_01v8 w=420000u l=150000u
** [instance X10 of sky130_fd_pr__nfet_01v8, params={'w': '420000u', 'l': '150000u'} connections=['d: [connection X10/d =>[signal: VGND w=1]]', 'g: [connection X10/g =>[signal: S w=1]]', 's: [connection X10/s =>[signal: a_505_21# w=1]]', 'b: [connection X10/b =>[signal: VNB w=1]]']]
X__39__10 VGND _39_:S _39__a_505_21# no_conn_46 sky130_fd_pr__nfet_01v8 w=420000u l=150000u
** [instance X11 of sky130_fd_pr__nfet_01v8, params={'w': '420000u', 'l': '150000u'} connections=['d: [connection X11/d =>[signal: a_439_47# w=1]]', 'g: [connection X11/g =>[signal: a_505_21# w=1]]', 's: [connection X11/s =>[signal: VGND w=1]]', 'b: [connection X11/b =>[signal: VNB w=1]]']]
X__39__11 _39__a_439_47# _39__a_505_21# VGND no_conn_46 sky130_fd_pr__nfet_01v8 w=420000u l=150000u

** replacing _59_ with the contents of sky130_fd_sc_hd__dfxtp_2
** [instance X0 of sky130_fd_pr__pfet_01v8_hvt, params={'w': '420000u', 'l': '150000u'} connections=['d: [connection X0/d =>[signal: a_891_413# w=1]]', 'g: [connection X0/g =>[signal: a_193_47# w=1]]', 's: [connection X0/s =>[signal: a_975_413# w=1]]', 'b: [connection X0/b =>[signal: VPB w=1]]']]
X__59__0 _59__a_891_413# _59__a_193_47# _59__a_975_413# no_conn_49 sky130_fd_pr__pfet_01v8_hvt w=420000u l=150000u
** [instance X1 of sky130_fd_pr__nfet_01v8, params={'w': '650000u', 'l': '150000u'} connections=['d: [connection X1/d =>[signal: a_1059_315# w=1]]', 'g: [connection X1/g =>[signal: a_891_413# w=1]]', 's: [connection X1/s =>[signal: VGND w=1]]', 'b: [connection X1/b =>[signal: VNB w=1]]']]
X__59__1 _59__a_1059_315# _59__a_891_413# VGND no_conn_48 sky130_fd_pr__nfet_01v8 w=650000u l=150000u
** [instance X2 of sky130_fd_pr__pfet_01v8_hvt, params={'w': '420000u', 'l': '150000u'} connections=['d: [connection X2/d =>[signal: a_466_413# w=1]]', 'g: [connection X2/g =>[signal: a_27_47# w=1]]', 's: [connection X2/s =>[signal: a_561_413# w=1]]', 'b: [connection X2/b =>[signal: VPB w=1]]']]
X__59__2 _59__a_466_413# _59__a_27_47# _59__a_561_413# no_conn_49 sky130_fd_pr__pfet_01v8_hvt w=420000u l=150000u
** [instance X3 of sky130_fd_pr__pfet_01v8_hvt, params={'w': '420000u', 'l': '150000u'} connections=['d: [connection X3/d =>[signal: a_634_159# w=1]]', 'g: [connection X3/g =>[signal: a_27_47# w=1]]', 's: [connection X3/s =>[signal: a_891_413# w=1]]', 'b: [connection X3/b =>[signal: VPB w=1]]']]
X__59__3 _59__a_634_159# _59__a_27_47# _59__a_891_413# no_conn_49 sky130_fd_pr__pfet_01v8_hvt w=420000u l=150000u
** [instance X4 of sky130_fd_pr__pfet_01v8_hvt, params={'w': '420000u', 'l': '150000u'} connections=['d: [connection X4/d =>[signal: a_381_47# w=1]]', 'g: [connection X4/g =>[signal: a_193_47# w=1]]', 's: [connection X4/s =>[signal: a_466_413# w=1]]', 'b: [connection X4/b =>[signal: VPB w=1]]']]
X__59__4 _59__a_381_47# _59__a_193_47# _59__a_466_413# no_conn_49 sky130_fd_pr__pfet_01v8_hvt w=420000u l=150000u
** [instance X5 of sky130_fd_pr__pfet_01v8_hvt, params={'w': '420000u', 'l': '150000u'} connections=['d: [connection X5/d =>[signal: VPWR w=1]]', 'g: [connection X5/g =>[signal: D w=1]]', 's: [connection X5/s =>[signal: a_381_47# w=1]]', 'b: [connection X5/b =>[signal: VPB w=1]]']]
X__59__5 VPWR _59_:D _59__a_381_47# no_conn_49 sky130_fd_pr__pfet_01v8_hvt w=420000u l=150000u
** [instance X6 of sky130_fd_pr__pfet_01v8_hvt, params={'w': '750000u', 'l': '150000u'} connections=['d: [connection X6/d =>[signal: VPWR w=1]]', 'g: [connection X6/g =>[signal: a_466_413# w=1]]', 's: [connection X6/s =>[signal: a_634_159# w=1]]', 'b: [connection X6/b =>[signal: VPB w=1]]']]
X__59__6 VPWR _59__a_466_413# _59__a_634_159# no_conn_49 sky130_fd_pr__pfet_01v8_hvt w=750000u l=150000u
** [instance X7 of sky130_fd_pr__nfet_01v8, params={'w': '640000u', 'l': '150000u'} connections=['d: [connection X7/d =>[signal: VGND w=1]]', 'g: [connection X7/g =>[signal: a_466_413# w=1]]', 's: [connection X7/s =>[signal: a_634_159# w=1]]', 'b: [connection X7/b =>[signal: VNB w=1]]']]
X__59__7 VGND _59__a_466_413# _59__a_634_159# no_conn_48 sky130_fd_pr__nfet_01v8 w=640000u l=150000u
** [instance X8 of sky130_fd_pr__nfet_01v8, params={'w': '420000u', 'l': '150000u'} connections=['d: [connection X8/d =>[signal: a_1017_47# w=1]]', 'g: [connection X8/g =>[signal: a_1059_315# w=1]]', 's: [connection X8/s =>[signal: VGND w=1]]', 'b: [connection X8/b =>[signal: VNB w=1]]']]
X__59__8 _59__a_1017_47# _59__a_1059_315# VGND no_conn_48 sky130_fd_pr__nfet_01v8 w=420000u l=150000u
** [instance X9 of sky130_fd_pr__pfet_01v8_hvt, params={'w': '1e+06u', 'l': '150000u'} connections=['d: [connection X9/d =>[signal: a_1059_315# w=1]]', 'g: [connection X9/g =>[signal: a_891_413# w=1]]', 's: [connection X9/s =>[signal: VPWR w=1]]', 'b: [connection X9/b =>[signal: VPB w=1]]']]
X__59__9 _59__a_1059_315# _59__a_891_413# VPWR no_conn_49 sky130_fd_pr__pfet_01v8_hvt w=1e+06u l=150000u
** [instance X10 of sky130_fd_pr__pfet_01v8_hvt, params={'w': '1e+06u', 'l': '150000u'} connections=['d: [connection X10/d =>[signal: Q w=1]]', 'g: [connection X10/g =>[signal: a_1059_315# w=1]]', 's: [connection X10/s =>[signal: VPWR w=1]]', 'b: [connection X10/b =>[signal: VPB w=1]]']]
X__59__10 _59_:Q _59__a_1059_315# VPWR no_conn_49 sky130_fd_pr__pfet_01v8_hvt w=1e+06u l=150000u
** [instance X11 of sky130_fd_pr__pfet_01v8_hvt, params={'w': '420000u', 'l': '150000u'} connections=['d: [connection X11/d =>[signal: a_561_413# w=1]]', 'g: [connection X11/g =>[signal: a_634_159# w=1]]', 's: [connection X11/s =>[signal: VPWR w=1]]', 'b: [connection X11/b =>[signal: VPB w=1]]']]
X__59__11 _59__a_561_413# _59__a_634_159# VPWR no_conn_49 sky130_fd_pr__pfet_01v8_hvt w=420000u l=150000u
** [instance X12 of sky130_fd_pr__pfet_01v8_hvt, params={'w': '1e+06u', 'l': '150000u'} connections=['d: [connection X12/d =>[signal: VPWR w=1]]', 'g: [connection X12/g =>[signal: a_1059_315# w=1]]', 's: [connection X12/s =>[signal: Q w=1]]', 'b: [connection X12/b =>[signal: VPB w=1]]']]
X__59__12 VPWR _59__a_1059_315# _59_:Q no_conn_49 sky130_fd_pr__pfet_01v8_hvt w=1e+06u l=150000u
** [instance X13 of sky130_fd_pr__nfet_01v8, params={'w': '360000u', 'l': '150000u'} connections=['d: [connection X13/d =>[signal: a_891_413# w=1]]', 'g: [connection X13/g =>[signal: a_27_47# w=1]]', 's: [connection X13/s =>[signal: a_1017_47# w=1]]', 'b: [connection X13/b =>[signal: VNB w=1]]']]
X__59__13 _59__a_891_413# _59__a_27_47# _59__a_1017_47# no_conn_48 sky130_fd_pr__nfet_01v8 w=360000u l=150000u
** [instance X14 of sky130_fd_pr__nfet_01v8, params={'w': '360000u', 'l': '150000u'} connections=['d: [connection X14/d =>[signal: a_634_159# w=1]]', 'g: [connection X14/g =>[signal: a_193_47# w=1]]', 's: [connection X14/s =>[signal: a_891_413# w=1]]', 'b: [connection X14/b =>[signal: VNB w=1]]']]
X__59__14 _59__a_634_159# _59__a_193_47# _59__a_891_413# no_conn_48 sky130_fd_pr__nfet_01v8 w=360000u l=150000u
** [instance X15 of sky130_fd_pr__nfet_01v8, params={'w': '420000u', 'l': '150000u'} connections=['d: [connection X15/d =>[signal: a_592_47# w=1]]', 'g: [connection X15/g =>[signal: a_634_159# w=1]]', 's: [connection X15/s =>[signal: VGND w=1]]', 'b: [connection X15/b =>[signal: VNB w=1]]']]
X__59__15 _59__a_592_47# _59__a_634_159# VGND no_conn_48 sky130_fd_pr__nfet_01v8 w=420000u l=150000u
** [instance X16 of sky130_fd_pr__nfet_01v8, params={'w': '360000u', 'l': '150000u'} connections=['d: [connection X16/d =>[signal: a_466_413# w=1]]', 'g: [connection X16/g =>[signal: a_193_47# w=1]]', 's: [connection X16/s =>[signal: a_592_47# w=1]]', 'b: [connection X16/b =>[signal: VNB w=1]]']]
X__59__16 _59__a_466_413# _59__a_193_47# _59__a_592_47# no_conn_48 sky130_fd_pr__nfet_01v8 w=360000u l=150000u
** [instance X17 of sky130_fd_pr__nfet_01v8, params={'w': '420000u', 'l': '150000u'} connections=['d: [connection X17/d =>[signal: VGND w=1]]', 'g: [connection X17/g =>[signal: a_27_47# w=1]]', 's: [connection X17/s =>[signal: a_193_47# w=1]]', 'b: [connection X17/b =>[signal: VNB w=1]]']]
X__59__17 VGND _59__a_27_47# _59__a_193_47# no_conn_48 sky130_fd_pr__nfet_01v8 w=420000u l=150000u
** [instance X18 of sky130_fd_pr__nfet_01v8, params={'w': '360000u', 'l': '150000u'} connections=['d: [connection X18/d =>[signal: a_381_47# w=1]]', 'g: [connection X18/g =>[signal: a_27_47# w=1]]', 's: [connection X18/s =>[signal: a_466_413# w=1]]', 'b: [connection X18/b =>[signal: VNB w=1]]']]
X__59__18 _59__a_381_47# _59__a_27_47# _59__a_466_413# no_conn_48 sky130_fd_pr__nfet_01v8 w=360000u l=150000u
** [instance X19 of sky130_fd_pr__nfet_01v8, params={'w': '420000u', 'l': '150000u'} connections=['d: [connection X19/d =>[signal: a_27_47# w=1]]', 'g: [connection X19/g =>[signal: CLK w=1]]', 's: [connection X19/s =>[signal: VGND w=1]]', 'b: [connection X19/b =>[signal: VNB w=1]]']]
X__59__19 _59__a_27_47# _59_:CLK VGND no_conn_48 sky130_fd_pr__nfet_01v8 w=420000u l=150000u
** [instance X20 of sky130_fd_pr__pfet_01v8_hvt, params={'w': '640000u', 'l': '150000u'} connections=['d: [connection X20/d =>[signal: a_27_47# w=1]]', 'g: [connection X20/g =>[signal: CLK w=1]]', 's: [connection X20/s =>[signal: VPWR w=1]]', 'b: [connection X20/b =>[signal: VPB w=1]]']]
X__59__20 _59__a_27_47# _59_:CLK VPWR no_conn_49 sky130_fd_pr__pfet_01v8_hvt w=640000u l=150000u
** [instance X21 of sky130_fd_pr__nfet_01v8, params={'w': '650000u', 'l': '150000u'} connections=['d: [connection X21/d =>[signal: Q w=1]]', 'g: [connection X21/g =>[signal: a_1059_315# w=1]]', 's: [connection X21/s =>[signal: VGND w=1]]', 'b: [connection X21/b =>[signal: VNB w=1]]']]
X__59__21 _59_:Q _59__a_1059_315# VGND no_conn_48 sky130_fd_pr__nfet_01v8 w=650000u l=150000u
** [instance X22 of sky130_fd_pr__pfet_01v8_hvt, params={'w': '640000u', 'l': '150000u'} connections=['d: [connection X22/d =>[signal: VPWR w=1]]', 'g: [connection X22/g =>[signal: a_27_47# w=1]]', 's: [connection X22/s =>[signal: a_193_47# w=1]]', 'b: [connection X22/b =>[signal: VPB w=1]]']]
X__59__22 VPWR _59__a_27_47# _59__a_193_47# no_conn_49 sky130_fd_pr__pfet_01v8_hvt w=640000u l=150000u
** [instance X23 of sky130_fd_pr__nfet_01v8, params={'w': '420000u', 'l': '150000u'} connections=['d: [connection X23/d =>[signal: VGND w=1]]', 'g: [connection X23/g =>[signal: D w=1]]', 's: [connection X23/s =>[signal: a_381_47# w=1]]', 'b: [connection X23/b =>[signal: VNB w=1]]']]
X__59__23 VGND _59_:D _59__a_381_47# no_conn_48 sky130_fd_pr__nfet_01v8 w=420000u l=150000u
** [instance X24 of sky130_fd_pr__pfet_01v8_hvt, params={'w': '420000u', 'l': '150000u'} connections=['d: [connection X24/d =>[signal: a_975_413# w=1]]', 'g: [connection X24/g =>[signal: a_1059_315# w=1]]', 's: [connection X24/s =>[signal: VPWR w=1]]', 'b: [connection X24/b =>[signal: VPB w=1]]']]
X__59__24 _59__a_975_413# _59__a_1059_315# VPWR no_conn_49 sky130_fd_pr__pfet_01v8_hvt w=420000u l=150000u
** [instance X25 of sky130_fd_pr__nfet_01v8, params={'w': '650000u', 'l': '150000u'} connections=['d: [connection X25/d =>[signal: VGND w=1]]', 'g: [connection X25/g =>[signal: a_1059_315# w=1]]', 's: [connection X25/s =>[signal: Q w=1]]', 'b: [connection X25/b =>[signal: VNB w=1]]']]
X__59__25 VGND _59__a_1059_315# _59_:Q no_conn_48 sky130_fd_pr__nfet_01v8 w=650000u l=150000u

** replacing _41_ with the contents of sky130_fd_sc_hd__mux2_1
** [instance X0 of sky130_fd_pr__pfet_01v8_hvt, params={'w': '420000u', 'l': '150000u'} connections=['d: [connection X0/d =>[signal: VPWR w=1]]', 'g: [connection X0/g =>[signal: S w=1]]', 's: [connection X0/s =>[signal: a_218_374# w=1]]', 'b: [connection X0/b =>[signal: VPB w=1]]']]
X__41__0 VPWR _41_:S _41__a_218_374# no_conn_51 sky130_fd_pr__pfet_01v8_hvt w=420000u l=150000u
** [instance X1 of sky130_fd_pr__nfet_01v8, params={'w': '420000u', 'l': '150000u'} connections=['d: [connection X1/d =>[signal: a_76_199# w=1]]', 'g: [connection X1/g =>[signal: A0 w=1]]', 's: [connection X1/s =>[signal: a_439_47# w=1]]', 'b: [connection X1/b =>[signal: VNB w=1]]']]
X__41__1 _41__a_76_199# _41_:A0 _41__a_439_47# no_conn_50 sky130_fd_pr__nfet_01v8 w=420000u l=150000u
** [instance X2 of sky130_fd_pr__pfet_01v8_hvt, params={'w': '420000u', 'l': '150000u'} connections=['d: [connection X2/d =>[signal: a_535_374# w=1]]', 'g: [connection X2/g =>[signal: a_505_21# w=1]]', 's: [connection X2/s =>[signal: VPWR w=1]]', 'b: [connection X2/b =>[signal: VPB w=1]]']]
X__41__2 _41__a_535_374# _41__a_505_21# VPWR no_conn_51 sky130_fd_pr__pfet_01v8_hvt w=420000u l=150000u
** [instance X3 of sky130_fd_pr__pfet_01v8_hvt, params={'w': '420000u', 'l': '150000u'} connections=['d: [connection X3/d =>[signal: VPWR w=1]]', 'g: [connection X3/g =>[signal: S w=1]]', 's: [connection X3/s =>[signal: a_505_21# w=1]]', 'b: [connection X3/b =>[signal: VPB w=1]]']]
X__41__3 VPWR _41_:S _41__a_505_21# no_conn_51 sky130_fd_pr__pfet_01v8_hvt w=420000u l=150000u
** [instance X4 of sky130_fd_pr__pfet_01v8_hvt, params={'w': '420000u', 'l': '150000u'} connections=['d: [connection X4/d =>[signal: a_76_199# w=1]]', 'g: [connection X4/g =>[signal: A1 w=1]]', 's: [connection X4/s =>[signal: a_535_374# w=1]]', 'b: [connection X4/b =>[signal: VPB w=1]]']]
X__41__4 _41__a_76_199# _41_:A1 _41__a_535_374# no_conn_51 sky130_fd_pr__pfet_01v8_hvt w=420000u l=150000u
** [instance X5 of sky130_fd_pr__nfet_01v8, params={'w': '420000u', 'l': '150000u'} connections=['d: [connection X5/d =>[signal: a_218_47# w=1]]', 'g: [connection X5/g =>[signal: A1 w=1]]', 's: [connection X5/s =>[signal: a_76_199# w=1]]', 'b: [connection X5/b =>[signal: VNB w=1]]']]
X__41__5 _41__a_218_47# _41_:A1 _41__a_76_199# no_conn_50 sky130_fd_pr__nfet_01v8 w=420000u l=150000u
** [instance X6 of sky130_fd_pr__pfet_01v8_hvt, params={'w': '420000u', 'l': '150000u'} connections=['d: [connection X6/d =>[signal: a_218_374# w=1]]', 'g: [connection X6/g =>[signal: A0 w=1]]', 's: [connection X6/s =>[signal: a_76_199# w=1]]', 'b: [connection X6/b =>[signal: VPB w=1]]']]
X__41__6 _41__a_218_374# _41_:A0 _41__a_76_199# no_conn_51 sky130_fd_pr__pfet_01v8_hvt w=420000u l=150000u
** [instance X7 of sky130_fd_pr__nfet_01v8, params={'w': '650000u', 'l': '150000u'} connections=['d: [connection X7/d =>[signal: X w=1]]', 'g: [connection X7/g =>[signal: a_76_199# w=1]]', 's: [connection X7/s =>[signal: VGND w=1]]', 'b: [connection X7/b =>[signal: VNB w=1]]']]
X__41__7 _41_:X _41__a_76_199# VGND no_conn_50 sky130_fd_pr__nfet_01v8 w=650000u l=150000u
** [instance X8 of sky130_fd_pr__pfet_01v8_hvt, params={'w': '1e+06u', 'l': '150000u'} connections=['d: [connection X8/d =>[signal: X w=1]]', 'g: [connection X8/g =>[signal: a_76_199# w=1]]', 's: [connection X8/s =>[signal: VPWR w=1]]', 'b: [connection X8/b =>[signal: VPB w=1]]']]
X__41__8 _41_:X _41__a_76_199# VPWR no_conn_51 sky130_fd_pr__pfet_01v8_hvt w=1e+06u l=150000u
** [instance X9 of sky130_fd_pr__nfet_01v8, params={'w': '420000u', 'l': '150000u'} connections=['d: [connection X9/d =>[signal: VGND w=1]]', 'g: [connection X9/g =>[signal: S w=1]]', 's: [connection X9/s =>[signal: a_218_47# w=1]]', 'b: [connection X9/b =>[signal: VNB w=1]]']]
X__41__9 VGND _41_:S _41__a_218_47# no_conn_50 sky130_fd_pr__nfet_01v8 w=420000u l=150000u
** [instance X10 of sky130_fd_pr__nfet_01v8, params={'w': '420000u', 'l': '150000u'} connections=['d: [connection X10/d =>[signal: VGND w=1]]', 'g: [connection X10/g =>[signal: S w=1]]', 's: [connection X10/s =>[signal: a_505_21# w=1]]', 'b: [connection X10/b =>[signal: VNB w=1]]']]
X__41__10 VGND _41_:S _41__a_505_21# no_conn_50 sky130_fd_pr__nfet_01v8 w=420000u l=150000u
** [instance X11 of sky130_fd_pr__nfet_01v8, params={'w': '420000u', 'l': '150000u'} connections=['d: [connection X11/d =>[signal: a_439_47# w=1]]', 'g: [connection X11/g =>[signal: a_505_21# w=1]]', 's: [connection X11/s =>[signal: VGND w=1]]', 'b: [connection X11/b =>[signal: VNB w=1]]']]
X__41__11 _41__a_439_47# _41__a_505_21# VGND no_conn_50 sky130_fd_pr__nfet_01v8 w=420000u l=150000u

** replacing _33_ with the contents of sky130_fd_sc_hd__mux4_2
** [instance X0 of sky130_fd_pr__pfet_01v8_hvt, params={'w': '640000u', 'l': '150000u'} connections=['d: [connection X0/d =>[signal: VPWR w=1]]', 'g: [connection X0/g =>[signal: A1 w=1]]', 's: [connection X0/s =>[signal: a_1060_369# w=1]]', 'b: [connection X0/b =>[signal: VPB w=1]]']]
X__33__0 VPWR _33_:A1 _33__a_1060_369# no_conn_53 sky130_fd_pr__pfet_01v8_hvt w=640000u l=150000u
** [instance X1 of sky130_fd_pr__nfet_01v8, params={'w': '360000u', 'l': '150000u'} connections=['d: [connection X1/d =>[signal: a_193_47# w=1]]', 'g: [connection X1/g =>[signal: a_27_47# w=1]]', 's: [connection X1/s =>[signal: a_288_47# w=1]]', 'b: [connection X1/b =>[signal: VNB w=1]]']]
X__33__1 _33__a_193_47# _33__a_27_47# _33__a_288_47# no_conn_52 sky130_fd_pr__nfet_01v8 w=360000u l=150000u
** [instance X2 of sky130_fd_pr__pfet_01v8_hvt, params={'w': '1e+06u', 'l': '150000u'} connections=['d: [connection X2/d =>[signal: VPWR w=1]]', 'g: [connection X2/g =>[signal: a_788_316# w=1]]', 's: [connection X2/s =>[signal: X w=1]]', 'b: [connection X2/b =>[signal: VPB w=1]]']]
X__33__2 VPWR _33__a_788_316# _33_:X no_conn_53 sky130_fd_pr__pfet_01v8_hvt w=1e+06u l=150000u
** [instance X3 of sky130_fd_pr__pfet_01v8_hvt, params={'w': '640000u', 'l': '150000u'} connections=['d: [connection X3/d =>[signal: a_1279_413# w=1]]', 'g: [connection X3/g =>[signal: A0 w=1]]', 's: [connection X3/s =>[signal: VPWR w=1]]', 'b: [connection X3/b =>[signal: VPB w=1]]']]
X__33__3 _33__a_1279_413# _33_:A0 VPWR no_conn_53 sky130_fd_pr__pfet_01v8_hvt w=640000u l=150000u
** [instance X4 of sky130_fd_pr__nfet_01v8, params={'w': '650000u', 'l': '150000u'} connections=['d: [connection X4/d =>[signal: VGND w=1]]', 'g: [connection X4/g =>[signal: a_788_316# w=1]]', 's: [connection X4/s =>[signal: X w=1]]', 'b: [connection X4/b =>[signal: VNB w=1]]']]
X__33__4 VGND _33__a_788_316# _33_:X no_conn_52 sky130_fd_pr__nfet_01v8 w=650000u l=150000u
** [instance X5 of sky130_fd_pr__pfet_01v8_hvt, params={'w': '1e+06u', 'l': '150000u'} connections=['d: [connection X5/d =>[signal: X w=1]]', 'g: [connection X5/g =>[signal: a_788_316# w=1]]', 's: [connection X5/s =>[signal: VPWR w=1]]', 'b: [connection X5/b =>[signal: VPB w=1]]']]
X__33__5 _33_:X _33__a_788_316# VPWR no_conn_53 sky130_fd_pr__pfet_01v8_hvt w=1e+06u l=150000u
** [instance X6 of sky130_fd_pr__nfet_01v8, params={'w': '420000u', 'l': '150000u'} connections=['d: [connection X6/d =>[signal: a_288_47# w=1]]', 'g: [connection X6/g =>[signal: S1 w=1]]', 's: [connection X6/s =>[signal: a_788_316# w=1]]', 'b: [connection X6/b =>[signal: VNB w=1]]']]
X__33__6 _33__a_288_47# _33_:S1 _33__a_788_316# no_conn_52 sky130_fd_pr__nfet_01v8 w=420000u l=150000u
** [instance X7 of sky130_fd_pr__pfet_01v8_hvt, params={'w': '420000u', 'l': '150000u'} connections=['d: [connection X7/d =>[signal: a_193_369# w=1]]', 'g: [connection X7/g =>[signal: S0 w=1]]', 's: [connection X7/s =>[signal: a_288_47# w=1]]', 'b: [connection X7/b =>[signal: VPB w=1]]']]
X__33__7 _33__a_193_369# _33_:S0 _33__a_288_47# no_conn_53 sky130_fd_pr__pfet_01v8_hvt w=420000u l=150000u
** [instance X8 of sky130_fd_pr__pfet_01v8_hvt, params={'w': '640000u', 'l': '150000u'} connections=['d: [connection X8/d =>[signal: a_372_413# w=1]]', 'g: [connection X8/g =>[signal: A3 w=1]]', 's: [connection X8/s =>[signal: VPWR w=1]]', 'b: [connection X8/b =>[signal: VPB w=1]]']]
X__33__8 _33__a_372_413# _33_:A3 VPWR no_conn_53 sky130_fd_pr__pfet_01v8_hvt w=640000u l=150000u
** [instance X9 of sky130_fd_pr__nfet_01v8, params={'w': '360000u', 'l': '150000u'} connections=['d: [connection X9/d =>[signal: a_872_316# w=1]]', 'g: [connection X9/g =>[signal: a_27_47# w=1]]', 's: [connection X9/s =>[signal: a_1281_47# w=1]]', 'b: [connection X9/b =>[signal: VNB w=1]]']]
X__33__9 _33__a_872_316# _33__a_27_47# _33__a_1281_47# no_conn_52 sky130_fd_pr__nfet_01v8 w=360000u l=150000u
** [instance X10 of sky130_fd_pr__pfet_01v8_hvt, params={'w': '420000u', 'l': '150000u'} connections=['d: [connection X10/d =>[signal: a_288_47# w=1]]', 'g: [connection X10/g =>[signal: a_27_47# w=1]]', 's: [connection X10/s =>[signal: a_372_413# w=1]]', 'b: [connection X10/b =>[signal: VPB w=1]]']]
X__33__10 _33__a_288_47# _33__a_27_47# _33__a_372_413# no_conn_53 sky130_fd_pr__pfet_01v8_hvt w=420000u l=150000u
** [instance X11 of sky130_fd_pr__nfet_01v8, params={'w': '420000u', 'l': '150000u'} connections=['d: [connection X11/d =>[signal: VGND w=1]]', 'g: [connection X11/g =>[signal: A1 w=1]]', 's: [connection X11/s =>[signal: a_1064_47# w=1]]', 'b: [connection X11/b =>[signal: VNB w=1]]']]
X__33__11 VGND _33_:A1 _33__a_1064_47# no_conn_52 sky130_fd_pr__nfet_01v8 w=420000u l=150000u
** [instance X12 of sky130_fd_pr__pfet_01v8_hvt, params={'w': '640000u', 'l': '150000u'} connections=['d: [connection X12/d =>[signal: VPWR w=1]]', 'g: [connection X12/g =>[signal: S1 w=1]]', 's: [connection X12/s =>[signal: a_600_345# w=1]]', 'b: [connection X12/b =>[signal: VPB w=1]]']]
X__33__12 VPWR _33_:S1 _33__a_600_345# no_conn_53 sky130_fd_pr__pfet_01v8_hvt w=640000u l=150000u
** [instance X13 of sky130_fd_pr__pfet_01v8_hvt, params={'w': '420000u', 'l': '150000u'} connections=['d: [connection X13/d =>[signal: a_872_316# w=1]]', 'g: [connection X13/g =>[signal: S0 w=1]]', 's: [connection X13/s =>[signal: a_1279_413# w=1]]', 'b: [connection X13/b =>[signal: VPB w=1]]']]
X__33__13 _33__a_872_316# _33_:S0 _33__a_1279_413# no_conn_53 sky130_fd_pr__pfet_01v8_hvt w=420000u l=150000u
** [instance X14 of sky130_fd_pr__pfet_01v8_hvt, params={'w': '640000u', 'l': '150000u'} connections=['d: [connection X14/d =>[signal: a_27_47# w=1]]', 'g: [connection X14/g =>[signal: S0 w=1]]', 's: [connection X14/s =>[signal: VPWR w=1]]', 'b: [connection X14/b =>[signal: VPB w=1]]']]
X__33__14 _33__a_27_47# _33_:S0 VPWR no_conn_53 sky130_fd_pr__pfet_01v8_hvt w=640000u l=150000u
** [instance X15 of sky130_fd_pr__pfet_01v8_hvt, params={'w': '640000u', 'l': '150000u'} connections=['d: [connection X15/d =>[signal: VPWR w=1]]', 'g: [connection X15/g =>[signal: A2 w=1]]', 's: [connection X15/s =>[signal: a_193_369# w=1]]', 'b: [connection X15/b =>[signal: VPB w=1]]']]
X__33__15 VPWR _33_:A2 _33__a_193_369# no_conn_53 sky130_fd_pr__pfet_01v8_hvt w=640000u l=150000u
** [instance X16 of sky130_fd_pr__nfet_01v8, params={'w': '420000u', 'l': '150000u'} connections=['d: [connection X16/d =>[signal: VGND w=1]]', 'g: [connection X16/g =>[signal: A2 w=1]]', 's: [connection X16/s =>[signal: a_193_47# w=1]]', 'b: [connection X16/b =>[signal: VNB w=1]]']]
X__33__16 VGND _33_:A2 _33__a_193_47# no_conn_52 sky130_fd_pr__nfet_01v8 w=420000u l=150000u
** [instance X17 of sky130_fd_pr__pfet_01v8_hvt, params={'w': '540000u', 'l': '150000u'} connections=['d: [connection X17/d =>[signal: a_288_47# w=1]]', 'g: [connection X17/g =>[signal: a_600_345# w=1]]', 's: [connection X17/s =>[signal: a_788_316# w=1]]', 'b: [connection X17/b =>[signal: VPB w=1]]']]
X__33__17 _33__a_288_47# _33__a_600_345# _33__a_788_316# no_conn_53 sky130_fd_pr__pfet_01v8_hvt w=540000u l=150000u
** [instance X18 of sky130_fd_pr__nfet_01v8, params={'w': '420000u', 'l': '150000u'} connections=['d: [connection X18/d =>[signal: a_397_47# w=1]]', 'g: [connection X18/g =>[signal: A3 w=1]]', 's: [connection X18/s =>[signal: VGND w=1]]', 'b: [connection X18/b =>[signal: VNB w=1]]']]
X__33__18 _33__a_397_47# _33_:A3 VGND no_conn_52 sky130_fd_pr__nfet_01v8 w=420000u l=150000u
** [instance X19 of sky130_fd_pr__nfet_01v8, params={'w': '420000u', 'l': '150000u'} connections=['d: [connection X19/d =>[signal: a_27_47# w=1]]', 'g: [connection X19/g =>[signal: S0 w=1]]', 's: [connection X19/s =>[signal: VGND w=1]]', 'b: [connection X19/b =>[signal: VNB w=1]]']]
X__33__19 _33__a_27_47# _33_:S0 VGND no_conn_52 sky130_fd_pr__nfet_01v8 w=420000u l=150000u
** [instance X20 of sky130_fd_pr__pfet_01v8_hvt, params={'w': '420000u', 'l': '150000u'} connections=['d: [connection X20/d =>[signal: a_1060_369# w=1]]', 'g: [connection X20/g =>[signal: a_27_47# w=1]]', 's: [connection X20/s =>[signal: a_872_316# w=1]]', 'b: [connection X20/b =>[signal: VPB w=1]]']]
X__33__20 _33__a_1060_369# _33__a_27_47# _33__a_872_316# no_conn_53 sky130_fd_pr__pfet_01v8_hvt w=420000u l=150000u
** [instance X21 of sky130_fd_pr__nfet_01v8, params={'w': '420000u', 'l': '150000u'} connections=['d: [connection X21/d =>[signal: VGND w=1]]', 'g: [connection X21/g =>[signal: S1 w=1]]', 's: [connection X21/s =>[signal: a_600_345# w=1]]', 'b: [connection X21/b =>[signal: VNB w=1]]']]
X__33__21 VGND _33_:S1 _33__a_600_345# no_conn_52 sky130_fd_pr__nfet_01v8 w=420000u l=150000u
** [instance X22 of sky130_fd_pr__nfet_01v8, params={'w': '420000u', 'l': '150000u'} connections=['d: [connection X22/d =>[signal: a_1281_47# w=1]]', 'g: [connection X22/g =>[signal: A0 w=1]]', 's: [connection X22/s =>[signal: VGND w=1]]', 'b: [connection X22/b =>[signal: VNB w=1]]']]
X__33__22 _33__a_1281_47# _33_:A0 VGND no_conn_52 sky130_fd_pr__nfet_01v8 w=420000u l=150000u
** [instance X23 of sky130_fd_pr__nfet_01v8, params={'w': '650000u', 'l': '150000u'} connections=['d: [connection X23/d =>[signal: X w=1]]', 'g: [connection X23/g =>[signal: a_788_316# w=1]]', 's: [connection X23/s =>[signal: VGND w=1]]', 'b: [connection X23/b =>[signal: VNB w=1]]']]
X__33__23 _33_:X _33__a_788_316# VGND no_conn_52 sky130_fd_pr__nfet_01v8 w=650000u l=150000u
** [instance X24 of sky130_fd_pr__nfet_01v8, params={'w': '360000u', 'l': '150000u'} connections=['d: [connection X24/d =>[signal: a_288_47# w=1]]', 'g: [connection X24/g =>[signal: S0 w=1]]', 's: [connection X24/s =>[signal: a_397_47# w=1]]', 'b: [connection X24/b =>[signal: VNB w=1]]']]
X__33__24 _33__a_288_47# _33_:S0 _33__a_397_47# no_conn_52 sky130_fd_pr__nfet_01v8 w=360000u l=150000u
** [instance X25 of sky130_fd_pr__pfet_01v8_hvt, params={'w': '540000u', 'l': '150000u'} connections=['d: [connection X25/d =>[signal: a_788_316# w=1]]', 'g: [connection X25/g =>[signal: S1 w=1]]', 's: [connection X25/s =>[signal: a_872_316# w=1]]', 'b: [connection X25/b =>[signal: VPB w=1]]']]
X__33__25 _33__a_788_316# _33_:S1 _33__a_872_316# no_conn_53 sky130_fd_pr__pfet_01v8_hvt w=540000u l=150000u
** [instance X26 of sky130_fd_pr__nfet_01v8, params={'w': '420000u', 'l': '150000u'} connections=['d: [connection X26/d =>[signal: a_788_316# w=1]]', 'g: [connection X26/g =>[signal: a_600_345# w=1]]', 's: [connection X26/s =>[signal: a_872_316# w=1]]', 'b: [connection X26/b =>[signal: VNB w=1]]']]
X__33__26 _33__a_788_316# _33__a_600_345# _33__a_872_316# no_conn_52 sky130_fd_pr__nfet_01v8 w=420000u l=150000u
** [instance X27 of sky130_fd_pr__nfet_01v8, params={'w': '360000u', 'l': '150000u'} connections=['d: [connection X27/d =>[signal: a_1064_47# w=1]]', 'g: [connection X27/g =>[signal: S0 w=1]]', 's: [connection X27/s =>[signal: a_872_316# w=1]]', 'b: [connection X27/b =>[signal: VNB w=1]]']]
X__33__27 _33__a_1064_47# _33_:S0 _33__a_872_316# no_conn_52 sky130_fd_pr__nfet_01v8 w=360000u l=150000u

** replacing hold17 with the contents of sky130_fd_sc_hd__dlygate4sd3_1
** [instance X0 of sky130_fd_pr__nfet_01v8, params={'w': '420000u', 'l': '500000u'} connections=['d: [connection X0/d =>[signal: a_391_47# w=1]]', 'g: [connection X0/g =>[signal: a_285_47# w=1]]', 's: [connection X0/s =>[signal: VGND w=1]]', 'b: [connection X0/b =>[signal: VNB w=1]]']]
X_hold17_0 hold17_a_391_47# hold17_a_285_47# VGND no_conn_54 sky130_fd_pr__nfet_01v8 w=420000u l=500000u
** [instance X1 of sky130_fd_pr__pfet_01v8_hvt, params={'w': '420000u', 'l': '500000u'} connections=['d: [connection X1/d =>[signal: VPWR w=1]]', 'g: [connection X1/g =>[signal: a_49_47# w=1]]', 's: [connection X1/s =>[signal: a_285_47# w=1]]', 'b: [connection X1/b =>[signal: VPB w=1]]']]
X_hold17_1 VPWR hold17_a_49_47# hold17_a_285_47# no_conn_55 sky130_fd_pr__pfet_01v8_hvt w=420000u l=500000u
** [instance X2 of sky130_fd_pr__nfet_01v8, params={'w': '420000u', 'l': '150000u'} connections=['d: [connection X2/d =>[signal: a_49_47# w=1]]', 'g: [connection X2/g =>[signal: A w=1]]', 's: [connection X2/s =>[signal: VGND w=1]]', 'b: [connection X2/b =>[signal: VNB w=1]]']]
X_hold17_2 hold17_a_49_47# hold17:A VGND no_conn_54 sky130_fd_pr__nfet_01v8 w=420000u l=150000u
** [instance X3 of sky130_fd_pr__pfet_01v8_hvt, params={'w': '1e+06u', 'l': '150000u'} connections=['d: [connection X3/d =>[signal: VPWR w=1]]', 'g: [connection X3/g =>[signal: a_391_47# w=1]]', 's: [connection X3/s =>[signal: X w=1]]', 'b: [connection X3/b =>[signal: VPB w=1]]']]
X_hold17_3 VPWR hold17_a_391_47# hold17:X no_conn_55 sky130_fd_pr__pfet_01v8_hvt w=1e+06u l=150000u
** [instance X4 of sky130_fd_pr__nfet_01v8, params={'w': '650000u', 'l': '150000u'} connections=['d: [connection X4/d =>[signal: VGND w=1]]', 'g: [connection X4/g =>[signal: a_391_47# w=1]]', 's: [connection X4/s =>[signal: X w=1]]', 'b: [connection X4/b =>[signal: VNB w=1]]']]
X_hold17_4 VGND hold17_a_391_47# hold17:X no_conn_54 sky130_fd_pr__nfet_01v8 w=650000u l=150000u
** [instance X5 of sky130_fd_pr__nfet_01v8, params={'w': '420000u', 'l': '500000u'} connections=['d: [connection X5/d =>[signal: VGND w=1]]', 'g: [connection X5/g =>[signal: a_49_47# w=1]]', 's: [connection X5/s =>[signal: a_285_47# w=1]]', 'b: [connection X5/b =>[signal: VNB w=1]]']]
X_hold17_5 VGND hold17_a_49_47# hold17_a_285_47# no_conn_54 sky130_fd_pr__nfet_01v8 w=420000u l=500000u
** [instance X6 of sky130_fd_pr__pfet_01v8_hvt, params={'w': '420000u', 'l': '500000u'} connections=['d: [connection X6/d =>[signal: a_391_47# w=1]]', 'g: [connection X6/g =>[signal: a_285_47# w=1]]', 's: [connection X6/s =>[signal: VPWR w=1]]', 'b: [connection X6/b =>[signal: VPB w=1]]']]
X_hold17_6 hold17_a_391_47# hold17_a_285_47# VPWR no_conn_55 sky130_fd_pr__pfet_01v8_hvt w=420000u l=500000u
** [instance X7 of sky130_fd_pr__pfet_01v8_hvt, params={'w': '420000u', 'l': '150000u'} connections=['d: [connection X7/d =>[signal: a_49_47# w=1]]', 'g: [connection X7/g =>[signal: A w=1]]', 's: [connection X7/s =>[signal: VPWR w=1]]', 'b: [connection X7/b =>[signal: VPB w=1]]']]
X_hold17_7 hold17_a_49_47# hold17:A VPWR no_conn_55 sky130_fd_pr__pfet_01v8_hvt w=420000u l=150000u

** replacing _42_ with the contents of sky130_fd_sc_hd__mux2_1
** [instance X0 of sky130_fd_pr__pfet_01v8_hvt, params={'w': '420000u', 'l': '150000u'} connections=['d: [connection X0/d =>[signal: VPWR w=1]]', 'g: [connection X0/g =>[signal: S w=1]]', 's: [connection X0/s =>[signal: a_218_374# w=1]]', 'b: [connection X0/b =>[signal: VPB w=1]]']]
X__42__0 VPWR _42_:S _42__a_218_374# no_conn_57 sky130_fd_pr__pfet_01v8_hvt w=420000u l=150000u
** [instance X1 of sky130_fd_pr__nfet_01v8, params={'w': '420000u', 'l': '150000u'} connections=['d: [connection X1/d =>[signal: a_76_199# w=1]]', 'g: [connection X1/g =>[signal: A0 w=1]]', 's: [connection X1/s =>[signal: a_439_47# w=1]]', 'b: [connection X1/b =>[signal: VNB w=1]]']]
X__42__1 _42__a_76_199# _42_:A0 _42__a_439_47# no_conn_56 sky130_fd_pr__nfet_01v8 w=420000u l=150000u
** [instance X2 of sky130_fd_pr__pfet_01v8_hvt, params={'w': '420000u', 'l': '150000u'} connections=['d: [connection X2/d =>[signal: a_535_374# w=1]]', 'g: [connection X2/g =>[signal: a_505_21# w=1]]', 's: [connection X2/s =>[signal: VPWR w=1]]', 'b: [connection X2/b =>[signal: VPB w=1]]']]
X__42__2 _42__a_535_374# _42__a_505_21# VPWR no_conn_57 sky130_fd_pr__pfet_01v8_hvt w=420000u l=150000u
** [instance X3 of sky130_fd_pr__pfet_01v8_hvt, params={'w': '420000u', 'l': '150000u'} connections=['d: [connection X3/d =>[signal: VPWR w=1]]', 'g: [connection X3/g =>[signal: S w=1]]', 's: [connection X3/s =>[signal: a_505_21# w=1]]', 'b: [connection X3/b =>[signal: VPB w=1]]']]
X__42__3 VPWR _42_:S _42__a_505_21# no_conn_57 sky130_fd_pr__pfet_01v8_hvt w=420000u l=150000u
** [instance X4 of sky130_fd_pr__pfet_01v8_hvt, params={'w': '420000u', 'l': '150000u'} connections=['d: [connection X4/d =>[signal: a_76_199# w=1]]', 'g: [connection X4/g =>[signal: A1 w=1]]', 's: [connection X4/s =>[signal: a_535_374# w=1]]', 'b: [connection X4/b =>[signal: VPB w=1]]']]
X__42__4 _42__a_76_199# _42_:A1 _42__a_535_374# no_conn_57 sky130_fd_pr__pfet_01v8_hvt w=420000u l=150000u
** [instance X5 of sky130_fd_pr__nfet_01v8, params={'w': '420000u', 'l': '150000u'} connections=['d: [connection X5/d =>[signal: a_218_47# w=1]]', 'g: [connection X5/g =>[signal: A1 w=1]]', 's: [connection X5/s =>[signal: a_76_199# w=1]]', 'b: [connection X5/b =>[signal: VNB w=1]]']]
X__42__5 _42__a_218_47# _42_:A1 _42__a_76_199# no_conn_56 sky130_fd_pr__nfet_01v8 w=420000u l=150000u
** [instance X6 of sky130_fd_pr__pfet_01v8_hvt, params={'w': '420000u', 'l': '150000u'} connections=['d: [connection X6/d =>[signal: a_218_374# w=1]]', 'g: [connection X6/g =>[signal: A0 w=1]]', 's: [connection X6/s =>[signal: a_76_199# w=1]]', 'b: [connection X6/b =>[signal: VPB w=1]]']]
X__42__6 _42__a_218_374# _42_:A0 _42__a_76_199# no_conn_57 sky130_fd_pr__pfet_01v8_hvt w=420000u l=150000u
** [instance X7 of sky130_fd_pr__nfet_01v8, params={'w': '650000u', 'l': '150000u'} connections=['d: [connection X7/d =>[signal: X w=1]]', 'g: [connection X7/g =>[signal: a_76_199# w=1]]', 's: [connection X7/s =>[signal: VGND w=1]]', 'b: [connection X7/b =>[signal: VNB w=1]]']]
X__42__7 _42_:X _42__a_76_199# VGND no_conn_56 sky130_fd_pr__nfet_01v8 w=650000u l=150000u
** [instance X8 of sky130_fd_pr__pfet_01v8_hvt, params={'w': '1e+06u', 'l': '150000u'} connections=['d: [connection X8/d =>[signal: X w=1]]', 'g: [connection X8/g =>[signal: a_76_199# w=1]]', 's: [connection X8/s =>[signal: VPWR w=1]]', 'b: [connection X8/b =>[signal: VPB w=1]]']]
X__42__8 _42_:X _42__a_76_199# VPWR no_conn_57 sky130_fd_pr__pfet_01v8_hvt w=1e+06u l=150000u
** [instance X9 of sky130_fd_pr__nfet_01v8, params={'w': '420000u', 'l': '150000u'} connections=['d: [connection X9/d =>[signal: VGND w=1]]', 'g: [connection X9/g =>[signal: S w=1]]', 's: [connection X9/s =>[signal: a_218_47# w=1]]', 'b: [connection X9/b =>[signal: VNB w=1]]']]
X__42__9 VGND _42_:S _42__a_218_47# no_conn_56 sky130_fd_pr__nfet_01v8 w=420000u l=150000u
** [instance X10 of sky130_fd_pr__nfet_01v8, params={'w': '420000u', 'l': '150000u'} connections=['d: [connection X10/d =>[signal: VGND w=1]]', 'g: [connection X10/g =>[signal: S w=1]]', 's: [connection X10/s =>[signal: a_505_21# w=1]]', 'b: [connection X10/b =>[signal: VNB w=1]]']]
X__42__10 VGND _42_:S _42__a_505_21# no_conn_56 sky130_fd_pr__nfet_01v8 w=420000u l=150000u
** [instance X11 of sky130_fd_pr__nfet_01v8, params={'w': '420000u', 'l': '150000u'} connections=['d: [connection X11/d =>[signal: a_439_47# w=1]]', 'g: [connection X11/g =>[signal: a_505_21# w=1]]', 's: [connection X11/s =>[signal: VGND w=1]]', 'b: [connection X11/b =>[signal: VNB w=1]]']]
X__42__11 _42__a_439_47# _42__a_505_21# VGND no_conn_56 sky130_fd_pr__nfet_01v8 w=420000u l=150000u

** replacing _32_ with the contents of sky130_fd_sc_hd__or2_2
** [instance X0 of sky130_fd_pr__pfet_01v8_hvt, params={'w': '420000u', 'l': '150000u'} connections=['d: [connection X0/d =>[signal: a_39_297# w=1]]', 'g: [connection X0/g =>[signal: B w=1]]', 's: [connection X0/s =>[signal: a_121_297# w=1]]', 'b: [connection X0/b =>[signal: VPB w=1]]']]
X__32__0 _32__a_39_297# _32_:B _32__a_121_297# no_conn_59 sky130_fd_pr__pfet_01v8_hvt w=420000u l=150000u
** [instance X1 of sky130_fd_pr__pfet_01v8_hvt, params={'w': '1e+06u', 'l': '150000u'} connections=['d: [connection X1/d =>[signal: X w=1]]', 'g: [connection X1/g =>[signal: a_39_297# w=1]]', 's: [connection X1/s =>[signal: VPWR w=1]]', 'b: [connection X1/b =>[signal: VPB w=1]]']]
X__32__1 _32_:X _32__a_39_297# VPWR no_conn_59 sky130_fd_pr__pfet_01v8_hvt w=1e+06u l=150000u
** [instance X2 of sky130_fd_pr__nfet_01v8, params={'w': '650000u', 'l': '150000u'} connections=['d: [connection X2/d =>[signal: VGND w=1]]', 'g: [connection X2/g =>[signal: a_39_297# w=1]]', 's: [connection X2/s =>[signal: X w=1]]', 'b: [connection X2/b =>[signal: VNB w=1]]']]
X__32__2 VGND _32__a_39_297# _32_:X no_conn_58 sky130_fd_pr__nfet_01v8 w=650000u l=150000u
** [instance X3 of sky130_fd_pr__pfet_01v8_hvt, params={'w': '1e+06u', 'l': '150000u'} connections=['d: [connection X3/d =>[signal: VPWR w=1]]', 'g: [connection X3/g =>[signal: a_39_297# w=1]]', 's: [connection X3/s =>[signal: X w=1]]', 'b: [connection X3/b =>[signal: VPB w=1]]']]
X__32__3 VPWR _32__a_39_297# _32_:X no_conn_59 sky130_fd_pr__pfet_01v8_hvt w=1e+06u l=150000u
** [instance X4 of sky130_fd_pr__nfet_01v8, params={'w': '420000u', 'l': '150000u'} connections=['d: [connection X4/d =>[signal: a_39_297# w=1]]', 'g: [connection X4/g =>[signal: A w=1]]', 's: [connection X4/s =>[signal: VGND w=1]]', 'b: [connection X4/b =>[signal: VNB w=1]]']]
X__32__4 _32__a_39_297# _32_:A VGND no_conn_58 sky130_fd_pr__nfet_01v8 w=420000u l=150000u
** [instance X5 of sky130_fd_pr__nfet_01v8, params={'w': '420000u', 'l': '150000u'} connections=['d: [connection X5/d =>[signal: VGND w=1]]', 'g: [connection X5/g =>[signal: B w=1]]', 's: [connection X5/s =>[signal: a_39_297# w=1]]', 'b: [connection X5/b =>[signal: VNB w=1]]']]
X__32__5 VGND _32_:B _32__a_39_297# no_conn_58 sky130_fd_pr__nfet_01v8 w=420000u l=150000u
** [instance X6 of sky130_fd_pr__pfet_01v8_hvt, params={'w': '420000u', 'l': '150000u'} connections=['d: [connection X6/d =>[signal: a_121_297# w=1]]', 'g: [connection X6/g =>[signal: A w=1]]', 's: [connection X6/s =>[signal: VPWR w=1]]', 'b: [connection X6/b =>[signal: VPB w=1]]']]
X__32__6 _32__a_121_297# _32_:A VPWR no_conn_59 sky130_fd_pr__pfet_01v8_hvt w=420000u l=150000u
** [instance X7 of sky130_fd_pr__nfet_01v8, params={'w': '650000u', 'l': '150000u'} connections=['d: [connection X7/d =>[signal: X w=1]]', 'g: [connection X7/g =>[signal: a_39_297# w=1]]', 's: [connection X7/s =>[signal: VGND w=1]]', 'b: [connection X7/b =>[signal: VNB w=1]]']]
X__32__7 _32_:X _32__a_39_297# VGND no_conn_58 sky130_fd_pr__nfet_01v8 w=650000u l=150000u

** replacing _43_ with the contents of sky130_fd_sc_hd__mux2_1
** [instance X0 of sky130_fd_pr__pfet_01v8_hvt, params={'w': '420000u', 'l': '150000u'} connections=['d: [connection X0/d =>[signal: VPWR w=1]]', 'g: [connection X0/g =>[signal: S w=1]]', 's: [connection X0/s =>[signal: a_218_374# w=1]]', 'b: [connection X0/b =>[signal: VPB w=1]]']]
X__43__0 VPWR _43_:S _43__a_218_374# no_conn_61 sky130_fd_pr__pfet_01v8_hvt w=420000u l=150000u
** [instance X1 of sky130_fd_pr__nfet_01v8, params={'w': '420000u', 'l': '150000u'} connections=['d: [connection X1/d =>[signal: a_76_199# w=1]]', 'g: [connection X1/g =>[signal: A0 w=1]]', 's: [connection X1/s =>[signal: a_439_47# w=1]]', 'b: [connection X1/b =>[signal: VNB w=1]]']]
X__43__1 _43__a_76_199# _43_:A0 _43__a_439_47# no_conn_60 sky130_fd_pr__nfet_01v8 w=420000u l=150000u
** [instance X2 of sky130_fd_pr__pfet_01v8_hvt, params={'w': '420000u', 'l': '150000u'} connections=['d: [connection X2/d =>[signal: a_535_374# w=1]]', 'g: [connection X2/g =>[signal: a_505_21# w=1]]', 's: [connection X2/s =>[signal: VPWR w=1]]', 'b: [connection X2/b =>[signal: VPB w=1]]']]
X__43__2 _43__a_535_374# _43__a_505_21# VPWR no_conn_61 sky130_fd_pr__pfet_01v8_hvt w=420000u l=150000u
** [instance X3 of sky130_fd_pr__pfet_01v8_hvt, params={'w': '420000u', 'l': '150000u'} connections=['d: [connection X3/d =>[signal: VPWR w=1]]', 'g: [connection X3/g =>[signal: S w=1]]', 's: [connection X3/s =>[signal: a_505_21# w=1]]', 'b: [connection X3/b =>[signal: VPB w=1]]']]
X__43__3 VPWR _43_:S _43__a_505_21# no_conn_61 sky130_fd_pr__pfet_01v8_hvt w=420000u l=150000u
** [instance X4 of sky130_fd_pr__pfet_01v8_hvt, params={'w': '420000u', 'l': '150000u'} connections=['d: [connection X4/d =>[signal: a_76_199# w=1]]', 'g: [connection X4/g =>[signal: A1 w=1]]', 's: [connection X4/s =>[signal: a_535_374# w=1]]', 'b: [connection X4/b =>[signal: VPB w=1]]']]
X__43__4 _43__a_76_199# _43_:A1 _43__a_535_374# no_conn_61 sky130_fd_pr__pfet_01v8_hvt w=420000u l=150000u
** [instance X5 of sky130_fd_pr__nfet_01v8, params={'w': '420000u', 'l': '150000u'} connections=['d: [connection X5/d =>[signal: a_218_47# w=1]]', 'g: [connection X5/g =>[signal: A1 w=1]]', 's: [connection X5/s =>[signal: a_76_199# w=1]]', 'b: [connection X5/b =>[signal: VNB w=1]]']]
X__43__5 _43__a_218_47# _43_:A1 _43__a_76_199# no_conn_60 sky130_fd_pr__nfet_01v8 w=420000u l=150000u
** [instance X6 of sky130_fd_pr__pfet_01v8_hvt, params={'w': '420000u', 'l': '150000u'} connections=['d: [connection X6/d =>[signal: a_218_374# w=1]]', 'g: [connection X6/g =>[signal: A0 w=1]]', 's: [connection X6/s =>[signal: a_76_199# w=1]]', 'b: [connection X6/b =>[signal: VPB w=1]]']]
X__43__6 _43__a_218_374# _43_:A0 _43__a_76_199# no_conn_61 sky130_fd_pr__pfet_01v8_hvt w=420000u l=150000u
** [instance X7 of sky130_fd_pr__nfet_01v8, params={'w': '650000u', 'l': '150000u'} connections=['d: [connection X7/d =>[signal: X w=1]]', 'g: [connection X7/g =>[signal: a_76_199# w=1]]', 's: [connection X7/s =>[signal: VGND w=1]]', 'b: [connection X7/b =>[signal: VNB w=1]]']]
X__43__7 _43_:X _43__a_76_199# VGND no_conn_60 sky130_fd_pr__nfet_01v8 w=650000u l=150000u
** [instance X8 of sky130_fd_pr__pfet_01v8_hvt, params={'w': '1e+06u', 'l': '150000u'} connections=['d: [connection X8/d =>[signal: X w=1]]', 'g: [connection X8/g =>[signal: a_76_199# w=1]]', 's: [connection X8/s =>[signal: VPWR w=1]]', 'b: [connection X8/b =>[signal: VPB w=1]]']]
X__43__8 _43_:X _43__a_76_199# VPWR no_conn_61 sky130_fd_pr__pfet_01v8_hvt w=1e+06u l=150000u
** [instance X9 of sky130_fd_pr__nfet_01v8, params={'w': '420000u', 'l': '150000u'} connections=['d: [connection X9/d =>[signal: VGND w=1]]', 'g: [connection X9/g =>[signal: S w=1]]', 's: [connection X9/s =>[signal: a_218_47# w=1]]', 'b: [connection X9/b =>[signal: VNB w=1]]']]
X__43__9 VGND _43_:S _43__a_218_47# no_conn_60 sky130_fd_pr__nfet_01v8 w=420000u l=150000u
** [instance X10 of sky130_fd_pr__nfet_01v8, params={'w': '420000u', 'l': '150000u'} connections=['d: [connection X10/d =>[signal: VGND w=1]]', 'g: [connection X10/g =>[signal: S w=1]]', 's: [connection X10/s =>[signal: a_505_21# w=1]]', 'b: [connection X10/b =>[signal: VNB w=1]]']]
X__43__10 VGND _43_:S _43__a_505_21# no_conn_60 sky130_fd_pr__nfet_01v8 w=420000u l=150000u
** [instance X11 of sky130_fd_pr__nfet_01v8, params={'w': '420000u', 'l': '150000u'} connections=['d: [connection X11/d =>[signal: a_439_47# w=1]]', 'g: [connection X11/g =>[signal: a_505_21# w=1]]', 's: [connection X11/s =>[signal: VGND w=1]]', 'b: [connection X11/b =>[signal: VNB w=1]]']]
X__43__11 _43__a_439_47# _43__a_505_21# VGND no_conn_60 sky130_fd_pr__nfet_01v8 w=420000u l=150000u

** replacing _60_ with the contents of sky130_fd_sc_hd__dfxtp_2
** [instance X0 of sky130_fd_pr__pfet_01v8_hvt, params={'w': '420000u', 'l': '150000u'} connections=['d: [connection X0/d =>[signal: a_891_413# w=1]]', 'g: [connection X0/g =>[signal: a_193_47# w=1]]', 's: [connection X0/s =>[signal: a_975_413# w=1]]', 'b: [connection X0/b =>[signal: VPB w=1]]']]
X__60__0 _60__a_891_413# _60__a_193_47# _60__a_975_413# no_conn_63 sky130_fd_pr__pfet_01v8_hvt w=420000u l=150000u
** [instance X1 of sky130_fd_pr__nfet_01v8, params={'w': '650000u', 'l': '150000u'} connections=['d: [connection X1/d =>[signal: a_1059_315# w=1]]', 'g: [connection X1/g =>[signal: a_891_413# w=1]]', 's: [connection X1/s =>[signal: VGND w=1]]', 'b: [connection X1/b =>[signal: VNB w=1]]']]
X__60__1 _60__a_1059_315# _60__a_891_413# VGND no_conn_62 sky130_fd_pr__nfet_01v8 w=650000u l=150000u
** [instance X2 of sky130_fd_pr__pfet_01v8_hvt, params={'w': '420000u', 'l': '150000u'} connections=['d: [connection X2/d =>[signal: a_466_413# w=1]]', 'g: [connection X2/g =>[signal: a_27_47# w=1]]', 's: [connection X2/s =>[signal: a_561_413# w=1]]', 'b: [connection X2/b =>[signal: VPB w=1]]']]
X__60__2 _60__a_466_413# _60__a_27_47# _60__a_561_413# no_conn_63 sky130_fd_pr__pfet_01v8_hvt w=420000u l=150000u
** [instance X3 of sky130_fd_pr__pfet_01v8_hvt, params={'w': '420000u', 'l': '150000u'} connections=['d: [connection X3/d =>[signal: a_634_159# w=1]]', 'g: [connection X3/g =>[signal: a_27_47# w=1]]', 's: [connection X3/s =>[signal: a_891_413# w=1]]', 'b: [connection X3/b =>[signal: VPB w=1]]']]
X__60__3 _60__a_634_159# _60__a_27_47# _60__a_891_413# no_conn_63 sky130_fd_pr__pfet_01v8_hvt w=420000u l=150000u
** [instance X4 of sky130_fd_pr__pfet_01v8_hvt, params={'w': '420000u', 'l': '150000u'} connections=['d: [connection X4/d =>[signal: a_381_47# w=1]]', 'g: [connection X4/g =>[signal: a_193_47# w=1]]', 's: [connection X4/s =>[signal: a_466_413# w=1]]', 'b: [connection X4/b =>[signal: VPB w=1]]']]
X__60__4 _60__a_381_47# _60__a_193_47# _60__a_466_413# no_conn_63 sky130_fd_pr__pfet_01v8_hvt w=420000u l=150000u
** [instance X5 of sky130_fd_pr__pfet_01v8_hvt, params={'w': '420000u', 'l': '150000u'} connections=['d: [connection X5/d =>[signal: VPWR w=1]]', 'g: [connection X5/g =>[signal: D w=1]]', 's: [connection X5/s =>[signal: a_381_47# w=1]]', 'b: [connection X5/b =>[signal: VPB w=1]]']]
X__60__5 VPWR _60_:D _60__a_381_47# no_conn_63 sky130_fd_pr__pfet_01v8_hvt w=420000u l=150000u
** [instance X6 of sky130_fd_pr__pfet_01v8_hvt, params={'w': '750000u', 'l': '150000u'} connections=['d: [connection X6/d =>[signal: VPWR w=1]]', 'g: [connection X6/g =>[signal: a_466_413# w=1]]', 's: [connection X6/s =>[signal: a_634_159# w=1]]', 'b: [connection X6/b =>[signal: VPB w=1]]']]
X__60__6 VPWR _60__a_466_413# _60__a_634_159# no_conn_63 sky130_fd_pr__pfet_01v8_hvt w=750000u l=150000u
** [instance X7 of sky130_fd_pr__nfet_01v8, params={'w': '640000u', 'l': '150000u'} connections=['d: [connection X7/d =>[signal: VGND w=1]]', 'g: [connection X7/g =>[signal: a_466_413# w=1]]', 's: [connection X7/s =>[signal: a_634_159# w=1]]', 'b: [connection X7/b =>[signal: VNB w=1]]']]
X__60__7 VGND _60__a_466_413# _60__a_634_159# no_conn_62 sky130_fd_pr__nfet_01v8 w=640000u l=150000u
** [instance X8 of sky130_fd_pr__nfet_01v8, params={'w': '420000u', 'l': '150000u'} connections=['d: [connection X8/d =>[signal: a_1017_47# w=1]]', 'g: [connection X8/g =>[signal: a_1059_315# w=1]]', 's: [connection X8/s =>[signal: VGND w=1]]', 'b: [connection X8/b =>[signal: VNB w=1]]']]
X__60__8 _60__a_1017_47# _60__a_1059_315# VGND no_conn_62 sky130_fd_pr__nfet_01v8 w=420000u l=150000u
** [instance X9 of sky130_fd_pr__pfet_01v8_hvt, params={'w': '1e+06u', 'l': '150000u'} connections=['d: [connection X9/d =>[signal: a_1059_315# w=1]]', 'g: [connection X9/g =>[signal: a_891_413# w=1]]', 's: [connection X9/s =>[signal: VPWR w=1]]', 'b: [connection X9/b =>[signal: VPB w=1]]']]
X__60__9 _60__a_1059_315# _60__a_891_413# VPWR no_conn_63 sky130_fd_pr__pfet_01v8_hvt w=1e+06u l=150000u
** [instance X10 of sky130_fd_pr__pfet_01v8_hvt, params={'w': '1e+06u', 'l': '150000u'} connections=['d: [connection X10/d =>[signal: Q w=1]]', 'g: [connection X10/g =>[signal: a_1059_315# w=1]]', 's: [connection X10/s =>[signal: VPWR w=1]]', 'b: [connection X10/b =>[signal: VPB w=1]]']]
X__60__10 _60_:Q _60__a_1059_315# VPWR no_conn_63 sky130_fd_pr__pfet_01v8_hvt w=1e+06u l=150000u
** [instance X11 of sky130_fd_pr__pfet_01v8_hvt, params={'w': '420000u', 'l': '150000u'} connections=['d: [connection X11/d =>[signal: a_561_413# w=1]]', 'g: [connection X11/g =>[signal: a_634_159# w=1]]', 's: [connection X11/s =>[signal: VPWR w=1]]', 'b: [connection X11/b =>[signal: VPB w=1]]']]
X__60__11 _60__a_561_413# _60__a_634_159# VPWR no_conn_63 sky130_fd_pr__pfet_01v8_hvt w=420000u l=150000u
** [instance X12 of sky130_fd_pr__pfet_01v8_hvt, params={'w': '1e+06u', 'l': '150000u'} connections=['d: [connection X12/d =>[signal: VPWR w=1]]', 'g: [connection X12/g =>[signal: a_1059_315# w=1]]', 's: [connection X12/s =>[signal: Q w=1]]', 'b: [connection X12/b =>[signal: VPB w=1]]']]
X__60__12 VPWR _60__a_1059_315# _60_:Q no_conn_63 sky130_fd_pr__pfet_01v8_hvt w=1e+06u l=150000u
** [instance X13 of sky130_fd_pr__nfet_01v8, params={'w': '360000u', 'l': '150000u'} connections=['d: [connection X13/d =>[signal: a_891_413# w=1]]', 'g: [connection X13/g =>[signal: a_27_47# w=1]]', 's: [connection X13/s =>[signal: a_1017_47# w=1]]', 'b: [connection X13/b =>[signal: VNB w=1]]']]
X__60__13 _60__a_891_413# _60__a_27_47# _60__a_1017_47# no_conn_62 sky130_fd_pr__nfet_01v8 w=360000u l=150000u
** [instance X14 of sky130_fd_pr__nfet_01v8, params={'w': '360000u', 'l': '150000u'} connections=['d: [connection X14/d =>[signal: a_634_159# w=1]]', 'g: [connection X14/g =>[signal: a_193_47# w=1]]', 's: [connection X14/s =>[signal: a_891_413# w=1]]', 'b: [connection X14/b =>[signal: VNB w=1]]']]
X__60__14 _60__a_634_159# _60__a_193_47# _60__a_891_413# no_conn_62 sky130_fd_pr__nfet_01v8 w=360000u l=150000u
** [instance X15 of sky130_fd_pr__nfet_01v8, params={'w': '420000u', 'l': '150000u'} connections=['d: [connection X15/d =>[signal: a_592_47# w=1]]', 'g: [connection X15/g =>[signal: a_634_159# w=1]]', 's: [connection X15/s =>[signal: VGND w=1]]', 'b: [connection X15/b =>[signal: VNB w=1]]']]
X__60__15 _60__a_592_47# _60__a_634_159# VGND no_conn_62 sky130_fd_pr__nfet_01v8 w=420000u l=150000u
** [instance X16 of sky130_fd_pr__nfet_01v8, params={'w': '360000u', 'l': '150000u'} connections=['d: [connection X16/d =>[signal: a_466_413# w=1]]', 'g: [connection X16/g =>[signal: a_193_47# w=1]]', 's: [connection X16/s =>[signal: a_592_47# w=1]]', 'b: [connection X16/b =>[signal: VNB w=1]]']]
X__60__16 _60__a_466_413# _60__a_193_47# _60__a_592_47# no_conn_62 sky130_fd_pr__nfet_01v8 w=360000u l=150000u
** [instance X17 of sky130_fd_pr__nfet_01v8, params={'w': '420000u', 'l': '150000u'} connections=['d: [connection X17/d =>[signal: VGND w=1]]', 'g: [connection X17/g =>[signal: a_27_47# w=1]]', 's: [connection X17/s =>[signal: a_193_47# w=1]]', 'b: [connection X17/b =>[signal: VNB w=1]]']]
X__60__17 VGND _60__a_27_47# _60__a_193_47# no_conn_62 sky130_fd_pr__nfet_01v8 w=420000u l=150000u
** [instance X18 of sky130_fd_pr__nfet_01v8, params={'w': '360000u', 'l': '150000u'} connections=['d: [connection X18/d =>[signal: a_381_47# w=1]]', 'g: [connection X18/g =>[signal: a_27_47# w=1]]', 's: [connection X18/s =>[signal: a_466_413# w=1]]', 'b: [connection X18/b =>[signal: VNB w=1]]']]
X__60__18 _60__a_381_47# _60__a_27_47# _60__a_466_413# no_conn_62 sky130_fd_pr__nfet_01v8 w=360000u l=150000u
** [instance X19 of sky130_fd_pr__nfet_01v8, params={'w': '420000u', 'l': '150000u'} connections=['d: [connection X19/d =>[signal: a_27_47# w=1]]', 'g: [connection X19/g =>[signal: CLK w=1]]', 's: [connection X19/s =>[signal: VGND w=1]]', 'b: [connection X19/b =>[signal: VNB w=1]]']]
X__60__19 _60__a_27_47# _60_:CLK VGND no_conn_62 sky130_fd_pr__nfet_01v8 w=420000u l=150000u
** [instance X20 of sky130_fd_pr__pfet_01v8_hvt, params={'w': '640000u', 'l': '150000u'} connections=['d: [connection X20/d =>[signal: a_27_47# w=1]]', 'g: [connection X20/g =>[signal: CLK w=1]]', 's: [connection X20/s =>[signal: VPWR w=1]]', 'b: [connection X20/b =>[signal: VPB w=1]]']]
X__60__20 _60__a_27_47# _60_:CLK VPWR no_conn_63 sky130_fd_pr__pfet_01v8_hvt w=640000u l=150000u
** [instance X21 of sky130_fd_pr__nfet_01v8, params={'w': '650000u', 'l': '150000u'} connections=['d: [connection X21/d =>[signal: Q w=1]]', 'g: [connection X21/g =>[signal: a_1059_315# w=1]]', 's: [connection X21/s =>[signal: VGND w=1]]', 'b: [connection X21/b =>[signal: VNB w=1]]']]
X__60__21 _60_:Q _60__a_1059_315# VGND no_conn_62 sky130_fd_pr__nfet_01v8 w=650000u l=150000u
** [instance X22 of sky130_fd_pr__pfet_01v8_hvt, params={'w': '640000u', 'l': '150000u'} connections=['d: [connection X22/d =>[signal: VPWR w=1]]', 'g: [connection X22/g =>[signal: a_27_47# w=1]]', 's: [connection X22/s =>[signal: a_193_47# w=1]]', 'b: [connection X22/b =>[signal: VPB w=1]]']]
X__60__22 VPWR _60__a_27_47# _60__a_193_47# no_conn_63 sky130_fd_pr__pfet_01v8_hvt w=640000u l=150000u
** [instance X23 of sky130_fd_pr__nfet_01v8, params={'w': '420000u', 'l': '150000u'} connections=['d: [connection X23/d =>[signal: VGND w=1]]', 'g: [connection X23/g =>[signal: D w=1]]', 's: [connection X23/s =>[signal: a_381_47# w=1]]', 'b: [connection X23/b =>[signal: VNB w=1]]']]
X__60__23 VGND _60_:D _60__a_381_47# no_conn_62 sky130_fd_pr__nfet_01v8 w=420000u l=150000u
** [instance X24 of sky130_fd_pr__pfet_01v8_hvt, params={'w': '420000u', 'l': '150000u'} connections=['d: [connection X24/d =>[signal: a_975_413# w=1]]', 'g: [connection X24/g =>[signal: a_1059_315# w=1]]', 's: [connection X24/s =>[signal: VPWR w=1]]', 'b: [connection X24/b =>[signal: VPB w=1]]']]
X__60__24 _60__a_975_413# _60__a_1059_315# VPWR no_conn_63 sky130_fd_pr__pfet_01v8_hvt w=420000u l=150000u
** [instance X25 of sky130_fd_pr__nfet_01v8, params={'w': '650000u', 'l': '150000u'} connections=['d: [connection X25/d =>[signal: VGND w=1]]', 'g: [connection X25/g =>[signal: a_1059_315# w=1]]', 's: [connection X25/s =>[signal: Q w=1]]', 'b: [connection X25/b =>[signal: VNB w=1]]']]
X__60__25 VGND _60__a_1059_315# _60_:Q no_conn_62 sky130_fd_pr__nfet_01v8 w=650000u l=150000u

** replacing hold21 with the contents of sky130_fd_sc_hd__dlygate4sd3_1
** [instance X0 of sky130_fd_pr__nfet_01v8, params={'w': '420000u', 'l': '500000u'} connections=['d: [connection X0/d =>[signal: a_391_47# w=1]]', 'g: [connection X0/g =>[signal: a_285_47# w=1]]', 's: [connection X0/s =>[signal: VGND w=1]]', 'b: [connection X0/b =>[signal: VNB w=1]]']]
X_hold21_0 hold21_a_391_47# hold21_a_285_47# VGND no_conn_64 sky130_fd_pr__nfet_01v8 w=420000u l=500000u
** [instance X1 of sky130_fd_pr__pfet_01v8_hvt, params={'w': '420000u', 'l': '500000u'} connections=['d: [connection X1/d =>[signal: VPWR w=1]]', 'g: [connection X1/g =>[signal: a_49_47# w=1]]', 's: [connection X1/s =>[signal: a_285_47# w=1]]', 'b: [connection X1/b =>[signal: VPB w=1]]']]
X_hold21_1 VPWR hold21_a_49_47# hold21_a_285_47# no_conn_65 sky130_fd_pr__pfet_01v8_hvt w=420000u l=500000u
** [instance X2 of sky130_fd_pr__nfet_01v8, params={'w': '420000u', 'l': '150000u'} connections=['d: [connection X2/d =>[signal: a_49_47# w=1]]', 'g: [connection X2/g =>[signal: A w=1]]', 's: [connection X2/s =>[signal: VGND w=1]]', 'b: [connection X2/b =>[signal: VNB w=1]]']]
X_hold21_2 hold21_a_49_47# hold21:A VGND no_conn_64 sky130_fd_pr__nfet_01v8 w=420000u l=150000u
** [instance X3 of sky130_fd_pr__pfet_01v8_hvt, params={'w': '1e+06u', 'l': '150000u'} connections=['d: [connection X3/d =>[signal: VPWR w=1]]', 'g: [connection X3/g =>[signal: a_391_47# w=1]]', 's: [connection X3/s =>[signal: X w=1]]', 'b: [connection X3/b =>[signal: VPB w=1]]']]
X_hold21_3 VPWR hold21_a_391_47# hold21:X no_conn_65 sky130_fd_pr__pfet_01v8_hvt w=1e+06u l=150000u
** [instance X4 of sky130_fd_pr__nfet_01v8, params={'w': '650000u', 'l': '150000u'} connections=['d: [connection X4/d =>[signal: VGND w=1]]', 'g: [connection X4/g =>[signal: a_391_47# w=1]]', 's: [connection X4/s =>[signal: X w=1]]', 'b: [connection X4/b =>[signal: VNB w=1]]']]
X_hold21_4 VGND hold21_a_391_47# hold21:X no_conn_64 sky130_fd_pr__nfet_01v8 w=650000u l=150000u
** [instance X5 of sky130_fd_pr__nfet_01v8, params={'w': '420000u', 'l': '500000u'} connections=['d: [connection X5/d =>[signal: VGND w=1]]', 'g: [connection X5/g =>[signal: a_49_47# w=1]]', 's: [connection X5/s =>[signal: a_285_47# w=1]]', 'b: [connection X5/b =>[signal: VNB w=1]]']]
X_hold21_5 VGND hold21_a_49_47# hold21_a_285_47# no_conn_64 sky130_fd_pr__nfet_01v8 w=420000u l=500000u
** [instance X6 of sky130_fd_pr__pfet_01v8_hvt, params={'w': '420000u', 'l': '500000u'} connections=['d: [connection X6/d =>[signal: a_391_47# w=1]]', 'g: [connection X6/g =>[signal: a_285_47# w=1]]', 's: [connection X6/s =>[signal: VPWR w=1]]', 'b: [connection X6/b =>[signal: VPB w=1]]']]
X_hold21_6 hold21_a_391_47# hold21_a_285_47# VPWR no_conn_65 sky130_fd_pr__pfet_01v8_hvt w=420000u l=500000u
** [instance X7 of sky130_fd_pr__pfet_01v8_hvt, params={'w': '420000u', 'l': '150000u'} connections=['d: [connection X7/d =>[signal: a_49_47# w=1]]', 'g: [connection X7/g =>[signal: A w=1]]', 's: [connection X7/s =>[signal: VPWR w=1]]', 'b: [connection X7/b =>[signal: VPB w=1]]']]
X_hold21_7 hold21_a_49_47# hold21:A VPWR no_conn_65 sky130_fd_pr__pfet_01v8_hvt w=420000u l=150000u

** replacing _38_ with the contents of sky130_fd_sc_hd__a22o_2
** [instance X0 of sky130_fd_pr__pfet_01v8_hvt, params={'w': '1e+06u', 'l': '150000u'} connections=['d: [connection X0/d =>[signal: VPWR w=1]]', 'g: [connection X0/g =>[signal: a_27_297# w=1]]', 's: [connection X0/s =>[signal: X w=1]]', 'b: [connection X0/b =>[signal: VPB w=1]]']]
X__38__0 VPWR _38__a_27_297# _38_:X no_conn_67 sky130_fd_pr__pfet_01v8_hvt w=1e+06u l=150000u
** [instance X1 of sky130_fd_pr__pfet_01v8_hvt, params={'w': '1e+06u', 'l': '150000u'} connections=['d: [connection X1/d =>[signal: a_109_297# w=1]]', 'g: [connection X1/g =>[signal: A2 w=1]]', 's: [connection X1/s =>[signal: VPWR w=1]]', 'b: [connection X1/b =>[signal: VPB w=1]]']]
X__38__1 _38__a_109_297# _38_:A2 VPWR no_conn_67 sky130_fd_pr__pfet_01v8_hvt w=1e+06u l=150000u
** [instance X2 of sky130_fd_pr__nfet_01v8, params={'w': '650000u', 'l': '150000u'} connections=['d: [connection X2/d =>[signal: a_109_47# w=1]]', 'g: [connection X2/g =>[signal: B1 w=1]]', 's: [connection X2/s =>[signal: a_27_297# w=1]]', 'b: [connection X2/b =>[signal: VNB w=1]]']]
X__38__2 _38__a_109_47# _38_:B1 _38__a_27_297# no_conn_66 sky130_fd_pr__nfet_01v8 w=650000u l=150000u
** [instance X3 of sky130_fd_pr__pfet_01v8_hvt, params={'w': '1e+06u', 'l': '150000u'} connections=['d: [connection X3/d =>[signal: VPWR w=1]]', 'g: [connection X3/g =>[signal: A1 w=1]]', 's: [connection X3/s =>[signal: a_109_297# w=1]]', 'b: [connection X3/b =>[signal: VPB w=1]]']]
X__38__3 VPWR _38_:A1 _38__a_109_297# no_conn_67 sky130_fd_pr__pfet_01v8_hvt w=1e+06u l=150000u
** [instance X4 of sky130_fd_pr__nfet_01v8, params={'w': '650000u', 'l': '150000u'} connections=['d: [connection X4/d =>[signal: X w=1]]', 'g: [connection X4/g =>[signal: a_27_297# w=1]]', 's: [connection X4/s =>[signal: VGND w=1]]', 'b: [connection X4/b =>[signal: VNB w=1]]']]
X__38__4 _38_:X _38__a_27_297# VGND no_conn_66 sky130_fd_pr__nfet_01v8 w=650000u l=150000u
** [instance X5 of sky130_fd_pr__nfet_01v8, params={'w': '650000u', 'l': '150000u'} connections=['d: [connection X5/d =>[signal: VGND w=1]]', 'g: [connection X5/g =>[signal: a_27_297# w=1]]', 's: [connection X5/s =>[signal: X w=1]]', 'b: [connection X5/b =>[signal: VNB w=1]]']]
X__38__5 VGND _38__a_27_297# _38_:X no_conn_66 sky130_fd_pr__nfet_01v8 w=650000u l=150000u
** [instance X6 of sky130_fd_pr__nfet_01v8, params={'w': '650000u', 'l': '150000u'} connections=['d: [connection X6/d =>[signal: VGND w=1]]', 'g: [connection X6/g =>[signal: B2 w=1]]', 's: [connection X6/s =>[signal: a_109_47# w=1]]', 'b: [connection X6/b =>[signal: VNB w=1]]']]
X__38__6 VGND _38_:B2 _38__a_109_47# no_conn_66 sky130_fd_pr__nfet_01v8 w=650000u l=150000u
** [instance X7 of sky130_fd_pr__pfet_01v8_hvt, params={'w': '1e+06u', 'l': '150000u'} connections=['d: [connection X7/d =>[signal: a_27_297# w=1]]', 'g: [connection X7/g =>[signal: B2 w=1]]', 's: [connection X7/s =>[signal: a_109_297# w=1]]', 'b: [connection X7/b =>[signal: VPB w=1]]']]
X__38__7 _38__a_27_297# _38_:B2 _38__a_109_297# no_conn_67 sky130_fd_pr__pfet_01v8_hvt w=1e+06u l=150000u
** [instance X8 of sky130_fd_pr__nfet_01v8, params={'w': '650000u', 'l': '150000u'} connections=['d: [connection X8/d =>[signal: a_27_297# w=1]]', 'g: [connection X8/g =>[signal: A1 w=1]]', 's: [connection X8/s =>[signal: a_381_47# w=1]]', 'b: [connection X8/b =>[signal: VNB w=1]]']]
X__38__8 _38__a_27_297# _38_:A1 _38__a_381_47# no_conn_66 sky130_fd_pr__nfet_01v8 w=650000u l=150000u
** [instance X9 of sky130_fd_pr__pfet_01v8_hvt, params={'w': '1e+06u', 'l': '150000u'} connections=['d: [connection X9/d =>[signal: a_109_297# w=1]]', 'g: [connection X9/g =>[signal: B1 w=1]]', 's: [connection X9/s =>[signal: a_27_297# w=1]]', 'b: [connection X9/b =>[signal: VPB w=1]]']]
X__38__9 _38__a_109_297# _38_:B1 _38__a_27_297# no_conn_67 sky130_fd_pr__pfet_01v8_hvt w=1e+06u l=150000u
** [instance X10 of sky130_fd_pr__nfet_01v8, params={'w': '650000u', 'l': '150000u'} connections=['d: [connection X10/d =>[signal: a_381_47# w=1]]', 'g: [connection X10/g =>[signal: A2 w=1]]', 's: [connection X10/s =>[signal: VGND w=1]]', 'b: [connection X10/b =>[signal: VNB w=1]]']]
X__38__10 _38__a_381_47# _38_:A2 VGND no_conn_66 sky130_fd_pr__nfet_01v8 w=650000u l=150000u
** [instance X11 of sky130_fd_pr__pfet_01v8_hvt, params={'w': '1e+06u', 'l': '150000u'} connections=['d: [connection X11/d =>[signal: X w=1]]', 'g: [connection X11/g =>[signal: a_27_297# w=1]]', 's: [connection X11/s =>[signal: VPWR w=1]]', 'b: [connection X11/b =>[signal: VPB w=1]]']]
X__38__11 _38_:X _38__a_27_297# VPWR no_conn_67 sky130_fd_pr__pfet_01v8_hvt w=1e+06u l=150000u

** replacing _44_ with the contents of sky130_fd_sc_hd__mux2_1
** [instance X0 of sky130_fd_pr__pfet_01v8_hvt, params={'w': '420000u', 'l': '150000u'} connections=['d: [connection X0/d =>[signal: VPWR w=1]]', 'g: [connection X0/g =>[signal: S w=1]]', 's: [connection X0/s =>[signal: a_218_374# w=1]]', 'b: [connection X0/b =>[signal: VPB w=1]]']]
X__44__0 VPWR _44_:S _44__a_218_374# no_conn_69 sky130_fd_pr__pfet_01v8_hvt w=420000u l=150000u
** [instance X1 of sky130_fd_pr__nfet_01v8, params={'w': '420000u', 'l': '150000u'} connections=['d: [connection X1/d =>[signal: a_76_199# w=1]]', 'g: [connection X1/g =>[signal: A0 w=1]]', 's: [connection X1/s =>[signal: a_439_47# w=1]]', 'b: [connection X1/b =>[signal: VNB w=1]]']]
X__44__1 _44__a_76_199# _44_:A0 _44__a_439_47# no_conn_68 sky130_fd_pr__nfet_01v8 w=420000u l=150000u
** [instance X2 of sky130_fd_pr__pfet_01v8_hvt, params={'w': '420000u', 'l': '150000u'} connections=['d: [connection X2/d =>[signal: a_535_374# w=1]]', 'g: [connection X2/g =>[signal: a_505_21# w=1]]', 's: [connection X2/s =>[signal: VPWR w=1]]', 'b: [connection X2/b =>[signal: VPB w=1]]']]
X__44__2 _44__a_535_374# _44__a_505_21# VPWR no_conn_69 sky130_fd_pr__pfet_01v8_hvt w=420000u l=150000u
** [instance X3 of sky130_fd_pr__pfet_01v8_hvt, params={'w': '420000u', 'l': '150000u'} connections=['d: [connection X3/d =>[signal: VPWR w=1]]', 'g: [connection X3/g =>[signal: S w=1]]', 's: [connection X3/s =>[signal: a_505_21# w=1]]', 'b: [connection X3/b =>[signal: VPB w=1]]']]
X__44__3 VPWR _44_:S _44__a_505_21# no_conn_69 sky130_fd_pr__pfet_01v8_hvt w=420000u l=150000u
** [instance X4 of sky130_fd_pr__pfet_01v8_hvt, params={'w': '420000u', 'l': '150000u'} connections=['d: [connection X4/d =>[signal: a_76_199# w=1]]', 'g: [connection X4/g =>[signal: A1 w=1]]', 's: [connection X4/s =>[signal: a_535_374# w=1]]', 'b: [connection X4/b =>[signal: VPB w=1]]']]
X__44__4 _44__a_76_199# _44_:A1 _44__a_535_374# no_conn_69 sky130_fd_pr__pfet_01v8_hvt w=420000u l=150000u
** [instance X5 of sky130_fd_pr__nfet_01v8, params={'w': '420000u', 'l': '150000u'} connections=['d: [connection X5/d =>[signal: a_218_47# w=1]]', 'g: [connection X5/g =>[signal: A1 w=1]]', 's: [connection X5/s =>[signal: a_76_199# w=1]]', 'b: [connection X5/b =>[signal: VNB w=1]]']]
X__44__5 _44__a_218_47# _44_:A1 _44__a_76_199# no_conn_68 sky130_fd_pr__nfet_01v8 w=420000u l=150000u
** [instance X6 of sky130_fd_pr__pfet_01v8_hvt, params={'w': '420000u', 'l': '150000u'} connections=['d: [connection X6/d =>[signal: a_218_374# w=1]]', 'g: [connection X6/g =>[signal: A0 w=1]]', 's: [connection X6/s =>[signal: a_76_199# w=1]]', 'b: [connection X6/b =>[signal: VPB w=1]]']]
X__44__6 _44__a_218_374# _44_:A0 _44__a_76_199# no_conn_69 sky130_fd_pr__pfet_01v8_hvt w=420000u l=150000u
** [instance X7 of sky130_fd_pr__nfet_01v8, params={'w': '650000u', 'l': '150000u'} connections=['d: [connection X7/d =>[signal: X w=1]]', 'g: [connection X7/g =>[signal: a_76_199# w=1]]', 's: [connection X7/s =>[signal: VGND w=1]]', 'b: [connection X7/b =>[signal: VNB w=1]]']]
X__44__7 _44_:X _44__a_76_199# VGND no_conn_68 sky130_fd_pr__nfet_01v8 w=650000u l=150000u
** [instance X8 of sky130_fd_pr__pfet_01v8_hvt, params={'w': '1e+06u', 'l': '150000u'} connections=['d: [connection X8/d =>[signal: X w=1]]', 'g: [connection X8/g =>[signal: a_76_199# w=1]]', 's: [connection X8/s =>[signal: VPWR w=1]]', 'b: [connection X8/b =>[signal: VPB w=1]]']]
X__44__8 _44_:X _44__a_76_199# VPWR no_conn_69 sky130_fd_pr__pfet_01v8_hvt w=1e+06u l=150000u
** [instance X9 of sky130_fd_pr__nfet_01v8, params={'w': '420000u', 'l': '150000u'} connections=['d: [connection X9/d =>[signal: VGND w=1]]', 'g: [connection X9/g =>[signal: S w=1]]', 's: [connection X9/s =>[signal: a_218_47# w=1]]', 'b: [connection X9/b =>[signal: VNB w=1]]']]
X__44__9 VGND _44_:S _44__a_218_47# no_conn_68 sky130_fd_pr__nfet_01v8 w=420000u l=150000u
** [instance X10 of sky130_fd_pr__nfet_01v8, params={'w': '420000u', 'l': '150000u'} connections=['d: [connection X10/d =>[signal: VGND w=1]]', 'g: [connection X10/g =>[signal: S w=1]]', 's: [connection X10/s =>[signal: a_505_21# w=1]]', 'b: [connection X10/b =>[signal: VNB w=1]]']]
X__44__10 VGND _44_:S _44__a_505_21# no_conn_68 sky130_fd_pr__nfet_01v8 w=420000u l=150000u
** [instance X11 of sky130_fd_pr__nfet_01v8, params={'w': '420000u', 'l': '150000u'} connections=['d: [connection X11/d =>[signal: a_439_47# w=1]]', 'g: [connection X11/g =>[signal: a_505_21# w=1]]', 's: [connection X11/s =>[signal: VGND w=1]]', 'b: [connection X11/b =>[signal: VNB w=1]]']]
X__44__11 _44__a_439_47# _44__a_505_21# VGND no_conn_68 sky130_fd_pr__nfet_01v8 w=420000u l=150000u

** replacing _61_ with the contents of sky130_fd_sc_hd__dfxtp_2
** [instance X0 of sky130_fd_pr__pfet_01v8_hvt, params={'w': '420000u', 'l': '150000u'} connections=['d: [connection X0/d =>[signal: a_891_413# w=1]]', 'g: [connection X0/g =>[signal: a_193_47# w=1]]', 's: [connection X0/s =>[signal: a_975_413# w=1]]', 'b: [connection X0/b =>[signal: VPB w=1]]']]
X__61__0 _61__a_891_413# _61__a_193_47# _61__a_975_413# no_conn_71 sky130_fd_pr__pfet_01v8_hvt w=420000u l=150000u
** [instance X1 of sky130_fd_pr__nfet_01v8, params={'w': '650000u', 'l': '150000u'} connections=['d: [connection X1/d =>[signal: a_1059_315# w=1]]', 'g: [connection X1/g =>[signal: a_891_413# w=1]]', 's: [connection X1/s =>[signal: VGND w=1]]', 'b: [connection X1/b =>[signal: VNB w=1]]']]
X__61__1 _61__a_1059_315# _61__a_891_413# VGND no_conn_70 sky130_fd_pr__nfet_01v8 w=650000u l=150000u
** [instance X2 of sky130_fd_pr__pfet_01v8_hvt, params={'w': '420000u', 'l': '150000u'} connections=['d: [connection X2/d =>[signal: a_466_413# w=1]]', 'g: [connection X2/g =>[signal: a_27_47# w=1]]', 's: [connection X2/s =>[signal: a_561_413# w=1]]', 'b: [connection X2/b =>[signal: VPB w=1]]']]
X__61__2 _61__a_466_413# _61__a_27_47# _61__a_561_413# no_conn_71 sky130_fd_pr__pfet_01v8_hvt w=420000u l=150000u
** [instance X3 of sky130_fd_pr__pfet_01v8_hvt, params={'w': '420000u', 'l': '150000u'} connections=['d: [connection X3/d =>[signal: a_634_159# w=1]]', 'g: [connection X3/g =>[signal: a_27_47# w=1]]', 's: [connection X3/s =>[signal: a_891_413# w=1]]', 'b: [connection X3/b =>[signal: VPB w=1]]']]
X__61__3 _61__a_634_159# _61__a_27_47# _61__a_891_413# no_conn_71 sky130_fd_pr__pfet_01v8_hvt w=420000u l=150000u
** [instance X4 of sky130_fd_pr__pfet_01v8_hvt, params={'w': '420000u', 'l': '150000u'} connections=['d: [connection X4/d =>[signal: a_381_47# w=1]]', 'g: [connection X4/g =>[signal: a_193_47# w=1]]', 's: [connection X4/s =>[signal: a_466_413# w=1]]', 'b: [connection X4/b =>[signal: VPB w=1]]']]
X__61__4 _61__a_381_47# _61__a_193_47# _61__a_466_413# no_conn_71 sky130_fd_pr__pfet_01v8_hvt w=420000u l=150000u
** [instance X5 of sky130_fd_pr__pfet_01v8_hvt, params={'w': '420000u', 'l': '150000u'} connections=['d: [connection X5/d =>[signal: VPWR w=1]]', 'g: [connection X5/g =>[signal: D w=1]]', 's: [connection X5/s =>[signal: a_381_47# w=1]]', 'b: [connection X5/b =>[signal: VPB w=1]]']]
X__61__5 VPWR _61_:D _61__a_381_47# no_conn_71 sky130_fd_pr__pfet_01v8_hvt w=420000u l=150000u
** [instance X6 of sky130_fd_pr__pfet_01v8_hvt, params={'w': '750000u', 'l': '150000u'} connections=['d: [connection X6/d =>[signal: VPWR w=1]]', 'g: [connection X6/g =>[signal: a_466_413# w=1]]', 's: [connection X6/s =>[signal: a_634_159# w=1]]', 'b: [connection X6/b =>[signal: VPB w=1]]']]
X__61__6 VPWR _61__a_466_413# _61__a_634_159# no_conn_71 sky130_fd_pr__pfet_01v8_hvt w=750000u l=150000u
** [instance X7 of sky130_fd_pr__nfet_01v8, params={'w': '640000u', 'l': '150000u'} connections=['d: [connection X7/d =>[signal: VGND w=1]]', 'g: [connection X7/g =>[signal: a_466_413# w=1]]', 's: [connection X7/s =>[signal: a_634_159# w=1]]', 'b: [connection X7/b =>[signal: VNB w=1]]']]
X__61__7 VGND _61__a_466_413# _61__a_634_159# no_conn_70 sky130_fd_pr__nfet_01v8 w=640000u l=150000u
** [instance X8 of sky130_fd_pr__nfet_01v8, params={'w': '420000u', 'l': '150000u'} connections=['d: [connection X8/d =>[signal: a_1017_47# w=1]]', 'g: [connection X8/g =>[signal: a_1059_315# w=1]]', 's: [connection X8/s =>[signal: VGND w=1]]', 'b: [connection X8/b =>[signal: VNB w=1]]']]
X__61__8 _61__a_1017_47# _61__a_1059_315# VGND no_conn_70 sky130_fd_pr__nfet_01v8 w=420000u l=150000u
** [instance X9 of sky130_fd_pr__pfet_01v8_hvt, params={'w': '1e+06u', 'l': '150000u'} connections=['d: [connection X9/d =>[signal: a_1059_315# w=1]]', 'g: [connection X9/g =>[signal: a_891_413# w=1]]', 's: [connection X9/s =>[signal: VPWR w=1]]', 'b: [connection X9/b =>[signal: VPB w=1]]']]
X__61__9 _61__a_1059_315# _61__a_891_413# VPWR no_conn_71 sky130_fd_pr__pfet_01v8_hvt w=1e+06u l=150000u
** [instance X10 of sky130_fd_pr__pfet_01v8_hvt, params={'w': '1e+06u', 'l': '150000u'} connections=['d: [connection X10/d =>[signal: Q w=1]]', 'g: [connection X10/g =>[signal: a_1059_315# w=1]]', 's: [connection X10/s =>[signal: VPWR w=1]]', 'b: [connection X10/b =>[signal: VPB w=1]]']]
X__61__10 _61_:Q _61__a_1059_315# VPWR no_conn_71 sky130_fd_pr__pfet_01v8_hvt w=1e+06u l=150000u
** [instance X11 of sky130_fd_pr__pfet_01v8_hvt, params={'w': '420000u', 'l': '150000u'} connections=['d: [connection X11/d =>[signal: a_561_413# w=1]]', 'g: [connection X11/g =>[signal: a_634_159# w=1]]', 's: [connection X11/s =>[signal: VPWR w=1]]', 'b: [connection X11/b =>[signal: VPB w=1]]']]
X__61__11 _61__a_561_413# _61__a_634_159# VPWR no_conn_71 sky130_fd_pr__pfet_01v8_hvt w=420000u l=150000u
** [instance X12 of sky130_fd_pr__pfet_01v8_hvt, params={'w': '1e+06u', 'l': '150000u'} connections=['d: [connection X12/d =>[signal: VPWR w=1]]', 'g: [connection X12/g =>[signal: a_1059_315# w=1]]', 's: [connection X12/s =>[signal: Q w=1]]', 'b: [connection X12/b =>[signal: VPB w=1]]']]
X__61__12 VPWR _61__a_1059_315# _61_:Q no_conn_71 sky130_fd_pr__pfet_01v8_hvt w=1e+06u l=150000u
** [instance X13 of sky130_fd_pr__nfet_01v8, params={'w': '360000u', 'l': '150000u'} connections=['d: [connection X13/d =>[signal: a_891_413# w=1]]', 'g: [connection X13/g =>[signal: a_27_47# w=1]]', 's: [connection X13/s =>[signal: a_1017_47# w=1]]', 'b: [connection X13/b =>[signal: VNB w=1]]']]
X__61__13 _61__a_891_413# _61__a_27_47# _61__a_1017_47# no_conn_70 sky130_fd_pr__nfet_01v8 w=360000u l=150000u
** [instance X14 of sky130_fd_pr__nfet_01v8, params={'w': '360000u', 'l': '150000u'} connections=['d: [connection X14/d =>[signal: a_634_159# w=1]]', 'g: [connection X14/g =>[signal: a_193_47# w=1]]', 's: [connection X14/s =>[signal: a_891_413# w=1]]', 'b: [connection X14/b =>[signal: VNB w=1]]']]
X__61__14 _61__a_634_159# _61__a_193_47# _61__a_891_413# no_conn_70 sky130_fd_pr__nfet_01v8 w=360000u l=150000u
** [instance X15 of sky130_fd_pr__nfet_01v8, params={'w': '420000u', 'l': '150000u'} connections=['d: [connection X15/d =>[signal: a_592_47# w=1]]', 'g: [connection X15/g =>[signal: a_634_159# w=1]]', 's: [connection X15/s =>[signal: VGND w=1]]', 'b: [connection X15/b =>[signal: VNB w=1]]']]
X__61__15 _61__a_592_47# _61__a_634_159# VGND no_conn_70 sky130_fd_pr__nfet_01v8 w=420000u l=150000u
** [instance X16 of sky130_fd_pr__nfet_01v8, params={'w': '360000u', 'l': '150000u'} connections=['d: [connection X16/d =>[signal: a_466_413# w=1]]', 'g: [connection X16/g =>[signal: a_193_47# w=1]]', 's: [connection X16/s =>[signal: a_592_47# w=1]]', 'b: [connection X16/b =>[signal: VNB w=1]]']]
X__61__16 _61__a_466_413# _61__a_193_47# _61__a_592_47# no_conn_70 sky130_fd_pr__nfet_01v8 w=360000u l=150000u
** [instance X17 of sky130_fd_pr__nfet_01v8, params={'w': '420000u', 'l': '150000u'} connections=['d: [connection X17/d =>[signal: VGND w=1]]', 'g: [connection X17/g =>[signal: a_27_47# w=1]]', 's: [connection X17/s =>[signal: a_193_47# w=1]]', 'b: [connection X17/b =>[signal: VNB w=1]]']]
X__61__17 VGND _61__a_27_47# _61__a_193_47# no_conn_70 sky130_fd_pr__nfet_01v8 w=420000u l=150000u
** [instance X18 of sky130_fd_pr__nfet_01v8, params={'w': '360000u', 'l': '150000u'} connections=['d: [connection X18/d =>[signal: a_381_47# w=1]]', 'g: [connection X18/g =>[signal: a_27_47# w=1]]', 's: [connection X18/s =>[signal: a_466_413# w=1]]', 'b: [connection X18/b =>[signal: VNB w=1]]']]
X__61__18 _61__a_381_47# _61__a_27_47# _61__a_466_413# no_conn_70 sky130_fd_pr__nfet_01v8 w=360000u l=150000u
** [instance X19 of sky130_fd_pr__nfet_01v8, params={'w': '420000u', 'l': '150000u'} connections=['d: [connection X19/d =>[signal: a_27_47# w=1]]', 'g: [connection X19/g =>[signal: CLK w=1]]', 's: [connection X19/s =>[signal: VGND w=1]]', 'b: [connection X19/b =>[signal: VNB w=1]]']]
X__61__19 _61__a_27_47# _61_:CLK VGND no_conn_70 sky130_fd_pr__nfet_01v8 w=420000u l=150000u
** [instance X20 of sky130_fd_pr__pfet_01v8_hvt, params={'w': '640000u', 'l': '150000u'} connections=['d: [connection X20/d =>[signal: a_27_47# w=1]]', 'g: [connection X20/g =>[signal: CLK w=1]]', 's: [connection X20/s =>[signal: VPWR w=1]]', 'b: [connection X20/b =>[signal: VPB w=1]]']]
X__61__20 _61__a_27_47# _61_:CLK VPWR no_conn_71 sky130_fd_pr__pfet_01v8_hvt w=640000u l=150000u
** [instance X21 of sky130_fd_pr__nfet_01v8, params={'w': '650000u', 'l': '150000u'} connections=['d: [connection X21/d =>[signal: Q w=1]]', 'g: [connection X21/g =>[signal: a_1059_315# w=1]]', 's: [connection X21/s =>[signal: VGND w=1]]', 'b: [connection X21/b =>[signal: VNB w=1]]']]
X__61__21 _61_:Q _61__a_1059_315# VGND no_conn_70 sky130_fd_pr__nfet_01v8 w=650000u l=150000u
** [instance X22 of sky130_fd_pr__pfet_01v8_hvt, params={'w': '640000u', 'l': '150000u'} connections=['d: [connection X22/d =>[signal: VPWR w=1]]', 'g: [connection X22/g =>[signal: a_27_47# w=1]]', 's: [connection X22/s =>[signal: a_193_47# w=1]]', 'b: [connection X22/b =>[signal: VPB w=1]]']]
X__61__22 VPWR _61__a_27_47# _61__a_193_47# no_conn_71 sky130_fd_pr__pfet_01v8_hvt w=640000u l=150000u
** [instance X23 of sky130_fd_pr__nfet_01v8, params={'w': '420000u', 'l': '150000u'} connections=['d: [connection X23/d =>[signal: VGND w=1]]', 'g: [connection X23/g =>[signal: D w=1]]', 's: [connection X23/s =>[signal: a_381_47# w=1]]', 'b: [connection X23/b =>[signal: VNB w=1]]']]
X__61__23 VGND _61_:D _61__a_381_47# no_conn_70 sky130_fd_pr__nfet_01v8 w=420000u l=150000u
** [instance X24 of sky130_fd_pr__pfet_01v8_hvt, params={'w': '420000u', 'l': '150000u'} connections=['d: [connection X24/d =>[signal: a_975_413# w=1]]', 'g: [connection X24/g =>[signal: a_1059_315# w=1]]', 's: [connection X24/s =>[signal: VPWR w=1]]', 'b: [connection X24/b =>[signal: VPB w=1]]']]
X__61__24 _61__a_975_413# _61__a_1059_315# VPWR no_conn_71 sky130_fd_pr__pfet_01v8_hvt w=420000u l=150000u
** [instance X25 of sky130_fd_pr__nfet_01v8, params={'w': '650000u', 'l': '150000u'} connections=['d: [connection X25/d =>[signal: VGND w=1]]', 'g: [connection X25/g =>[signal: a_1059_315# w=1]]', 's: [connection X25/s =>[signal: Q w=1]]', 'b: [connection X25/b =>[signal: VNB w=1]]']]
X__61__25 VGND _61__a_1059_315# _61_:Q no_conn_70 sky130_fd_pr__nfet_01v8 w=650000u l=150000u

** replacing fanout13 with the contents of sky130_fd_sc_hd__clkdlybuf4s25_1
** [instance X0 of sky130_fd_pr__pfet_01v8_hvt, params={'w': '820000u', 'l': '250000u'} connections=['d: [connection X0/d =>[signal: a_355_47# w=1]]', 'g: [connection X0/g =>[signal: a_244_47# w=1]]', 's: [connection X0/s =>[signal: VPWR w=1]]', 'b: [connection X0/b =>[signal: VPB w=1]]']]
X_fanout13_0 fanout13_a_355_47# fanout13_a_244_47# VPWR no_conn_73 sky130_fd_pr__pfet_01v8_hvt w=820000u l=250000u
** [instance X1 of sky130_fd_pr__pfet_01v8_hvt, params={'w': '820000u', 'l': '250000u'} connections=['d: [connection X1/d =>[signal: VPWR w=1]]', 'g: [connection X1/g =>[signal: a_27_47# w=1]]', 's: [connection X1/s =>[signal: a_244_47# w=1]]', 'b: [connection X1/b =>[signal: VPB w=1]]']]
X_fanout13_1 VPWR fanout13_a_27_47# fanout13_a_244_47# no_conn_73 sky130_fd_pr__pfet_01v8_hvt w=820000u l=250000u
** [instance X2 of sky130_fd_pr__pfet_01v8_hvt, params={'w': '1e+06u', 'l': '150000u'} connections=['d: [connection X2/d =>[signal: VPWR w=1]]', 'g: [connection X2/g =>[signal: a_355_47# w=1]]', 's: [connection X2/s =>[signal: X w=1]]', 'b: [connection X2/b =>[signal: VPB w=1]]']]
X_fanout13_2 VPWR fanout13_a_355_47# fanout13:X no_conn_73 sky130_fd_pr__pfet_01v8_hvt w=1e+06u l=150000u
** [instance X3 of sky130_fd_pr__pfet_01v8_hvt, params={'w': '1e+06u', 'l': '150000u'} connections=['d: [connection X3/d =>[signal: a_27_47# w=1]]', 'g: [connection X3/g =>[signal: A w=1]]', 's: [connection X3/s =>[signal: VPWR w=1]]', 'b: [connection X3/b =>[signal: VPB w=1]]']]
X_fanout13_3 fanout13_a_27_47# fanout13:A VPWR no_conn_73 sky130_fd_pr__pfet_01v8_hvt w=1e+06u l=150000u
** [instance X4 of sky130_fd_pr__nfet_01v8, params={'w': '650000u', 'l': '250000u'} connections=['d: [connection X4/d =>[signal: a_355_47# w=1]]', 'g: [connection X4/g =>[signal: a_244_47# w=1]]', 's: [connection X4/s =>[signal: VGND w=1]]', 'b: [connection X4/b =>[signal: VNB w=1]]']]
X_fanout13_4 fanout13_a_355_47# fanout13_a_244_47# VGND no_conn_72 sky130_fd_pr__nfet_01v8 w=650000u l=250000u
** [instance X5 of sky130_fd_pr__nfet_01v8, params={'w': '650000u', 'l': '250000u'} connections=['d: [connection X5/d =>[signal: VGND w=1]]', 'g: [connection X5/g =>[signal: a_27_47# w=1]]', 's: [connection X5/s =>[signal: a_244_47# w=1]]', 'b: [connection X5/b =>[signal: VNB w=1]]']]
X_fanout13_5 VGND fanout13_a_27_47# fanout13_a_244_47# no_conn_72 sky130_fd_pr__nfet_01v8 w=650000u l=250000u
** [instance X6 of sky130_fd_pr__nfet_01v8, params={'w': '420000u', 'l': '150000u'} connections=['d: [connection X6/d =>[signal: VGND w=1]]', 'g: [connection X6/g =>[signal: a_355_47# w=1]]', 's: [connection X6/s =>[signal: X w=1]]', 'b: [connection X6/b =>[signal: VNB w=1]]']]
X_fanout13_6 VGND fanout13_a_355_47# fanout13:X no_conn_72 sky130_fd_pr__nfet_01v8 w=420000u l=150000u
** [instance X7 of sky130_fd_pr__nfet_01v8, params={'w': '420000u', 'l': '150000u'} connections=['d: [connection X7/d =>[signal: a_27_47# w=1]]', 'g: [connection X7/g =>[signal: A w=1]]', 's: [connection X7/s =>[signal: VGND w=1]]', 'b: [connection X7/b =>[signal: VNB w=1]]']]
X_fanout13_7 fanout13_a_27_47# fanout13:A VGND no_conn_72 sky130_fd_pr__nfet_01v8 w=420000u l=150000u

** replacing hold27 with the contents of sky130_fd_sc_hd__dlygate4sd3_1
** [instance X0 of sky130_fd_pr__nfet_01v8, params={'w': '420000u', 'l': '500000u'} connections=['d: [connection X0/d =>[signal: a_391_47# w=1]]', 'g: [connection X0/g =>[signal: a_285_47# w=1]]', 's: [connection X0/s =>[signal: VGND w=1]]', 'b: [connection X0/b =>[signal: VNB w=1]]']]
X_hold27_0 hold27_a_391_47# hold27_a_285_47# VGND no_conn_74 sky130_fd_pr__nfet_01v8 w=420000u l=500000u
** [instance X1 of sky130_fd_pr__pfet_01v8_hvt, params={'w': '420000u', 'l': '500000u'} connections=['d: [connection X1/d =>[signal: VPWR w=1]]', 'g: [connection X1/g =>[signal: a_49_47# w=1]]', 's: [connection X1/s =>[signal: a_285_47# w=1]]', 'b: [connection X1/b =>[signal: VPB w=1]]']]
X_hold27_1 VPWR hold27_a_49_47# hold27_a_285_47# no_conn_75 sky130_fd_pr__pfet_01v8_hvt w=420000u l=500000u
** [instance X2 of sky130_fd_pr__nfet_01v8, params={'w': '420000u', 'l': '150000u'} connections=['d: [connection X2/d =>[signal: a_49_47# w=1]]', 'g: [connection X2/g =>[signal: A w=1]]', 's: [connection X2/s =>[signal: VGND w=1]]', 'b: [connection X2/b =>[signal: VNB w=1]]']]
X_hold27_2 hold27_a_49_47# hold27:A VGND no_conn_74 sky130_fd_pr__nfet_01v8 w=420000u l=150000u
** [instance X3 of sky130_fd_pr__pfet_01v8_hvt, params={'w': '1e+06u', 'l': '150000u'} connections=['d: [connection X3/d =>[signal: VPWR w=1]]', 'g: [connection X3/g =>[signal: a_391_47# w=1]]', 's: [connection X3/s =>[signal: X w=1]]', 'b: [connection X3/b =>[signal: VPB w=1]]']]
X_hold27_3 VPWR hold27_a_391_47# hold27:X no_conn_75 sky130_fd_pr__pfet_01v8_hvt w=1e+06u l=150000u
** [instance X4 of sky130_fd_pr__nfet_01v8, params={'w': '650000u', 'l': '150000u'} connections=['d: [connection X4/d =>[signal: VGND w=1]]', 'g: [connection X4/g =>[signal: a_391_47# w=1]]', 's: [connection X4/s =>[signal: X w=1]]', 'b: [connection X4/b =>[signal: VNB w=1]]']]
X_hold27_4 VGND hold27_a_391_47# hold27:X no_conn_74 sky130_fd_pr__nfet_01v8 w=650000u l=150000u
** [instance X5 of sky130_fd_pr__nfet_01v8, params={'w': '420000u', 'l': '500000u'} connections=['d: [connection X5/d =>[signal: VGND w=1]]', 'g: [connection X5/g =>[signal: a_49_47# w=1]]', 's: [connection X5/s =>[signal: a_285_47# w=1]]', 'b: [connection X5/b =>[signal: VNB w=1]]']]
X_hold27_5 VGND hold27_a_49_47# hold27_a_285_47# no_conn_74 sky130_fd_pr__nfet_01v8 w=420000u l=500000u
** [instance X6 of sky130_fd_pr__pfet_01v8_hvt, params={'w': '420000u', 'l': '500000u'} connections=['d: [connection X6/d =>[signal: a_391_47# w=1]]', 'g: [connection X6/g =>[signal: a_285_47# w=1]]', 's: [connection X6/s =>[signal: VPWR w=1]]', 'b: [connection X6/b =>[signal: VPB w=1]]']]
X_hold27_6 hold27_a_391_47# hold27_a_285_47# VPWR no_conn_75 sky130_fd_pr__pfet_01v8_hvt w=420000u l=500000u
** [instance X7 of sky130_fd_pr__pfet_01v8_hvt, params={'w': '420000u', 'l': '150000u'} connections=['d: [connection X7/d =>[signal: a_49_47# w=1]]', 'g: [connection X7/g =>[signal: A w=1]]', 's: [connection X7/s =>[signal: VPWR w=1]]', 'b: [connection X7/b =>[signal: VPB w=1]]']]
X_hold27_7 hold27_a_49_47# hold27:A VPWR no_conn_75 sky130_fd_pr__pfet_01v8_hvt w=420000u l=150000u

** replacing _62_ with the contents of sky130_fd_sc_hd__dfxtp_2
** [instance X0 of sky130_fd_pr__pfet_01v8_hvt, params={'w': '420000u', 'l': '150000u'} connections=['d: [connection X0/d =>[signal: a_891_413# w=1]]', 'g: [connection X0/g =>[signal: a_193_47# w=1]]', 's: [connection X0/s =>[signal: a_975_413# w=1]]', 'b: [connection X0/b =>[signal: VPB w=1]]']]
X__62__0 _62__a_891_413# _62__a_193_47# _62__a_975_413# no_conn_77 sky130_fd_pr__pfet_01v8_hvt w=420000u l=150000u
** [instance X1 of sky130_fd_pr__nfet_01v8, params={'w': '650000u', 'l': '150000u'} connections=['d: [connection X1/d =>[signal: a_1059_315# w=1]]', 'g: [connection X1/g =>[signal: a_891_413# w=1]]', 's: [connection X1/s =>[signal: VGND w=1]]', 'b: [connection X1/b =>[signal: VNB w=1]]']]
X__62__1 _62__a_1059_315# _62__a_891_413# VGND no_conn_76 sky130_fd_pr__nfet_01v8 w=650000u l=150000u
** [instance X2 of sky130_fd_pr__pfet_01v8_hvt, params={'w': '420000u', 'l': '150000u'} connections=['d: [connection X2/d =>[signal: a_466_413# w=1]]', 'g: [connection X2/g =>[signal: a_27_47# w=1]]', 's: [connection X2/s =>[signal: a_561_413# w=1]]', 'b: [connection X2/b =>[signal: VPB w=1]]']]
X__62__2 _62__a_466_413# _62__a_27_47# _62__a_561_413# no_conn_77 sky130_fd_pr__pfet_01v8_hvt w=420000u l=150000u
** [instance X3 of sky130_fd_pr__pfet_01v8_hvt, params={'w': '420000u', 'l': '150000u'} connections=['d: [connection X3/d =>[signal: a_634_159# w=1]]', 'g: [connection X3/g =>[signal: a_27_47# w=1]]', 's: [connection X3/s =>[signal: a_891_413# w=1]]', 'b: [connection X3/b =>[signal: VPB w=1]]']]
X__62__3 _62__a_634_159# _62__a_27_47# _62__a_891_413# no_conn_77 sky130_fd_pr__pfet_01v8_hvt w=420000u l=150000u
** [instance X4 of sky130_fd_pr__pfet_01v8_hvt, params={'w': '420000u', 'l': '150000u'} connections=['d: [connection X4/d =>[signal: a_381_47# w=1]]', 'g: [connection X4/g =>[signal: a_193_47# w=1]]', 's: [connection X4/s =>[signal: a_466_413# w=1]]', 'b: [connection X4/b =>[signal: VPB w=1]]']]
X__62__4 _62__a_381_47# _62__a_193_47# _62__a_466_413# no_conn_77 sky130_fd_pr__pfet_01v8_hvt w=420000u l=150000u
** [instance X5 of sky130_fd_pr__pfet_01v8_hvt, params={'w': '420000u', 'l': '150000u'} connections=['d: [connection X5/d =>[signal: VPWR w=1]]', 'g: [connection X5/g =>[signal: D w=1]]', 's: [connection X5/s =>[signal: a_381_47# w=1]]', 'b: [connection X5/b =>[signal: VPB w=1]]']]
X__62__5 VPWR _62_:D _62__a_381_47# no_conn_77 sky130_fd_pr__pfet_01v8_hvt w=420000u l=150000u
** [instance X6 of sky130_fd_pr__pfet_01v8_hvt, params={'w': '750000u', 'l': '150000u'} connections=['d: [connection X6/d =>[signal: VPWR w=1]]', 'g: [connection X6/g =>[signal: a_466_413# w=1]]', 's: [connection X6/s =>[signal: a_634_159# w=1]]', 'b: [connection X6/b =>[signal: VPB w=1]]']]
X__62__6 VPWR _62__a_466_413# _62__a_634_159# no_conn_77 sky130_fd_pr__pfet_01v8_hvt w=750000u l=150000u
** [instance X7 of sky130_fd_pr__nfet_01v8, params={'w': '640000u', 'l': '150000u'} connections=['d: [connection X7/d =>[signal: VGND w=1]]', 'g: [connection X7/g =>[signal: a_466_413# w=1]]', 's: [connection X7/s =>[signal: a_634_159# w=1]]', 'b: [connection X7/b =>[signal: VNB w=1]]']]
X__62__7 VGND _62__a_466_413# _62__a_634_159# no_conn_76 sky130_fd_pr__nfet_01v8 w=640000u l=150000u
** [instance X8 of sky130_fd_pr__nfet_01v8, params={'w': '420000u', 'l': '150000u'} connections=['d: [connection X8/d =>[signal: a_1017_47# w=1]]', 'g: [connection X8/g =>[signal: a_1059_315# w=1]]', 's: [connection X8/s =>[signal: VGND w=1]]', 'b: [connection X8/b =>[signal: VNB w=1]]']]
X__62__8 _62__a_1017_47# _62__a_1059_315# VGND no_conn_76 sky130_fd_pr__nfet_01v8 w=420000u l=150000u
** [instance X9 of sky130_fd_pr__pfet_01v8_hvt, params={'w': '1e+06u', 'l': '150000u'} connections=['d: [connection X9/d =>[signal: a_1059_315# w=1]]', 'g: [connection X9/g =>[signal: a_891_413# w=1]]', 's: [connection X9/s =>[signal: VPWR w=1]]', 'b: [connection X9/b =>[signal: VPB w=1]]']]
X__62__9 _62__a_1059_315# _62__a_891_413# VPWR no_conn_77 sky130_fd_pr__pfet_01v8_hvt w=1e+06u l=150000u
** [instance X10 of sky130_fd_pr__pfet_01v8_hvt, params={'w': '1e+06u', 'l': '150000u'} connections=['d: [connection X10/d =>[signal: Q w=1]]', 'g: [connection X10/g =>[signal: a_1059_315# w=1]]', 's: [connection X10/s =>[signal: VPWR w=1]]', 'b: [connection X10/b =>[signal: VPB w=1]]']]
X__62__10 _62_:Q _62__a_1059_315# VPWR no_conn_77 sky130_fd_pr__pfet_01v8_hvt w=1e+06u l=150000u
** [instance X11 of sky130_fd_pr__pfet_01v8_hvt, params={'w': '420000u', 'l': '150000u'} connections=['d: [connection X11/d =>[signal: a_561_413# w=1]]', 'g: [connection X11/g =>[signal: a_634_159# w=1]]', 's: [connection X11/s =>[signal: VPWR w=1]]', 'b: [connection X11/b =>[signal: VPB w=1]]']]
X__62__11 _62__a_561_413# _62__a_634_159# VPWR no_conn_77 sky130_fd_pr__pfet_01v8_hvt w=420000u l=150000u
** [instance X12 of sky130_fd_pr__pfet_01v8_hvt, params={'w': '1e+06u', 'l': '150000u'} connections=['d: [connection X12/d =>[signal: VPWR w=1]]', 'g: [connection X12/g =>[signal: a_1059_315# w=1]]', 's: [connection X12/s =>[signal: Q w=1]]', 'b: [connection X12/b =>[signal: VPB w=1]]']]
X__62__12 VPWR _62__a_1059_315# _62_:Q no_conn_77 sky130_fd_pr__pfet_01v8_hvt w=1e+06u l=150000u
** [instance X13 of sky130_fd_pr__nfet_01v8, params={'w': '360000u', 'l': '150000u'} connections=['d: [connection X13/d =>[signal: a_891_413# w=1]]', 'g: [connection X13/g =>[signal: a_27_47# w=1]]', 's: [connection X13/s =>[signal: a_1017_47# w=1]]', 'b: [connection X13/b =>[signal: VNB w=1]]']]
X__62__13 _62__a_891_413# _62__a_27_47# _62__a_1017_47# no_conn_76 sky130_fd_pr__nfet_01v8 w=360000u l=150000u
** [instance X14 of sky130_fd_pr__nfet_01v8, params={'w': '360000u', 'l': '150000u'} connections=['d: [connection X14/d =>[signal: a_634_159# w=1]]', 'g: [connection X14/g =>[signal: a_193_47# w=1]]', 's: [connection X14/s =>[signal: a_891_413# w=1]]', 'b: [connection X14/b =>[signal: VNB w=1]]']]
X__62__14 _62__a_634_159# _62__a_193_47# _62__a_891_413# no_conn_76 sky130_fd_pr__nfet_01v8 w=360000u l=150000u
** [instance X15 of sky130_fd_pr__nfet_01v8, params={'w': '420000u', 'l': '150000u'} connections=['d: [connection X15/d =>[signal: a_592_47# w=1]]', 'g: [connection X15/g =>[signal: a_634_159# w=1]]', 's: [connection X15/s =>[signal: VGND w=1]]', 'b: [connection X15/b =>[signal: VNB w=1]]']]
X__62__15 _62__a_592_47# _62__a_634_159# VGND no_conn_76 sky130_fd_pr__nfet_01v8 w=420000u l=150000u
** [instance X16 of sky130_fd_pr__nfet_01v8, params={'w': '360000u', 'l': '150000u'} connections=['d: [connection X16/d =>[signal: a_466_413# w=1]]', 'g: [connection X16/g =>[signal: a_193_47# w=1]]', 's: [connection X16/s =>[signal: a_592_47# w=1]]', 'b: [connection X16/b =>[signal: VNB w=1]]']]
X__62__16 _62__a_466_413# _62__a_193_47# _62__a_592_47# no_conn_76 sky130_fd_pr__nfet_01v8 w=360000u l=150000u
** [instance X17 of sky130_fd_pr__nfet_01v8, params={'w': '420000u', 'l': '150000u'} connections=['d: [connection X17/d =>[signal: VGND w=1]]', 'g: [connection X17/g =>[signal: a_27_47# w=1]]', 's: [connection X17/s =>[signal: a_193_47# w=1]]', 'b: [connection X17/b =>[signal: VNB w=1]]']]
X__62__17 VGND _62__a_27_47# _62__a_193_47# no_conn_76 sky130_fd_pr__nfet_01v8 w=420000u l=150000u
** [instance X18 of sky130_fd_pr__nfet_01v8, params={'w': '360000u', 'l': '150000u'} connections=['d: [connection X18/d =>[signal: a_381_47# w=1]]', 'g: [connection X18/g =>[signal: a_27_47# w=1]]', 's: [connection X18/s =>[signal: a_466_413# w=1]]', 'b: [connection X18/b =>[signal: VNB w=1]]']]
X__62__18 _62__a_381_47# _62__a_27_47# _62__a_466_413# no_conn_76 sky130_fd_pr__nfet_01v8 w=360000u l=150000u
** [instance X19 of sky130_fd_pr__nfet_01v8, params={'w': '420000u', 'l': '150000u'} connections=['d: [connection X19/d =>[signal: a_27_47# w=1]]', 'g: [connection X19/g =>[signal: CLK w=1]]', 's: [connection X19/s =>[signal: VGND w=1]]', 'b: [connection X19/b =>[signal: VNB w=1]]']]
X__62__19 _62__a_27_47# _62_:CLK VGND no_conn_76 sky130_fd_pr__nfet_01v8 w=420000u l=150000u
** [instance X20 of sky130_fd_pr__pfet_01v8_hvt, params={'w': '640000u', 'l': '150000u'} connections=['d: [connection X20/d =>[signal: a_27_47# w=1]]', 'g: [connection X20/g =>[signal: CLK w=1]]', 's: [connection X20/s =>[signal: VPWR w=1]]', 'b: [connection X20/b =>[signal: VPB w=1]]']]
X__62__20 _62__a_27_47# _62_:CLK VPWR no_conn_77 sky130_fd_pr__pfet_01v8_hvt w=640000u l=150000u
** [instance X21 of sky130_fd_pr__nfet_01v8, params={'w': '650000u', 'l': '150000u'} connections=['d: [connection X21/d =>[signal: Q w=1]]', 'g: [connection X21/g =>[signal: a_1059_315# w=1]]', 's: [connection X21/s =>[signal: VGND w=1]]', 'b: [connection X21/b =>[signal: VNB w=1]]']]
X__62__21 _62_:Q _62__a_1059_315# VGND no_conn_76 sky130_fd_pr__nfet_01v8 w=650000u l=150000u
** [instance X22 of sky130_fd_pr__pfet_01v8_hvt, params={'w': '640000u', 'l': '150000u'} connections=['d: [connection X22/d =>[signal: VPWR w=1]]', 'g: [connection X22/g =>[signal: a_27_47# w=1]]', 's: [connection X22/s =>[signal: a_193_47# w=1]]', 'b: [connection X22/b =>[signal: VPB w=1]]']]
X__62__22 VPWR _62__a_27_47# _62__a_193_47# no_conn_77 sky130_fd_pr__pfet_01v8_hvt w=640000u l=150000u
** [instance X23 of sky130_fd_pr__nfet_01v8, params={'w': '420000u', 'l': '150000u'} connections=['d: [connection X23/d =>[signal: VGND w=1]]', 'g: [connection X23/g =>[signal: D w=1]]', 's: [connection X23/s =>[signal: a_381_47# w=1]]', 'b: [connection X23/b =>[signal: VNB w=1]]']]
X__62__23 VGND _62_:D _62__a_381_47# no_conn_76 sky130_fd_pr__nfet_01v8 w=420000u l=150000u
** [instance X24 of sky130_fd_pr__pfet_01v8_hvt, params={'w': '420000u', 'l': '150000u'} connections=['d: [connection X24/d =>[signal: a_975_413# w=1]]', 'g: [connection X24/g =>[signal: a_1059_315# w=1]]', 's: [connection X24/s =>[signal: VPWR w=1]]', 'b: [connection X24/b =>[signal: VPB w=1]]']]
X__62__24 _62__a_975_413# _62__a_1059_315# VPWR no_conn_77 sky130_fd_pr__pfet_01v8_hvt w=420000u l=150000u
** [instance X25 of sky130_fd_pr__nfet_01v8, params={'w': '650000u', 'l': '150000u'} connections=['d: [connection X25/d =>[signal: VGND w=1]]', 'g: [connection X25/g =>[signal: a_1059_315# w=1]]', 's: [connection X25/s =>[signal: Q w=1]]', 'b: [connection X25/b =>[signal: VNB w=1]]']]
X__62__25 VGND _62__a_1059_315# _62_:Q no_conn_76 sky130_fd_pr__nfet_01v8 w=650000u l=150000u

** replacing hold23 with the contents of sky130_fd_sc_hd__dlygate4sd3_1
** [instance X0 of sky130_fd_pr__nfet_01v8, params={'w': '420000u', 'l': '500000u'} connections=['d: [connection X0/d =>[signal: a_391_47# w=1]]', 'g: [connection X0/g =>[signal: a_285_47# w=1]]', 's: [connection X0/s =>[signal: VGND w=1]]', 'b: [connection X0/b =>[signal: VNB w=1]]']]
X_hold23_0 hold23_a_391_47# hold23_a_285_47# VGND no_conn_78 sky130_fd_pr__nfet_01v8 w=420000u l=500000u
** [instance X1 of sky130_fd_pr__pfet_01v8_hvt, params={'w': '420000u', 'l': '500000u'} connections=['d: [connection X1/d =>[signal: VPWR w=1]]', 'g: [connection X1/g =>[signal: a_49_47# w=1]]', 's: [connection X1/s =>[signal: a_285_47# w=1]]', 'b: [connection X1/b =>[signal: VPB w=1]]']]
X_hold23_1 VPWR hold23_a_49_47# hold23_a_285_47# no_conn_79 sky130_fd_pr__pfet_01v8_hvt w=420000u l=500000u
** [instance X2 of sky130_fd_pr__nfet_01v8, params={'w': '420000u', 'l': '150000u'} connections=['d: [connection X2/d =>[signal: a_49_47# w=1]]', 'g: [connection X2/g =>[signal: A w=1]]', 's: [connection X2/s =>[signal: VGND w=1]]', 'b: [connection X2/b =>[signal: VNB w=1]]']]
X_hold23_2 hold23_a_49_47# hold23:A VGND no_conn_78 sky130_fd_pr__nfet_01v8 w=420000u l=150000u
** [instance X3 of sky130_fd_pr__pfet_01v8_hvt, params={'w': '1e+06u', 'l': '150000u'} connections=['d: [connection X3/d =>[signal: VPWR w=1]]', 'g: [connection X3/g =>[signal: a_391_47# w=1]]', 's: [connection X3/s =>[signal: X w=1]]', 'b: [connection X3/b =>[signal: VPB w=1]]']]
X_hold23_3 VPWR hold23_a_391_47# hold23:X no_conn_79 sky130_fd_pr__pfet_01v8_hvt w=1e+06u l=150000u
** [instance X4 of sky130_fd_pr__nfet_01v8, params={'w': '650000u', 'l': '150000u'} connections=['d: [connection X4/d =>[signal: VGND w=1]]', 'g: [connection X4/g =>[signal: a_391_47# w=1]]', 's: [connection X4/s =>[signal: X w=1]]', 'b: [connection X4/b =>[signal: VNB w=1]]']]
X_hold23_4 VGND hold23_a_391_47# hold23:X no_conn_78 sky130_fd_pr__nfet_01v8 w=650000u l=150000u
** [instance X5 of sky130_fd_pr__nfet_01v8, params={'w': '420000u', 'l': '500000u'} connections=['d: [connection X5/d =>[signal: VGND w=1]]', 'g: [connection X5/g =>[signal: a_49_47# w=1]]', 's: [connection X5/s =>[signal: a_285_47# w=1]]', 'b: [connection X5/b =>[signal: VNB w=1]]']]
X_hold23_5 VGND hold23_a_49_47# hold23_a_285_47# no_conn_78 sky130_fd_pr__nfet_01v8 w=420000u l=500000u
** [instance X6 of sky130_fd_pr__pfet_01v8_hvt, params={'w': '420000u', 'l': '500000u'} connections=['d: [connection X6/d =>[signal: a_391_47# w=1]]', 'g: [connection X6/g =>[signal: a_285_47# w=1]]', 's: [connection X6/s =>[signal: VPWR w=1]]', 'b: [connection X6/b =>[signal: VPB w=1]]']]
X_hold23_6 hold23_a_391_47# hold23_a_285_47# VPWR no_conn_79 sky130_fd_pr__pfet_01v8_hvt w=420000u l=500000u
** [instance X7 of sky130_fd_pr__pfet_01v8_hvt, params={'w': '420000u', 'l': '150000u'} connections=['d: [connection X7/d =>[signal: a_49_47# w=1]]', 'g: [connection X7/g =>[signal: A w=1]]', 's: [connection X7/s =>[signal: VPWR w=1]]', 'b: [connection X7/b =>[signal: VPB w=1]]']]
X_hold23_7 hold23_a_49_47# hold23:A VPWR no_conn_79 sky130_fd_pr__pfet_01v8_hvt w=420000u l=150000u

** replacing hold29 with the contents of sky130_fd_sc_hd__dlygate4sd3_1
** [instance X0 of sky130_fd_pr__nfet_01v8, params={'w': '420000u', 'l': '500000u'} connections=['d: [connection X0/d =>[signal: a_391_47# w=1]]', 'g: [connection X0/g =>[signal: a_285_47# w=1]]', 's: [connection X0/s =>[signal: VGND w=1]]', 'b: [connection X0/b =>[signal: VNB w=1]]']]
X_hold29_0 hold29_a_391_47# hold29_a_285_47# VGND no_conn_80 sky130_fd_pr__nfet_01v8 w=420000u l=500000u
** [instance X1 of sky130_fd_pr__pfet_01v8_hvt, params={'w': '420000u', 'l': '500000u'} connections=['d: [connection X1/d =>[signal: VPWR w=1]]', 'g: [connection X1/g =>[signal: a_49_47# w=1]]', 's: [connection X1/s =>[signal: a_285_47# w=1]]', 'b: [connection X1/b =>[signal: VPB w=1]]']]
X_hold29_1 VPWR hold29_a_49_47# hold29_a_285_47# no_conn_81 sky130_fd_pr__pfet_01v8_hvt w=420000u l=500000u
** [instance X2 of sky130_fd_pr__nfet_01v8, params={'w': '420000u', 'l': '150000u'} connections=['d: [connection X2/d =>[signal: a_49_47# w=1]]', 'g: [connection X2/g =>[signal: A w=1]]', 's: [connection X2/s =>[signal: VGND w=1]]', 'b: [connection X2/b =>[signal: VNB w=1]]']]
X_hold29_2 hold29_a_49_47# hold29:A VGND no_conn_80 sky130_fd_pr__nfet_01v8 w=420000u l=150000u
** [instance X3 of sky130_fd_pr__pfet_01v8_hvt, params={'w': '1e+06u', 'l': '150000u'} connections=['d: [connection X3/d =>[signal: VPWR w=1]]', 'g: [connection X3/g =>[signal: a_391_47# w=1]]', 's: [connection X3/s =>[signal: X w=1]]', 'b: [connection X3/b =>[signal: VPB w=1]]']]
X_hold29_3 VPWR hold29_a_391_47# hold29:X no_conn_81 sky130_fd_pr__pfet_01v8_hvt w=1e+06u l=150000u
** [instance X4 of sky130_fd_pr__nfet_01v8, params={'w': '650000u', 'l': '150000u'} connections=['d: [connection X4/d =>[signal: VGND w=1]]', 'g: [connection X4/g =>[signal: a_391_47# w=1]]', 's: [connection X4/s =>[signal: X w=1]]', 'b: [connection X4/b =>[signal: VNB w=1]]']]
X_hold29_4 VGND hold29_a_391_47# hold29:X no_conn_80 sky130_fd_pr__nfet_01v8 w=650000u l=150000u
** [instance X5 of sky130_fd_pr__nfet_01v8, params={'w': '420000u', 'l': '500000u'} connections=['d: [connection X5/d =>[signal: VGND w=1]]', 'g: [connection X5/g =>[signal: a_49_47# w=1]]', 's: [connection X5/s =>[signal: a_285_47# w=1]]', 'b: [connection X5/b =>[signal: VNB w=1]]']]
X_hold29_5 VGND hold29_a_49_47# hold29_a_285_47# no_conn_80 sky130_fd_pr__nfet_01v8 w=420000u l=500000u
** [instance X6 of sky130_fd_pr__pfet_01v8_hvt, params={'w': '420000u', 'l': '500000u'} connections=['d: [connection X6/d =>[signal: a_391_47# w=1]]', 'g: [connection X6/g =>[signal: a_285_47# w=1]]', 's: [connection X6/s =>[signal: VPWR w=1]]', 'b: [connection X6/b =>[signal: VPB w=1]]']]
X_hold29_6 hold29_a_391_47# hold29_a_285_47# VPWR no_conn_81 sky130_fd_pr__pfet_01v8_hvt w=420000u l=500000u
** [instance X7 of sky130_fd_pr__pfet_01v8_hvt, params={'w': '420000u', 'l': '150000u'} connections=['d: [connection X7/d =>[signal: a_49_47# w=1]]', 'g: [connection X7/g =>[signal: A w=1]]', 's: [connection X7/s =>[signal: VPWR w=1]]', 'b: [connection X7/b =>[signal: VPB w=1]]']]
X_hold29_7 hold29_a_49_47# hold29:A VPWR no_conn_81 sky130_fd_pr__pfet_01v8_hvt w=420000u l=150000u

** replacing _63_ with the contents of sky130_fd_sc_hd__dfxtp_2
** [instance X0 of sky130_fd_pr__pfet_01v8_hvt, params={'w': '420000u', 'l': '150000u'} connections=['d: [connection X0/d =>[signal: a_891_413# w=1]]', 'g: [connection X0/g =>[signal: a_193_47# w=1]]', 's: [connection X0/s =>[signal: a_975_413# w=1]]', 'b: [connection X0/b =>[signal: VPB w=1]]']]
X__63__0 _63__a_891_413# _63__a_193_47# _63__a_975_413# no_conn_83 sky130_fd_pr__pfet_01v8_hvt w=420000u l=150000u
** [instance X1 of sky130_fd_pr__nfet_01v8, params={'w': '650000u', 'l': '150000u'} connections=['d: [connection X1/d =>[signal: a_1059_315# w=1]]', 'g: [connection X1/g =>[signal: a_891_413# w=1]]', 's: [connection X1/s =>[signal: VGND w=1]]', 'b: [connection X1/b =>[signal: VNB w=1]]']]
X__63__1 _63__a_1059_315# _63__a_891_413# VGND no_conn_82 sky130_fd_pr__nfet_01v8 w=650000u l=150000u
** [instance X2 of sky130_fd_pr__pfet_01v8_hvt, params={'w': '420000u', 'l': '150000u'} connections=['d: [connection X2/d =>[signal: a_466_413# w=1]]', 'g: [connection X2/g =>[signal: a_27_47# w=1]]', 's: [connection X2/s =>[signal: a_561_413# w=1]]', 'b: [connection X2/b =>[signal: VPB w=1]]']]
X__63__2 _63__a_466_413# _63__a_27_47# _63__a_561_413# no_conn_83 sky130_fd_pr__pfet_01v8_hvt w=420000u l=150000u
** [instance X3 of sky130_fd_pr__pfet_01v8_hvt, params={'w': '420000u', 'l': '150000u'} connections=['d: [connection X3/d =>[signal: a_634_159# w=1]]', 'g: [connection X3/g =>[signal: a_27_47# w=1]]', 's: [connection X3/s =>[signal: a_891_413# w=1]]', 'b: [connection X3/b =>[signal: VPB w=1]]']]
X__63__3 _63__a_634_159# _63__a_27_47# _63__a_891_413# no_conn_83 sky130_fd_pr__pfet_01v8_hvt w=420000u l=150000u
** [instance X4 of sky130_fd_pr__pfet_01v8_hvt, params={'w': '420000u', 'l': '150000u'} connections=['d: [connection X4/d =>[signal: a_381_47# w=1]]', 'g: [connection X4/g =>[signal: a_193_47# w=1]]', 's: [connection X4/s =>[signal: a_466_413# w=1]]', 'b: [connection X4/b =>[signal: VPB w=1]]']]
X__63__4 _63__a_381_47# _63__a_193_47# _63__a_466_413# no_conn_83 sky130_fd_pr__pfet_01v8_hvt w=420000u l=150000u
** [instance X5 of sky130_fd_pr__pfet_01v8_hvt, params={'w': '420000u', 'l': '150000u'} connections=['d: [connection X5/d =>[signal: VPWR w=1]]', 'g: [connection X5/g =>[signal: D w=1]]', 's: [connection X5/s =>[signal: a_381_47# w=1]]', 'b: [connection X5/b =>[signal: VPB w=1]]']]
X__63__5 VPWR _63_:D _63__a_381_47# no_conn_83 sky130_fd_pr__pfet_01v8_hvt w=420000u l=150000u
** [instance X6 of sky130_fd_pr__pfet_01v8_hvt, params={'w': '750000u', 'l': '150000u'} connections=['d: [connection X6/d =>[signal: VPWR w=1]]', 'g: [connection X6/g =>[signal: a_466_413# w=1]]', 's: [connection X6/s =>[signal: a_634_159# w=1]]', 'b: [connection X6/b =>[signal: VPB w=1]]']]
X__63__6 VPWR _63__a_466_413# _63__a_634_159# no_conn_83 sky130_fd_pr__pfet_01v8_hvt w=750000u l=150000u
** [instance X7 of sky130_fd_pr__nfet_01v8, params={'w': '640000u', 'l': '150000u'} connections=['d: [connection X7/d =>[signal: VGND w=1]]', 'g: [connection X7/g =>[signal: a_466_413# w=1]]', 's: [connection X7/s =>[signal: a_634_159# w=1]]', 'b: [connection X7/b =>[signal: VNB w=1]]']]
X__63__7 VGND _63__a_466_413# _63__a_634_159# no_conn_82 sky130_fd_pr__nfet_01v8 w=640000u l=150000u
** [instance X8 of sky130_fd_pr__nfet_01v8, params={'w': '420000u', 'l': '150000u'} connections=['d: [connection X8/d =>[signal: a_1017_47# w=1]]', 'g: [connection X8/g =>[signal: a_1059_315# w=1]]', 's: [connection X8/s =>[signal: VGND w=1]]', 'b: [connection X8/b =>[signal: VNB w=1]]']]
X__63__8 _63__a_1017_47# _63__a_1059_315# VGND no_conn_82 sky130_fd_pr__nfet_01v8 w=420000u l=150000u
** [instance X9 of sky130_fd_pr__pfet_01v8_hvt, params={'w': '1e+06u', 'l': '150000u'} connections=['d: [connection X9/d =>[signal: a_1059_315# w=1]]', 'g: [connection X9/g =>[signal: a_891_413# w=1]]', 's: [connection X9/s =>[signal: VPWR w=1]]', 'b: [connection X9/b =>[signal: VPB w=1]]']]
X__63__9 _63__a_1059_315# _63__a_891_413# VPWR no_conn_83 sky130_fd_pr__pfet_01v8_hvt w=1e+06u l=150000u
** [instance X10 of sky130_fd_pr__pfet_01v8_hvt, params={'w': '1e+06u', 'l': '150000u'} connections=['d: [connection X10/d =>[signal: Q w=1]]', 'g: [connection X10/g =>[signal: a_1059_315# w=1]]', 's: [connection X10/s =>[signal: VPWR w=1]]', 'b: [connection X10/b =>[signal: VPB w=1]]']]
X__63__10 _63_:Q _63__a_1059_315# VPWR no_conn_83 sky130_fd_pr__pfet_01v8_hvt w=1e+06u l=150000u
** [instance X11 of sky130_fd_pr__pfet_01v8_hvt, params={'w': '420000u', 'l': '150000u'} connections=['d: [connection X11/d =>[signal: a_561_413# w=1]]', 'g: [connection X11/g =>[signal: a_634_159# w=1]]', 's: [connection X11/s =>[signal: VPWR w=1]]', 'b: [connection X11/b =>[signal: VPB w=1]]']]
X__63__11 _63__a_561_413# _63__a_634_159# VPWR no_conn_83 sky130_fd_pr__pfet_01v8_hvt w=420000u l=150000u
** [instance X12 of sky130_fd_pr__pfet_01v8_hvt, params={'w': '1e+06u', 'l': '150000u'} connections=['d: [connection X12/d =>[signal: VPWR w=1]]', 'g: [connection X12/g =>[signal: a_1059_315# w=1]]', 's: [connection X12/s =>[signal: Q w=1]]', 'b: [connection X12/b =>[signal: VPB w=1]]']]
X__63__12 VPWR _63__a_1059_315# _63_:Q no_conn_83 sky130_fd_pr__pfet_01v8_hvt w=1e+06u l=150000u
** [instance X13 of sky130_fd_pr__nfet_01v8, params={'w': '360000u', 'l': '150000u'} connections=['d: [connection X13/d =>[signal: a_891_413# w=1]]', 'g: [connection X13/g =>[signal: a_27_47# w=1]]', 's: [connection X13/s =>[signal: a_1017_47# w=1]]', 'b: [connection X13/b =>[signal: VNB w=1]]']]
X__63__13 _63__a_891_413# _63__a_27_47# _63__a_1017_47# no_conn_82 sky130_fd_pr__nfet_01v8 w=360000u l=150000u
** [instance X14 of sky130_fd_pr__nfet_01v8, params={'w': '360000u', 'l': '150000u'} connections=['d: [connection X14/d =>[signal: a_634_159# w=1]]', 'g: [connection X14/g =>[signal: a_193_47# w=1]]', 's: [connection X14/s =>[signal: a_891_413# w=1]]', 'b: [connection X14/b =>[signal: VNB w=1]]']]
X__63__14 _63__a_634_159# _63__a_193_47# _63__a_891_413# no_conn_82 sky130_fd_pr__nfet_01v8 w=360000u l=150000u
** [instance X15 of sky130_fd_pr__nfet_01v8, params={'w': '420000u', 'l': '150000u'} connections=['d: [connection X15/d =>[signal: a_592_47# w=1]]', 'g: [connection X15/g =>[signal: a_634_159# w=1]]', 's: [connection X15/s =>[signal: VGND w=1]]', 'b: [connection X15/b =>[signal: VNB w=1]]']]
X__63__15 _63__a_592_47# _63__a_634_159# VGND no_conn_82 sky130_fd_pr__nfet_01v8 w=420000u l=150000u
** [instance X16 of sky130_fd_pr__nfet_01v8, params={'w': '360000u', 'l': '150000u'} connections=['d: [connection X16/d =>[signal: a_466_413# w=1]]', 'g: [connection X16/g =>[signal: a_193_47# w=1]]', 's: [connection X16/s =>[signal: a_592_47# w=1]]', 'b: [connection X16/b =>[signal: VNB w=1]]']]
X__63__16 _63__a_466_413# _63__a_193_47# _63__a_592_47# no_conn_82 sky130_fd_pr__nfet_01v8 w=360000u l=150000u
** [instance X17 of sky130_fd_pr__nfet_01v8, params={'w': '420000u', 'l': '150000u'} connections=['d: [connection X17/d =>[signal: VGND w=1]]', 'g: [connection X17/g =>[signal: a_27_47# w=1]]', 's: [connection X17/s =>[signal: a_193_47# w=1]]', 'b: [connection X17/b =>[signal: VNB w=1]]']]
X__63__17 VGND _63__a_27_47# _63__a_193_47# no_conn_82 sky130_fd_pr__nfet_01v8 w=420000u l=150000u
** [instance X18 of sky130_fd_pr__nfet_01v8, params={'w': '360000u', 'l': '150000u'} connections=['d: [connection X18/d =>[signal: a_381_47# w=1]]', 'g: [connection X18/g =>[signal: a_27_47# w=1]]', 's: [connection X18/s =>[signal: a_466_413# w=1]]', 'b: [connection X18/b =>[signal: VNB w=1]]']]
X__63__18 _63__a_381_47# _63__a_27_47# _63__a_466_413# no_conn_82 sky130_fd_pr__nfet_01v8 w=360000u l=150000u
** [instance X19 of sky130_fd_pr__nfet_01v8, params={'w': '420000u', 'l': '150000u'} connections=['d: [connection X19/d =>[signal: a_27_47# w=1]]', 'g: [connection X19/g =>[signal: CLK w=1]]', 's: [connection X19/s =>[signal: VGND w=1]]', 'b: [connection X19/b =>[signal: VNB w=1]]']]
X__63__19 _63__a_27_47# _63_:CLK VGND no_conn_82 sky130_fd_pr__nfet_01v8 w=420000u l=150000u
** [instance X20 of sky130_fd_pr__pfet_01v8_hvt, params={'w': '640000u', 'l': '150000u'} connections=['d: [connection X20/d =>[signal: a_27_47# w=1]]', 'g: [connection X20/g =>[signal: CLK w=1]]', 's: [connection X20/s =>[signal: VPWR w=1]]', 'b: [connection X20/b =>[signal: VPB w=1]]']]
X__63__20 _63__a_27_47# _63_:CLK VPWR no_conn_83 sky130_fd_pr__pfet_01v8_hvt w=640000u l=150000u
** [instance X21 of sky130_fd_pr__nfet_01v8, params={'w': '650000u', 'l': '150000u'} connections=['d: [connection X21/d =>[signal: Q w=1]]', 'g: [connection X21/g =>[signal: a_1059_315# w=1]]', 's: [connection X21/s =>[signal: VGND w=1]]', 'b: [connection X21/b =>[signal: VNB w=1]]']]
X__63__21 _63_:Q _63__a_1059_315# VGND no_conn_82 sky130_fd_pr__nfet_01v8 w=650000u l=150000u
** [instance X22 of sky130_fd_pr__pfet_01v8_hvt, params={'w': '640000u', 'l': '150000u'} connections=['d: [connection X22/d =>[signal: VPWR w=1]]', 'g: [connection X22/g =>[signal: a_27_47# w=1]]', 's: [connection X22/s =>[signal: a_193_47# w=1]]', 'b: [connection X22/b =>[signal: VPB w=1]]']]
X__63__22 VPWR _63__a_27_47# _63__a_193_47# no_conn_83 sky130_fd_pr__pfet_01v8_hvt w=640000u l=150000u
** [instance X23 of sky130_fd_pr__nfet_01v8, params={'w': '420000u', 'l': '150000u'} connections=['d: [connection X23/d =>[signal: VGND w=1]]', 'g: [connection X23/g =>[signal: D w=1]]', 's: [connection X23/s =>[signal: a_381_47# w=1]]', 'b: [connection X23/b =>[signal: VNB w=1]]']]
X__63__23 VGND _63_:D _63__a_381_47# no_conn_82 sky130_fd_pr__nfet_01v8 w=420000u l=150000u
** [instance X24 of sky130_fd_pr__pfet_01v8_hvt, params={'w': '420000u', 'l': '150000u'} connections=['d: [connection X24/d =>[signal: a_975_413# w=1]]', 'g: [connection X24/g =>[signal: a_1059_315# w=1]]', 's: [connection X24/s =>[signal: VPWR w=1]]', 'b: [connection X24/b =>[signal: VPB w=1]]']]
X__63__24 _63__a_975_413# _63__a_1059_315# VPWR no_conn_83 sky130_fd_pr__pfet_01v8_hvt w=420000u l=150000u
** [instance X25 of sky130_fd_pr__nfet_01v8, params={'w': '650000u', 'l': '150000u'} connections=['d: [connection X25/d =>[signal: VGND w=1]]', 'g: [connection X25/g =>[signal: a_1059_315# w=1]]', 's: [connection X25/s =>[signal: Q w=1]]', 'b: [connection X25/b =>[signal: VNB w=1]]']]
X__63__25 VGND _63__a_1059_315# _63_:Q no_conn_82 sky130_fd_pr__nfet_01v8 w=650000u l=150000u

** replacing _45_ with the contents of sky130_fd_sc_hd__mux2_1
** [instance X0 of sky130_fd_pr__pfet_01v8_hvt, params={'w': '420000u', 'l': '150000u'} connections=['d: [connection X0/d =>[signal: VPWR w=1]]', 'g: [connection X0/g =>[signal: S w=1]]', 's: [connection X0/s =>[signal: a_218_374# w=1]]', 'b: [connection X0/b =>[signal: VPB w=1]]']]
X__45__0 VPWR _45_:S _45__a_218_374# no_conn_85 sky130_fd_pr__pfet_01v8_hvt w=420000u l=150000u
** [instance X1 of sky130_fd_pr__nfet_01v8, params={'w': '420000u', 'l': '150000u'} connections=['d: [connection X1/d =>[signal: a_76_199# w=1]]', 'g: [connection X1/g =>[signal: A0 w=1]]', 's: [connection X1/s =>[signal: a_439_47# w=1]]', 'b: [connection X1/b =>[signal: VNB w=1]]']]
X__45__1 _45__a_76_199# _45_:A0 _45__a_439_47# no_conn_84 sky130_fd_pr__nfet_01v8 w=420000u l=150000u
** [instance X2 of sky130_fd_pr__pfet_01v8_hvt, params={'w': '420000u', 'l': '150000u'} connections=['d: [connection X2/d =>[signal: a_535_374# w=1]]', 'g: [connection X2/g =>[signal: a_505_21# w=1]]', 's: [connection X2/s =>[signal: VPWR w=1]]', 'b: [connection X2/b =>[signal: VPB w=1]]']]
X__45__2 _45__a_535_374# _45__a_505_21# VPWR no_conn_85 sky130_fd_pr__pfet_01v8_hvt w=420000u l=150000u
** [instance X3 of sky130_fd_pr__pfet_01v8_hvt, params={'w': '420000u', 'l': '150000u'} connections=['d: [connection X3/d =>[signal: VPWR w=1]]', 'g: [connection X3/g =>[signal: S w=1]]', 's: [connection X3/s =>[signal: a_505_21# w=1]]', 'b: [connection X3/b =>[signal: VPB w=1]]']]
X__45__3 VPWR _45_:S _45__a_505_21# no_conn_85 sky130_fd_pr__pfet_01v8_hvt w=420000u l=150000u
** [instance X4 of sky130_fd_pr__pfet_01v8_hvt, params={'w': '420000u', 'l': '150000u'} connections=['d: [connection X4/d =>[signal: a_76_199# w=1]]', 'g: [connection X4/g =>[signal: A1 w=1]]', 's: [connection X4/s =>[signal: a_535_374# w=1]]', 'b: [connection X4/b =>[signal: VPB w=1]]']]
X__45__4 _45__a_76_199# _45_:A1 _45__a_535_374# no_conn_85 sky130_fd_pr__pfet_01v8_hvt w=420000u l=150000u
** [instance X5 of sky130_fd_pr__nfet_01v8, params={'w': '420000u', 'l': '150000u'} connections=['d: [connection X5/d =>[signal: a_218_47# w=1]]', 'g: [connection X5/g =>[signal: A1 w=1]]', 's: [connection X5/s =>[signal: a_76_199# w=1]]', 'b: [connection X5/b =>[signal: VNB w=1]]']]
X__45__5 _45__a_218_47# _45_:A1 _45__a_76_199# no_conn_84 sky130_fd_pr__nfet_01v8 w=420000u l=150000u
** [instance X6 of sky130_fd_pr__pfet_01v8_hvt, params={'w': '420000u', 'l': '150000u'} connections=['d: [connection X6/d =>[signal: a_218_374# w=1]]', 'g: [connection X6/g =>[signal: A0 w=1]]', 's: [connection X6/s =>[signal: a_76_199# w=1]]', 'b: [connection X6/b =>[signal: VPB w=1]]']]
X__45__6 _45__a_218_374# _45_:A0 _45__a_76_199# no_conn_85 sky130_fd_pr__pfet_01v8_hvt w=420000u l=150000u
** [instance X7 of sky130_fd_pr__nfet_01v8, params={'w': '650000u', 'l': '150000u'} connections=['d: [connection X7/d =>[signal: X w=1]]', 'g: [connection X7/g =>[signal: a_76_199# w=1]]', 's: [connection X7/s =>[signal: VGND w=1]]', 'b: [connection X7/b =>[signal: VNB w=1]]']]
X__45__7 _45_:X _45__a_76_199# VGND no_conn_84 sky130_fd_pr__nfet_01v8 w=650000u l=150000u
** [instance X8 of sky130_fd_pr__pfet_01v8_hvt, params={'w': '1e+06u', 'l': '150000u'} connections=['d: [connection X8/d =>[signal: X w=1]]', 'g: [connection X8/g =>[signal: a_76_199# w=1]]', 's: [connection X8/s =>[signal: VPWR w=1]]', 'b: [connection X8/b =>[signal: VPB w=1]]']]
X__45__8 _45_:X _45__a_76_199# VPWR no_conn_85 sky130_fd_pr__pfet_01v8_hvt w=1e+06u l=150000u
** [instance X9 of sky130_fd_pr__nfet_01v8, params={'w': '420000u', 'l': '150000u'} connections=['d: [connection X9/d =>[signal: VGND w=1]]', 'g: [connection X9/g =>[signal: S w=1]]', 's: [connection X9/s =>[signal: a_218_47# w=1]]', 'b: [connection X9/b =>[signal: VNB w=1]]']]
X__45__9 VGND _45_:S _45__a_218_47# no_conn_84 sky130_fd_pr__nfet_01v8 w=420000u l=150000u
** [instance X10 of sky130_fd_pr__nfet_01v8, params={'w': '420000u', 'l': '150000u'} connections=['d: [connection X10/d =>[signal: VGND w=1]]', 'g: [connection X10/g =>[signal: S w=1]]', 's: [connection X10/s =>[signal: a_505_21# w=1]]', 'b: [connection X10/b =>[signal: VNB w=1]]']]
X__45__10 VGND _45_:S _45__a_505_21# no_conn_84 sky130_fd_pr__nfet_01v8 w=420000u l=150000u
** [instance X11 of sky130_fd_pr__nfet_01v8, params={'w': '420000u', 'l': '150000u'} connections=['d: [connection X11/d =>[signal: a_439_47# w=1]]', 'g: [connection X11/g =>[signal: a_505_21# w=1]]', 's: [connection X11/s =>[signal: VGND w=1]]', 'b: [connection X11/b =>[signal: VNB w=1]]']]
X__45__11 _45__a_439_47# _45__a_505_21# VGND no_conn_84 sky130_fd_pr__nfet_01v8 w=420000u l=150000u

** replacing _46_ with the contents of sky130_fd_sc_hd__mux2_1
** [instance X0 of sky130_fd_pr__pfet_01v8_hvt, params={'w': '420000u', 'l': '150000u'} connections=['d: [connection X0/d =>[signal: VPWR w=1]]', 'g: [connection X0/g =>[signal: S w=1]]', 's: [connection X0/s =>[signal: a_218_374# w=1]]', 'b: [connection X0/b =>[signal: VPB w=1]]']]
X__46__0 VPWR _46_:S _46__a_218_374# no_conn_87 sky130_fd_pr__pfet_01v8_hvt w=420000u l=150000u
** [instance X1 of sky130_fd_pr__nfet_01v8, params={'w': '420000u', 'l': '150000u'} connections=['d: [connection X1/d =>[signal: a_76_199# w=1]]', 'g: [connection X1/g =>[signal: A0 w=1]]', 's: [connection X1/s =>[signal: a_439_47# w=1]]', 'b: [connection X1/b =>[signal: VNB w=1]]']]
X__46__1 _46__a_76_199# _46_:A0 _46__a_439_47# no_conn_86 sky130_fd_pr__nfet_01v8 w=420000u l=150000u
** [instance X2 of sky130_fd_pr__pfet_01v8_hvt, params={'w': '420000u', 'l': '150000u'} connections=['d: [connection X2/d =>[signal: a_535_374# w=1]]', 'g: [connection X2/g =>[signal: a_505_21# w=1]]', 's: [connection X2/s =>[signal: VPWR w=1]]', 'b: [connection X2/b =>[signal: VPB w=1]]']]
X__46__2 _46__a_535_374# _46__a_505_21# VPWR no_conn_87 sky130_fd_pr__pfet_01v8_hvt w=420000u l=150000u
** [instance X3 of sky130_fd_pr__pfet_01v8_hvt, params={'w': '420000u', 'l': '150000u'} connections=['d: [connection X3/d =>[signal: VPWR w=1]]', 'g: [connection X3/g =>[signal: S w=1]]', 's: [connection X3/s =>[signal: a_505_21# w=1]]', 'b: [connection X3/b =>[signal: VPB w=1]]']]
X__46__3 VPWR _46_:S _46__a_505_21# no_conn_87 sky130_fd_pr__pfet_01v8_hvt w=420000u l=150000u
** [instance X4 of sky130_fd_pr__pfet_01v8_hvt, params={'w': '420000u', 'l': '150000u'} connections=['d: [connection X4/d =>[signal: a_76_199# w=1]]', 'g: [connection X4/g =>[signal: A1 w=1]]', 's: [connection X4/s =>[signal: a_535_374# w=1]]', 'b: [connection X4/b =>[signal: VPB w=1]]']]
X__46__4 _46__a_76_199# _46_:A1 _46__a_535_374# no_conn_87 sky130_fd_pr__pfet_01v8_hvt w=420000u l=150000u
** [instance X5 of sky130_fd_pr__nfet_01v8, params={'w': '420000u', 'l': '150000u'} connections=['d: [connection X5/d =>[signal: a_218_47# w=1]]', 'g: [connection X5/g =>[signal: A1 w=1]]', 's: [connection X5/s =>[signal: a_76_199# w=1]]', 'b: [connection X5/b =>[signal: VNB w=1]]']]
X__46__5 _46__a_218_47# _46_:A1 _46__a_76_199# no_conn_86 sky130_fd_pr__nfet_01v8 w=420000u l=150000u
** [instance X6 of sky130_fd_pr__pfet_01v8_hvt, params={'w': '420000u', 'l': '150000u'} connections=['d: [connection X6/d =>[signal: a_218_374# w=1]]', 'g: [connection X6/g =>[signal: A0 w=1]]', 's: [connection X6/s =>[signal: a_76_199# w=1]]', 'b: [connection X6/b =>[signal: VPB w=1]]']]
X__46__6 _46__a_218_374# _46_:A0 _46__a_76_199# no_conn_87 sky130_fd_pr__pfet_01v8_hvt w=420000u l=150000u
** [instance X7 of sky130_fd_pr__nfet_01v8, params={'w': '650000u', 'l': '150000u'} connections=['d: [connection X7/d =>[signal: X w=1]]', 'g: [connection X7/g =>[signal: a_76_199# w=1]]', 's: [connection X7/s =>[signal: VGND w=1]]', 'b: [connection X7/b =>[signal: VNB w=1]]']]
X__46__7 _46_:X _46__a_76_199# VGND no_conn_86 sky130_fd_pr__nfet_01v8 w=650000u l=150000u
** [instance X8 of sky130_fd_pr__pfet_01v8_hvt, params={'w': '1e+06u', 'l': '150000u'} connections=['d: [connection X8/d =>[signal: X w=1]]', 'g: [connection X8/g =>[signal: a_76_199# w=1]]', 's: [connection X8/s =>[signal: VPWR w=1]]', 'b: [connection X8/b =>[signal: VPB w=1]]']]
X__46__8 _46_:X _46__a_76_199# VPWR no_conn_87 sky130_fd_pr__pfet_01v8_hvt w=1e+06u l=150000u
** [instance X9 of sky130_fd_pr__nfet_01v8, params={'w': '420000u', 'l': '150000u'} connections=['d: [connection X9/d =>[signal: VGND w=1]]', 'g: [connection X9/g =>[signal: S w=1]]', 's: [connection X9/s =>[signal: a_218_47# w=1]]', 'b: [connection X9/b =>[signal: VNB w=1]]']]
X__46__9 VGND _46_:S _46__a_218_47# no_conn_86 sky130_fd_pr__nfet_01v8 w=420000u l=150000u
** [instance X10 of sky130_fd_pr__nfet_01v8, params={'w': '420000u', 'l': '150000u'} connections=['d: [connection X10/d =>[signal: VGND w=1]]', 'g: [connection X10/g =>[signal: S w=1]]', 's: [connection X10/s =>[signal: a_505_21# w=1]]', 'b: [connection X10/b =>[signal: VNB w=1]]']]
X__46__10 VGND _46_:S _46__a_505_21# no_conn_86 sky130_fd_pr__nfet_01v8 w=420000u l=150000u
** [instance X11 of sky130_fd_pr__nfet_01v8, params={'w': '420000u', 'l': '150000u'} connections=['d: [connection X11/d =>[signal: a_439_47# w=1]]', 'g: [connection X11/g =>[signal: a_505_21# w=1]]', 's: [connection X11/s =>[signal: VGND w=1]]', 'b: [connection X11/b =>[signal: VNB w=1]]']]
X__46__11 _46__a_439_47# _46__a_505_21# VGND no_conn_86 sky130_fd_pr__nfet_01v8 w=420000u l=150000u

** replacing hold18 with the contents of sky130_fd_sc_hd__dlygate4sd3_1
** [instance X0 of sky130_fd_pr__nfet_01v8, params={'w': '420000u', 'l': '500000u'} connections=['d: [connection X0/d =>[signal: a_391_47# w=1]]', 'g: [connection X0/g =>[signal: a_285_47# w=1]]', 's: [connection X0/s =>[signal: VGND w=1]]', 'b: [connection X0/b =>[signal: VNB w=1]]']]
X_hold18_0 hold18_a_391_47# hold18_a_285_47# VGND no_conn_88 sky130_fd_pr__nfet_01v8 w=420000u l=500000u
** [instance X1 of sky130_fd_pr__pfet_01v8_hvt, params={'w': '420000u', 'l': '500000u'} connections=['d: [connection X1/d =>[signal: VPWR w=1]]', 'g: [connection X1/g =>[signal: a_49_47# w=1]]', 's: [connection X1/s =>[signal: a_285_47# w=1]]', 'b: [connection X1/b =>[signal: VPB w=1]]']]
X_hold18_1 VPWR hold18_a_49_47# hold18_a_285_47# no_conn_89 sky130_fd_pr__pfet_01v8_hvt w=420000u l=500000u
** [instance X2 of sky130_fd_pr__nfet_01v8, params={'w': '420000u', 'l': '150000u'} connections=['d: [connection X2/d =>[signal: a_49_47# w=1]]', 'g: [connection X2/g =>[signal: A w=1]]', 's: [connection X2/s =>[signal: VGND w=1]]', 'b: [connection X2/b =>[signal: VNB w=1]]']]
X_hold18_2 hold18_a_49_47# hold18:A VGND no_conn_88 sky130_fd_pr__nfet_01v8 w=420000u l=150000u
** [instance X3 of sky130_fd_pr__pfet_01v8_hvt, params={'w': '1e+06u', 'l': '150000u'} connections=['d: [connection X3/d =>[signal: VPWR w=1]]', 'g: [connection X3/g =>[signal: a_391_47# w=1]]', 's: [connection X3/s =>[signal: X w=1]]', 'b: [connection X3/b =>[signal: VPB w=1]]']]
X_hold18_3 VPWR hold18_a_391_47# hold18:X no_conn_89 sky130_fd_pr__pfet_01v8_hvt w=1e+06u l=150000u
** [instance X4 of sky130_fd_pr__nfet_01v8, params={'w': '650000u', 'l': '150000u'} connections=['d: [connection X4/d =>[signal: VGND w=1]]', 'g: [connection X4/g =>[signal: a_391_47# w=1]]', 's: [connection X4/s =>[signal: X w=1]]', 'b: [connection X4/b =>[signal: VNB w=1]]']]
X_hold18_4 VGND hold18_a_391_47# hold18:X no_conn_88 sky130_fd_pr__nfet_01v8 w=650000u l=150000u
** [instance X5 of sky130_fd_pr__nfet_01v8, params={'w': '420000u', 'l': '500000u'} connections=['d: [connection X5/d =>[signal: VGND w=1]]', 'g: [connection X5/g =>[signal: a_49_47# w=1]]', 's: [connection X5/s =>[signal: a_285_47# w=1]]', 'b: [connection X5/b =>[signal: VNB w=1]]']]
X_hold18_5 VGND hold18_a_49_47# hold18_a_285_47# no_conn_88 sky130_fd_pr__nfet_01v8 w=420000u l=500000u
** [instance X6 of sky130_fd_pr__pfet_01v8_hvt, params={'w': '420000u', 'l': '500000u'} connections=['d: [connection X6/d =>[signal: a_391_47# w=1]]', 'g: [connection X6/g =>[signal: a_285_47# w=1]]', 's: [connection X6/s =>[signal: VPWR w=1]]', 'b: [connection X6/b =>[signal: VPB w=1]]']]
X_hold18_6 hold18_a_391_47# hold18_a_285_47# VPWR no_conn_89 sky130_fd_pr__pfet_01v8_hvt w=420000u l=500000u
** [instance X7 of sky130_fd_pr__pfet_01v8_hvt, params={'w': '420000u', 'l': '150000u'} connections=['d: [connection X7/d =>[signal: a_49_47# w=1]]', 'g: [connection X7/g =>[signal: A w=1]]', 's: [connection X7/s =>[signal: VPWR w=1]]', 'b: [connection X7/b =>[signal: VPB w=1]]']]
X_hold18_7 hold18_a_49_47# hold18:A VPWR no_conn_89 sky130_fd_pr__pfet_01v8_hvt w=420000u l=150000u

** replacing hold15 with the contents of sky130_fd_sc_hd__dlygate4sd3_1
** [instance X0 of sky130_fd_pr__nfet_01v8, params={'w': '420000u', 'l': '500000u'} connections=['d: [connection X0/d =>[signal: a_391_47# w=1]]', 'g: [connection X0/g =>[signal: a_285_47# w=1]]', 's: [connection X0/s =>[signal: VGND w=1]]', 'b: [connection X0/b =>[signal: VNB w=1]]']]
X_hold15_0 hold15_a_391_47# hold15_a_285_47# VGND no_conn_90 sky130_fd_pr__nfet_01v8 w=420000u l=500000u
** [instance X1 of sky130_fd_pr__pfet_01v8_hvt, params={'w': '420000u', 'l': '500000u'} connections=['d: [connection X1/d =>[signal: VPWR w=1]]', 'g: [connection X1/g =>[signal: a_49_47# w=1]]', 's: [connection X1/s =>[signal: a_285_47# w=1]]', 'b: [connection X1/b =>[signal: VPB w=1]]']]
X_hold15_1 VPWR hold15_a_49_47# hold15_a_285_47# no_conn_91 sky130_fd_pr__pfet_01v8_hvt w=420000u l=500000u
** [instance X2 of sky130_fd_pr__nfet_01v8, params={'w': '420000u', 'l': '150000u'} connections=['d: [connection X2/d =>[signal: a_49_47# w=1]]', 'g: [connection X2/g =>[signal: A w=1]]', 's: [connection X2/s =>[signal: VGND w=1]]', 'b: [connection X2/b =>[signal: VNB w=1]]']]
X_hold15_2 hold15_a_49_47# hold15:A VGND no_conn_90 sky130_fd_pr__nfet_01v8 w=420000u l=150000u
** [instance X3 of sky130_fd_pr__pfet_01v8_hvt, params={'w': '1e+06u', 'l': '150000u'} connections=['d: [connection X3/d =>[signal: VPWR w=1]]', 'g: [connection X3/g =>[signal: a_391_47# w=1]]', 's: [connection X3/s =>[signal: X w=1]]', 'b: [connection X3/b =>[signal: VPB w=1]]']]
X_hold15_3 VPWR hold15_a_391_47# hold15:X no_conn_91 sky130_fd_pr__pfet_01v8_hvt w=1e+06u l=150000u
** [instance X4 of sky130_fd_pr__nfet_01v8, params={'w': '650000u', 'l': '150000u'} connections=['d: [connection X4/d =>[signal: VGND w=1]]', 'g: [connection X4/g =>[signal: a_391_47# w=1]]', 's: [connection X4/s =>[signal: X w=1]]', 'b: [connection X4/b =>[signal: VNB w=1]]']]
X_hold15_4 VGND hold15_a_391_47# hold15:X no_conn_90 sky130_fd_pr__nfet_01v8 w=650000u l=150000u
** [instance X5 of sky130_fd_pr__nfet_01v8, params={'w': '420000u', 'l': '500000u'} connections=['d: [connection X5/d =>[signal: VGND w=1]]', 'g: [connection X5/g =>[signal: a_49_47# w=1]]', 's: [connection X5/s =>[signal: a_285_47# w=1]]', 'b: [connection X5/b =>[signal: VNB w=1]]']]
X_hold15_5 VGND hold15_a_49_47# hold15_a_285_47# no_conn_90 sky130_fd_pr__nfet_01v8 w=420000u l=500000u
** [instance X6 of sky130_fd_pr__pfet_01v8_hvt, params={'w': '420000u', 'l': '500000u'} connections=['d: [connection X6/d =>[signal: a_391_47# w=1]]', 'g: [connection X6/g =>[signal: a_285_47# w=1]]', 's: [connection X6/s =>[signal: VPWR w=1]]', 'b: [connection X6/b =>[signal: VPB w=1]]']]
X_hold15_6 hold15_a_391_47# hold15_a_285_47# VPWR no_conn_91 sky130_fd_pr__pfet_01v8_hvt w=420000u l=500000u
** [instance X7 of sky130_fd_pr__pfet_01v8_hvt, params={'w': '420000u', 'l': '150000u'} connections=['d: [connection X7/d =>[signal: a_49_47# w=1]]', 'g: [connection X7/g =>[signal: A w=1]]', 's: [connection X7/s =>[signal: VPWR w=1]]', 'b: [connection X7/b =>[signal: VPB w=1]]']]
X_hold15_7 hold15_a_49_47# hold15:A VPWR no_conn_91 sky130_fd_pr__pfet_01v8_hvt w=420000u l=150000u

** replacing _65_ with the contents of sky130_fd_sc_hd__dfxtp_2
** [instance X0 of sky130_fd_pr__pfet_01v8_hvt, params={'w': '420000u', 'l': '150000u'} connections=['d: [connection X0/d =>[signal: a_891_413# w=1]]', 'g: [connection X0/g =>[signal: a_193_47# w=1]]', 's: [connection X0/s =>[signal: a_975_413# w=1]]', 'b: [connection X0/b =>[signal: VPB w=1]]']]
X__65__0 _65__a_891_413# _65__a_193_47# _65__a_975_413# no_conn_93 sky130_fd_pr__pfet_01v8_hvt w=420000u l=150000u
** [instance X1 of sky130_fd_pr__nfet_01v8, params={'w': '650000u', 'l': '150000u'} connections=['d: [connection X1/d =>[signal: a_1059_315# w=1]]', 'g: [connection X1/g =>[signal: a_891_413# w=1]]', 's: [connection X1/s =>[signal: VGND w=1]]', 'b: [connection X1/b =>[signal: VNB w=1]]']]
X__65__1 _65__a_1059_315# _65__a_891_413# VGND no_conn_92 sky130_fd_pr__nfet_01v8 w=650000u l=150000u
** [instance X2 of sky130_fd_pr__pfet_01v8_hvt, params={'w': '420000u', 'l': '150000u'} connections=['d: [connection X2/d =>[signal: a_466_413# w=1]]', 'g: [connection X2/g =>[signal: a_27_47# w=1]]', 's: [connection X2/s =>[signal: a_561_413# w=1]]', 'b: [connection X2/b =>[signal: VPB w=1]]']]
X__65__2 _65__a_466_413# _65__a_27_47# _65__a_561_413# no_conn_93 sky130_fd_pr__pfet_01v8_hvt w=420000u l=150000u
** [instance X3 of sky130_fd_pr__pfet_01v8_hvt, params={'w': '420000u', 'l': '150000u'} connections=['d: [connection X3/d =>[signal: a_634_159# w=1]]', 'g: [connection X3/g =>[signal: a_27_47# w=1]]', 's: [connection X3/s =>[signal: a_891_413# w=1]]', 'b: [connection X3/b =>[signal: VPB w=1]]']]
X__65__3 _65__a_634_159# _65__a_27_47# _65__a_891_413# no_conn_93 sky130_fd_pr__pfet_01v8_hvt w=420000u l=150000u
** [instance X4 of sky130_fd_pr__pfet_01v8_hvt, params={'w': '420000u', 'l': '150000u'} connections=['d: [connection X4/d =>[signal: a_381_47# w=1]]', 'g: [connection X4/g =>[signal: a_193_47# w=1]]', 's: [connection X4/s =>[signal: a_466_413# w=1]]', 'b: [connection X4/b =>[signal: VPB w=1]]']]
X__65__4 _65__a_381_47# _65__a_193_47# _65__a_466_413# no_conn_93 sky130_fd_pr__pfet_01v8_hvt w=420000u l=150000u
** [instance X5 of sky130_fd_pr__pfet_01v8_hvt, params={'w': '420000u', 'l': '150000u'} connections=['d: [connection X5/d =>[signal: VPWR w=1]]', 'g: [connection X5/g =>[signal: D w=1]]', 's: [connection X5/s =>[signal: a_381_47# w=1]]', 'b: [connection X5/b =>[signal: VPB w=1]]']]
X__65__5 VPWR _65_:D _65__a_381_47# no_conn_93 sky130_fd_pr__pfet_01v8_hvt w=420000u l=150000u
** [instance X6 of sky130_fd_pr__pfet_01v8_hvt, params={'w': '750000u', 'l': '150000u'} connections=['d: [connection X6/d =>[signal: VPWR w=1]]', 'g: [connection X6/g =>[signal: a_466_413# w=1]]', 's: [connection X6/s =>[signal: a_634_159# w=1]]', 'b: [connection X6/b =>[signal: VPB w=1]]']]
X__65__6 VPWR _65__a_466_413# _65__a_634_159# no_conn_93 sky130_fd_pr__pfet_01v8_hvt w=750000u l=150000u
** [instance X7 of sky130_fd_pr__nfet_01v8, params={'w': '640000u', 'l': '150000u'} connections=['d: [connection X7/d =>[signal: VGND w=1]]', 'g: [connection X7/g =>[signal: a_466_413# w=1]]', 's: [connection X7/s =>[signal: a_634_159# w=1]]', 'b: [connection X7/b =>[signal: VNB w=1]]']]
X__65__7 VGND _65__a_466_413# _65__a_634_159# no_conn_92 sky130_fd_pr__nfet_01v8 w=640000u l=150000u
** [instance X8 of sky130_fd_pr__nfet_01v8, params={'w': '420000u', 'l': '150000u'} connections=['d: [connection X8/d =>[signal: a_1017_47# w=1]]', 'g: [connection X8/g =>[signal: a_1059_315# w=1]]', 's: [connection X8/s =>[signal: VGND w=1]]', 'b: [connection X8/b =>[signal: VNB w=1]]']]
X__65__8 _65__a_1017_47# _65__a_1059_315# VGND no_conn_92 sky130_fd_pr__nfet_01v8 w=420000u l=150000u
** [instance X9 of sky130_fd_pr__pfet_01v8_hvt, params={'w': '1e+06u', 'l': '150000u'} connections=['d: [connection X9/d =>[signal: a_1059_315# w=1]]', 'g: [connection X9/g =>[signal: a_891_413# w=1]]', 's: [connection X9/s =>[signal: VPWR w=1]]', 'b: [connection X9/b =>[signal: VPB w=1]]']]
X__65__9 _65__a_1059_315# _65__a_891_413# VPWR no_conn_93 sky130_fd_pr__pfet_01v8_hvt w=1e+06u l=150000u
** [instance X10 of sky130_fd_pr__pfet_01v8_hvt, params={'w': '1e+06u', 'l': '150000u'} connections=['d: [connection X10/d =>[signal: Q w=1]]', 'g: [connection X10/g =>[signal: a_1059_315# w=1]]', 's: [connection X10/s =>[signal: VPWR w=1]]', 'b: [connection X10/b =>[signal: VPB w=1]]']]
X__65__10 _65_:Q _65__a_1059_315# VPWR no_conn_93 sky130_fd_pr__pfet_01v8_hvt w=1e+06u l=150000u
** [instance X11 of sky130_fd_pr__pfet_01v8_hvt, params={'w': '420000u', 'l': '150000u'} connections=['d: [connection X11/d =>[signal: a_561_413# w=1]]', 'g: [connection X11/g =>[signal: a_634_159# w=1]]', 's: [connection X11/s =>[signal: VPWR w=1]]', 'b: [connection X11/b =>[signal: VPB w=1]]']]
X__65__11 _65__a_561_413# _65__a_634_159# VPWR no_conn_93 sky130_fd_pr__pfet_01v8_hvt w=420000u l=150000u
** [instance X12 of sky130_fd_pr__pfet_01v8_hvt, params={'w': '1e+06u', 'l': '150000u'} connections=['d: [connection X12/d =>[signal: VPWR w=1]]', 'g: [connection X12/g =>[signal: a_1059_315# w=1]]', 's: [connection X12/s =>[signal: Q w=1]]', 'b: [connection X12/b =>[signal: VPB w=1]]']]
X__65__12 VPWR _65__a_1059_315# _65_:Q no_conn_93 sky130_fd_pr__pfet_01v8_hvt w=1e+06u l=150000u
** [instance X13 of sky130_fd_pr__nfet_01v8, params={'w': '360000u', 'l': '150000u'} connections=['d: [connection X13/d =>[signal: a_891_413# w=1]]', 'g: [connection X13/g =>[signal: a_27_47# w=1]]', 's: [connection X13/s =>[signal: a_1017_47# w=1]]', 'b: [connection X13/b =>[signal: VNB w=1]]']]
X__65__13 _65__a_891_413# _65__a_27_47# _65__a_1017_47# no_conn_92 sky130_fd_pr__nfet_01v8 w=360000u l=150000u
** [instance X14 of sky130_fd_pr__nfet_01v8, params={'w': '360000u', 'l': '150000u'} connections=['d: [connection X14/d =>[signal: a_634_159# w=1]]', 'g: [connection X14/g =>[signal: a_193_47# w=1]]', 's: [connection X14/s =>[signal: a_891_413# w=1]]', 'b: [connection X14/b =>[signal: VNB w=1]]']]
X__65__14 _65__a_634_159# _65__a_193_47# _65__a_891_413# no_conn_92 sky130_fd_pr__nfet_01v8 w=360000u l=150000u
** [instance X15 of sky130_fd_pr__nfet_01v8, params={'w': '420000u', 'l': '150000u'} connections=['d: [connection X15/d =>[signal: a_592_47# w=1]]', 'g: [connection X15/g =>[signal: a_634_159# w=1]]', 's: [connection X15/s =>[signal: VGND w=1]]', 'b: [connection X15/b =>[signal: VNB w=1]]']]
X__65__15 _65__a_592_47# _65__a_634_159# VGND no_conn_92 sky130_fd_pr__nfet_01v8 w=420000u l=150000u
** [instance X16 of sky130_fd_pr__nfet_01v8, params={'w': '360000u', 'l': '150000u'} connections=['d: [connection X16/d =>[signal: a_466_413# w=1]]', 'g: [connection X16/g =>[signal: a_193_47# w=1]]', 's: [connection X16/s =>[signal: a_592_47# w=1]]', 'b: [connection X16/b =>[signal: VNB w=1]]']]
X__65__16 _65__a_466_413# _65__a_193_47# _65__a_592_47# no_conn_92 sky130_fd_pr__nfet_01v8 w=360000u l=150000u
** [instance X17 of sky130_fd_pr__nfet_01v8, params={'w': '420000u', 'l': '150000u'} connections=['d: [connection X17/d =>[signal: VGND w=1]]', 'g: [connection X17/g =>[signal: a_27_47# w=1]]', 's: [connection X17/s =>[signal: a_193_47# w=1]]', 'b: [connection X17/b =>[signal: VNB w=1]]']]
X__65__17 VGND _65__a_27_47# _65__a_193_47# no_conn_92 sky130_fd_pr__nfet_01v8 w=420000u l=150000u
** [instance X18 of sky130_fd_pr__nfet_01v8, params={'w': '360000u', 'l': '150000u'} connections=['d: [connection X18/d =>[signal: a_381_47# w=1]]', 'g: [connection X18/g =>[signal: a_27_47# w=1]]', 's: [connection X18/s =>[signal: a_466_413# w=1]]', 'b: [connection X18/b =>[signal: VNB w=1]]']]
X__65__18 _65__a_381_47# _65__a_27_47# _65__a_466_413# no_conn_92 sky130_fd_pr__nfet_01v8 w=360000u l=150000u
** [instance X19 of sky130_fd_pr__nfet_01v8, params={'w': '420000u', 'l': '150000u'} connections=['d: [connection X19/d =>[signal: a_27_47# w=1]]', 'g: [connection X19/g =>[signal: CLK w=1]]', 's: [connection X19/s =>[signal: VGND w=1]]', 'b: [connection X19/b =>[signal: VNB w=1]]']]
X__65__19 _65__a_27_47# _65_:CLK VGND no_conn_92 sky130_fd_pr__nfet_01v8 w=420000u l=150000u
** [instance X20 of sky130_fd_pr__pfet_01v8_hvt, params={'w': '640000u', 'l': '150000u'} connections=['d: [connection X20/d =>[signal: a_27_47# w=1]]', 'g: [connection X20/g =>[signal: CLK w=1]]', 's: [connection X20/s =>[signal: VPWR w=1]]', 'b: [connection X20/b =>[signal: VPB w=1]]']]
X__65__20 _65__a_27_47# _65_:CLK VPWR no_conn_93 sky130_fd_pr__pfet_01v8_hvt w=640000u l=150000u
** [instance X21 of sky130_fd_pr__nfet_01v8, params={'w': '650000u', 'l': '150000u'} connections=['d: [connection X21/d =>[signal: Q w=1]]', 'g: [connection X21/g =>[signal: a_1059_315# w=1]]', 's: [connection X21/s =>[signal: VGND w=1]]', 'b: [connection X21/b =>[signal: VNB w=1]]']]
X__65__21 _65_:Q _65__a_1059_315# VGND no_conn_92 sky130_fd_pr__nfet_01v8 w=650000u l=150000u
** [instance X22 of sky130_fd_pr__pfet_01v8_hvt, params={'w': '640000u', 'l': '150000u'} connections=['d: [connection X22/d =>[signal: VPWR w=1]]', 'g: [connection X22/g =>[signal: a_27_47# w=1]]', 's: [connection X22/s =>[signal: a_193_47# w=1]]', 'b: [connection X22/b =>[signal: VPB w=1]]']]
X__65__22 VPWR _65__a_27_47# _65__a_193_47# no_conn_93 sky130_fd_pr__pfet_01v8_hvt w=640000u l=150000u
** [instance X23 of sky130_fd_pr__nfet_01v8, params={'w': '420000u', 'l': '150000u'} connections=['d: [connection X23/d =>[signal: VGND w=1]]', 'g: [connection X23/g =>[signal: D w=1]]', 's: [connection X23/s =>[signal: a_381_47# w=1]]', 'b: [connection X23/b =>[signal: VNB w=1]]']]
X__65__23 VGND _65_:D _65__a_381_47# no_conn_92 sky130_fd_pr__nfet_01v8 w=420000u l=150000u
** [instance X24 of sky130_fd_pr__pfet_01v8_hvt, params={'w': '420000u', 'l': '150000u'} connections=['d: [connection X24/d =>[signal: a_975_413# w=1]]', 'g: [connection X24/g =>[signal: a_1059_315# w=1]]', 's: [connection X24/s =>[signal: VPWR w=1]]', 'b: [connection X24/b =>[signal: VPB w=1]]']]
X__65__24 _65__a_975_413# _65__a_1059_315# VPWR no_conn_93 sky130_fd_pr__pfet_01v8_hvt w=420000u l=150000u
** [instance X25 of sky130_fd_pr__nfet_01v8, params={'w': '650000u', 'l': '150000u'} connections=['d: [connection X25/d =>[signal: VGND w=1]]', 'g: [connection X25/g =>[signal: a_1059_315# w=1]]', 's: [connection X25/s =>[signal: Q w=1]]', 'b: [connection X25/b =>[signal: VNB w=1]]']]
X__65__25 VGND _65__a_1059_315# _65_:Q no_conn_92 sky130_fd_pr__nfet_01v8 w=650000u l=150000u

** replacing _47_ with the contents of sky130_fd_sc_hd__mux2_1
** [instance X0 of sky130_fd_pr__pfet_01v8_hvt, params={'w': '420000u', 'l': '150000u'} connections=['d: [connection X0/d =>[signal: VPWR w=1]]', 'g: [connection X0/g =>[signal: S w=1]]', 's: [connection X0/s =>[signal: a_218_374# w=1]]', 'b: [connection X0/b =>[signal: VPB w=1]]']]
X__47__0 VPWR _47_:S _47__a_218_374# no_conn_95 sky130_fd_pr__pfet_01v8_hvt w=420000u l=150000u
** [instance X1 of sky130_fd_pr__nfet_01v8, params={'w': '420000u', 'l': '150000u'} connections=['d: [connection X1/d =>[signal: a_76_199# w=1]]', 'g: [connection X1/g =>[signal: A0 w=1]]', 's: [connection X1/s =>[signal: a_439_47# w=1]]', 'b: [connection X1/b =>[signal: VNB w=1]]']]
X__47__1 _47__a_76_199# _47_:A0 _47__a_439_47# no_conn_94 sky130_fd_pr__nfet_01v8 w=420000u l=150000u
** [instance X2 of sky130_fd_pr__pfet_01v8_hvt, params={'w': '420000u', 'l': '150000u'} connections=['d: [connection X2/d =>[signal: a_535_374# w=1]]', 'g: [connection X2/g =>[signal: a_505_21# w=1]]', 's: [connection X2/s =>[signal: VPWR w=1]]', 'b: [connection X2/b =>[signal: VPB w=1]]']]
X__47__2 _47__a_535_374# _47__a_505_21# VPWR no_conn_95 sky130_fd_pr__pfet_01v8_hvt w=420000u l=150000u
** [instance X3 of sky130_fd_pr__pfet_01v8_hvt, params={'w': '420000u', 'l': '150000u'} connections=['d: [connection X3/d =>[signal: VPWR w=1]]', 'g: [connection X3/g =>[signal: S w=1]]', 's: [connection X3/s =>[signal: a_505_21# w=1]]', 'b: [connection X3/b =>[signal: VPB w=1]]']]
X__47__3 VPWR _47_:S _47__a_505_21# no_conn_95 sky130_fd_pr__pfet_01v8_hvt w=420000u l=150000u
** [instance X4 of sky130_fd_pr__pfet_01v8_hvt, params={'w': '420000u', 'l': '150000u'} connections=['d: [connection X4/d =>[signal: a_76_199# w=1]]', 'g: [connection X4/g =>[signal: A1 w=1]]', 's: [connection X4/s =>[signal: a_535_374# w=1]]', 'b: [connection X4/b =>[signal: VPB w=1]]']]
X__47__4 _47__a_76_199# _47_:A1 _47__a_535_374# no_conn_95 sky130_fd_pr__pfet_01v8_hvt w=420000u l=150000u
** [instance X5 of sky130_fd_pr__nfet_01v8, params={'w': '420000u', 'l': '150000u'} connections=['d: [connection X5/d =>[signal: a_218_47# w=1]]', 'g: [connection X5/g =>[signal: A1 w=1]]', 's: [connection X5/s =>[signal: a_76_199# w=1]]', 'b: [connection X5/b =>[signal: VNB w=1]]']]
X__47__5 _47__a_218_47# _47_:A1 _47__a_76_199# no_conn_94 sky130_fd_pr__nfet_01v8 w=420000u l=150000u
** [instance X6 of sky130_fd_pr__pfet_01v8_hvt, params={'w': '420000u', 'l': '150000u'} connections=['d: [connection X6/d =>[signal: a_218_374# w=1]]', 'g: [connection X6/g =>[signal: A0 w=1]]', 's: [connection X6/s =>[signal: a_76_199# w=1]]', 'b: [connection X6/b =>[signal: VPB w=1]]']]
X__47__6 _47__a_218_374# _47_:A0 _47__a_76_199# no_conn_95 sky130_fd_pr__pfet_01v8_hvt w=420000u l=150000u
** [instance X7 of sky130_fd_pr__nfet_01v8, params={'w': '650000u', 'l': '150000u'} connections=['d: [connection X7/d =>[signal: X w=1]]', 'g: [connection X7/g =>[signal: a_76_199# w=1]]', 's: [connection X7/s =>[signal: VGND w=1]]', 'b: [connection X7/b =>[signal: VNB w=1]]']]
X__47__7 _47_:X _47__a_76_199# VGND no_conn_94 sky130_fd_pr__nfet_01v8 w=650000u l=150000u
** [instance X8 of sky130_fd_pr__pfet_01v8_hvt, params={'w': '1e+06u', 'l': '150000u'} connections=['d: [connection X8/d =>[signal: X w=1]]', 'g: [connection X8/g =>[signal: a_76_199# w=1]]', 's: [connection X8/s =>[signal: VPWR w=1]]', 'b: [connection X8/b =>[signal: VPB w=1]]']]
X__47__8 _47_:X _47__a_76_199# VPWR no_conn_95 sky130_fd_pr__pfet_01v8_hvt w=1e+06u l=150000u
** [instance X9 of sky130_fd_pr__nfet_01v8, params={'w': '420000u', 'l': '150000u'} connections=['d: [connection X9/d =>[signal: VGND w=1]]', 'g: [connection X9/g =>[signal: S w=1]]', 's: [connection X9/s =>[signal: a_218_47# w=1]]', 'b: [connection X9/b =>[signal: VNB w=1]]']]
X__47__9 VGND _47_:S _47__a_218_47# no_conn_94 sky130_fd_pr__nfet_01v8 w=420000u l=150000u
** [instance X10 of sky130_fd_pr__nfet_01v8, params={'w': '420000u', 'l': '150000u'} connections=['d: [connection X10/d =>[signal: VGND w=1]]', 'g: [connection X10/g =>[signal: S w=1]]', 's: [connection X10/s =>[signal: a_505_21# w=1]]', 'b: [connection X10/b =>[signal: VNB w=1]]']]
X__47__10 VGND _47_:S _47__a_505_21# no_conn_94 sky130_fd_pr__nfet_01v8 w=420000u l=150000u
** [instance X11 of sky130_fd_pr__nfet_01v8, params={'w': '420000u', 'l': '150000u'} connections=['d: [connection X11/d =>[signal: a_439_47# w=1]]', 'g: [connection X11/g =>[signal: a_505_21# w=1]]', 's: [connection X11/s =>[signal: VGND w=1]]', 'b: [connection X11/b =>[signal: VNB w=1]]']]
X__47__11 _47__a_439_47# _47__a_505_21# VGND no_conn_94 sky130_fd_pr__nfet_01v8 w=420000u l=150000u

** replacing _48_ with the contents of sky130_fd_sc_hd__mux2_1
** [instance X0 of sky130_fd_pr__pfet_01v8_hvt, params={'w': '420000u', 'l': '150000u'} connections=['d: [connection X0/d =>[signal: VPWR w=1]]', 'g: [connection X0/g =>[signal: S w=1]]', 's: [connection X0/s =>[signal: a_218_374# w=1]]', 'b: [connection X0/b =>[signal: VPB w=1]]']]
X__48__0 VPWR _48_:S _48__a_218_374# no_conn_97 sky130_fd_pr__pfet_01v8_hvt w=420000u l=150000u
** [instance X1 of sky130_fd_pr__nfet_01v8, params={'w': '420000u', 'l': '150000u'} connections=['d: [connection X1/d =>[signal: a_76_199# w=1]]', 'g: [connection X1/g =>[signal: A0 w=1]]', 's: [connection X1/s =>[signal: a_439_47# w=1]]', 'b: [connection X1/b =>[signal: VNB w=1]]']]
X__48__1 _48__a_76_199# _48_:A0 _48__a_439_47# no_conn_96 sky130_fd_pr__nfet_01v8 w=420000u l=150000u
** [instance X2 of sky130_fd_pr__pfet_01v8_hvt, params={'w': '420000u', 'l': '150000u'} connections=['d: [connection X2/d =>[signal: a_535_374# w=1]]', 'g: [connection X2/g =>[signal: a_505_21# w=1]]', 's: [connection X2/s =>[signal: VPWR w=1]]', 'b: [connection X2/b =>[signal: VPB w=1]]']]
X__48__2 _48__a_535_374# _48__a_505_21# VPWR no_conn_97 sky130_fd_pr__pfet_01v8_hvt w=420000u l=150000u
** [instance X3 of sky130_fd_pr__pfet_01v8_hvt, params={'w': '420000u', 'l': '150000u'} connections=['d: [connection X3/d =>[signal: VPWR w=1]]', 'g: [connection X3/g =>[signal: S w=1]]', 's: [connection X3/s =>[signal: a_505_21# w=1]]', 'b: [connection X3/b =>[signal: VPB w=1]]']]
X__48__3 VPWR _48_:S _48__a_505_21# no_conn_97 sky130_fd_pr__pfet_01v8_hvt w=420000u l=150000u
** [instance X4 of sky130_fd_pr__pfet_01v8_hvt, params={'w': '420000u', 'l': '150000u'} connections=['d: [connection X4/d =>[signal: a_76_199# w=1]]', 'g: [connection X4/g =>[signal: A1 w=1]]', 's: [connection X4/s =>[signal: a_535_374# w=1]]', 'b: [connection X4/b =>[signal: VPB w=1]]']]
X__48__4 _48__a_76_199# _48_:A1 _48__a_535_374# no_conn_97 sky130_fd_pr__pfet_01v8_hvt w=420000u l=150000u
** [instance X5 of sky130_fd_pr__nfet_01v8, params={'w': '420000u', 'l': '150000u'} connections=['d: [connection X5/d =>[signal: a_218_47# w=1]]', 'g: [connection X5/g =>[signal: A1 w=1]]', 's: [connection X5/s =>[signal: a_76_199# w=1]]', 'b: [connection X5/b =>[signal: VNB w=1]]']]
X__48__5 _48__a_218_47# _48_:A1 _48__a_76_199# no_conn_96 sky130_fd_pr__nfet_01v8 w=420000u l=150000u
** [instance X6 of sky130_fd_pr__pfet_01v8_hvt, params={'w': '420000u', 'l': '150000u'} connections=['d: [connection X6/d =>[signal: a_218_374# w=1]]', 'g: [connection X6/g =>[signal: A0 w=1]]', 's: [connection X6/s =>[signal: a_76_199# w=1]]', 'b: [connection X6/b =>[signal: VPB w=1]]']]
X__48__6 _48__a_218_374# _48_:A0 _48__a_76_199# no_conn_97 sky130_fd_pr__pfet_01v8_hvt w=420000u l=150000u
** [instance X7 of sky130_fd_pr__nfet_01v8, params={'w': '650000u', 'l': '150000u'} connections=['d: [connection X7/d =>[signal: X w=1]]', 'g: [connection X7/g =>[signal: a_76_199# w=1]]', 's: [connection X7/s =>[signal: VGND w=1]]', 'b: [connection X7/b =>[signal: VNB w=1]]']]
X__48__7 _48_:X _48__a_76_199# VGND no_conn_96 sky130_fd_pr__nfet_01v8 w=650000u l=150000u
** [instance X8 of sky130_fd_pr__pfet_01v8_hvt, params={'w': '1e+06u', 'l': '150000u'} connections=['d: [connection X8/d =>[signal: X w=1]]', 'g: [connection X8/g =>[signal: a_76_199# w=1]]', 's: [connection X8/s =>[signal: VPWR w=1]]', 'b: [connection X8/b =>[signal: VPB w=1]]']]
X__48__8 _48_:X _48__a_76_199# VPWR no_conn_97 sky130_fd_pr__pfet_01v8_hvt w=1e+06u l=150000u
** [instance X9 of sky130_fd_pr__nfet_01v8, params={'w': '420000u', 'l': '150000u'} connections=['d: [connection X9/d =>[signal: VGND w=1]]', 'g: [connection X9/g =>[signal: S w=1]]', 's: [connection X9/s =>[signal: a_218_47# w=1]]', 'b: [connection X9/b =>[signal: VNB w=1]]']]
X__48__9 VGND _48_:S _48__a_218_47# no_conn_96 sky130_fd_pr__nfet_01v8 w=420000u l=150000u
** [instance X10 of sky130_fd_pr__nfet_01v8, params={'w': '420000u', 'l': '150000u'} connections=['d: [connection X10/d =>[signal: VGND w=1]]', 'g: [connection X10/g =>[signal: S w=1]]', 's: [connection X10/s =>[signal: a_505_21# w=1]]', 'b: [connection X10/b =>[signal: VNB w=1]]']]
X__48__10 VGND _48_:S _48__a_505_21# no_conn_96 sky130_fd_pr__nfet_01v8 w=420000u l=150000u
** [instance X11 of sky130_fd_pr__nfet_01v8, params={'w': '420000u', 'l': '150000u'} connections=['d: [connection X11/d =>[signal: a_439_47# w=1]]', 'g: [connection X11/g =>[signal: a_505_21# w=1]]', 's: [connection X11/s =>[signal: VGND w=1]]', 'b: [connection X11/b =>[signal: VNB w=1]]']]
X__48__11 _48__a_439_47# _48__a_505_21# VGND no_conn_96 sky130_fd_pr__nfet_01v8 w=420000u l=150000u

** replacing _36_ with the contents of sky130_fd_sc_hd__mux4_2
** [instance X0 of sky130_fd_pr__pfet_01v8_hvt, params={'w': '640000u', 'l': '150000u'} connections=['d: [connection X0/d =>[signal: VPWR w=1]]', 'g: [connection X0/g =>[signal: A1 w=1]]', 's: [connection X0/s =>[signal: a_1060_369# w=1]]', 'b: [connection X0/b =>[signal: VPB w=1]]']]
X__36__0 VPWR _36_:A1 _36__a_1060_369# no_conn_99 sky130_fd_pr__pfet_01v8_hvt w=640000u l=150000u
** [instance X1 of sky130_fd_pr__nfet_01v8, params={'w': '360000u', 'l': '150000u'} connections=['d: [connection X1/d =>[signal: a_193_47# w=1]]', 'g: [connection X1/g =>[signal: a_27_47# w=1]]', 's: [connection X1/s =>[signal: a_288_47# w=1]]', 'b: [connection X1/b =>[signal: VNB w=1]]']]
X__36__1 _36__a_193_47# _36__a_27_47# _36__a_288_47# no_conn_98 sky130_fd_pr__nfet_01v8 w=360000u l=150000u
** [instance X2 of sky130_fd_pr__pfet_01v8_hvt, params={'w': '1e+06u', 'l': '150000u'} connections=['d: [connection X2/d =>[signal: VPWR w=1]]', 'g: [connection X2/g =>[signal: a_788_316# w=1]]', 's: [connection X2/s =>[signal: X w=1]]', 'b: [connection X2/b =>[signal: VPB w=1]]']]
X__36__2 VPWR _36__a_788_316# _36_:X no_conn_99 sky130_fd_pr__pfet_01v8_hvt w=1e+06u l=150000u
** [instance X3 of sky130_fd_pr__pfet_01v8_hvt, params={'w': '640000u', 'l': '150000u'} connections=['d: [connection X3/d =>[signal: a_1279_413# w=1]]', 'g: [connection X3/g =>[signal: A0 w=1]]', 's: [connection X3/s =>[signal: VPWR w=1]]', 'b: [connection X3/b =>[signal: VPB w=1]]']]
X__36__3 _36__a_1279_413# _36_:A0 VPWR no_conn_99 sky130_fd_pr__pfet_01v8_hvt w=640000u l=150000u
** [instance X4 of sky130_fd_pr__nfet_01v8, params={'w': '650000u', 'l': '150000u'} connections=['d: [connection X4/d =>[signal: VGND w=1]]', 'g: [connection X4/g =>[signal: a_788_316# w=1]]', 's: [connection X4/s =>[signal: X w=1]]', 'b: [connection X4/b =>[signal: VNB w=1]]']]
X__36__4 VGND _36__a_788_316# _36_:X no_conn_98 sky130_fd_pr__nfet_01v8 w=650000u l=150000u
** [instance X5 of sky130_fd_pr__pfet_01v8_hvt, params={'w': '1e+06u', 'l': '150000u'} connections=['d: [connection X5/d =>[signal: X w=1]]', 'g: [connection X5/g =>[signal: a_788_316# w=1]]', 's: [connection X5/s =>[signal: VPWR w=1]]', 'b: [connection X5/b =>[signal: VPB w=1]]']]
X__36__5 _36_:X _36__a_788_316# VPWR no_conn_99 sky130_fd_pr__pfet_01v8_hvt w=1e+06u l=150000u
** [instance X6 of sky130_fd_pr__nfet_01v8, params={'w': '420000u', 'l': '150000u'} connections=['d: [connection X6/d =>[signal: a_288_47# w=1]]', 'g: [connection X6/g =>[signal: S1 w=1]]', 's: [connection X6/s =>[signal: a_788_316# w=1]]', 'b: [connection X6/b =>[signal: VNB w=1]]']]
X__36__6 _36__a_288_47# _36_:S1 _36__a_788_316# no_conn_98 sky130_fd_pr__nfet_01v8 w=420000u l=150000u
** [instance X7 of sky130_fd_pr__pfet_01v8_hvt, params={'w': '420000u', 'l': '150000u'} connections=['d: [connection X7/d =>[signal: a_193_369# w=1]]', 'g: [connection X7/g =>[signal: S0 w=1]]', 's: [connection X7/s =>[signal: a_288_47# w=1]]', 'b: [connection X7/b =>[signal: VPB w=1]]']]
X__36__7 _36__a_193_369# _36_:S0 _36__a_288_47# no_conn_99 sky130_fd_pr__pfet_01v8_hvt w=420000u l=150000u
** [instance X8 of sky130_fd_pr__pfet_01v8_hvt, params={'w': '640000u', 'l': '150000u'} connections=['d: [connection X8/d =>[signal: a_372_413# w=1]]', 'g: [connection X8/g =>[signal: A3 w=1]]', 's: [connection X8/s =>[signal: VPWR w=1]]', 'b: [connection X8/b =>[signal: VPB w=1]]']]
X__36__8 _36__a_372_413# _36_:A3 VPWR no_conn_99 sky130_fd_pr__pfet_01v8_hvt w=640000u l=150000u
** [instance X9 of sky130_fd_pr__nfet_01v8, params={'w': '360000u', 'l': '150000u'} connections=['d: [connection X9/d =>[signal: a_872_316# w=1]]', 'g: [connection X9/g =>[signal: a_27_47# w=1]]', 's: [connection X9/s =>[signal: a_1281_47# w=1]]', 'b: [connection X9/b =>[signal: VNB w=1]]']]
X__36__9 _36__a_872_316# _36__a_27_47# _36__a_1281_47# no_conn_98 sky130_fd_pr__nfet_01v8 w=360000u l=150000u
** [instance X10 of sky130_fd_pr__pfet_01v8_hvt, params={'w': '420000u', 'l': '150000u'} connections=['d: [connection X10/d =>[signal: a_288_47# w=1]]', 'g: [connection X10/g =>[signal: a_27_47# w=1]]', 's: [connection X10/s =>[signal: a_372_413# w=1]]', 'b: [connection X10/b =>[signal: VPB w=1]]']]
X__36__10 _36__a_288_47# _36__a_27_47# _36__a_372_413# no_conn_99 sky130_fd_pr__pfet_01v8_hvt w=420000u l=150000u
** [instance X11 of sky130_fd_pr__nfet_01v8, params={'w': '420000u', 'l': '150000u'} connections=['d: [connection X11/d =>[signal: VGND w=1]]', 'g: [connection X11/g =>[signal: A1 w=1]]', 's: [connection X11/s =>[signal: a_1064_47# w=1]]', 'b: [connection X11/b =>[signal: VNB w=1]]']]
X__36__11 VGND _36_:A1 _36__a_1064_47# no_conn_98 sky130_fd_pr__nfet_01v8 w=420000u l=150000u
** [instance X12 of sky130_fd_pr__pfet_01v8_hvt, params={'w': '640000u', 'l': '150000u'} connections=['d: [connection X12/d =>[signal: VPWR w=1]]', 'g: [connection X12/g =>[signal: S1 w=1]]', 's: [connection X12/s =>[signal: a_600_345# w=1]]', 'b: [connection X12/b =>[signal: VPB w=1]]']]
X__36__12 VPWR _36_:S1 _36__a_600_345# no_conn_99 sky130_fd_pr__pfet_01v8_hvt w=640000u l=150000u
** [instance X13 of sky130_fd_pr__pfet_01v8_hvt, params={'w': '420000u', 'l': '150000u'} connections=['d: [connection X13/d =>[signal: a_872_316# w=1]]', 'g: [connection X13/g =>[signal: S0 w=1]]', 's: [connection X13/s =>[signal: a_1279_413# w=1]]', 'b: [connection X13/b =>[signal: VPB w=1]]']]
X__36__13 _36__a_872_316# _36_:S0 _36__a_1279_413# no_conn_99 sky130_fd_pr__pfet_01v8_hvt w=420000u l=150000u
** [instance X14 of sky130_fd_pr__pfet_01v8_hvt, params={'w': '640000u', 'l': '150000u'} connections=['d: [connection X14/d =>[signal: a_27_47# w=1]]', 'g: [connection X14/g =>[signal: S0 w=1]]', 's: [connection X14/s =>[signal: VPWR w=1]]', 'b: [connection X14/b =>[signal: VPB w=1]]']]
X__36__14 _36__a_27_47# _36_:S0 VPWR no_conn_99 sky130_fd_pr__pfet_01v8_hvt w=640000u l=150000u
** [instance X15 of sky130_fd_pr__pfet_01v8_hvt, params={'w': '640000u', 'l': '150000u'} connections=['d: [connection X15/d =>[signal: VPWR w=1]]', 'g: [connection X15/g =>[signal: A2 w=1]]', 's: [connection X15/s =>[signal: a_193_369# w=1]]', 'b: [connection X15/b =>[signal: VPB w=1]]']]
X__36__15 VPWR _36_:A2 _36__a_193_369# no_conn_99 sky130_fd_pr__pfet_01v8_hvt w=640000u l=150000u
** [instance X16 of sky130_fd_pr__nfet_01v8, params={'w': '420000u', 'l': '150000u'} connections=['d: [connection X16/d =>[signal: VGND w=1]]', 'g: [connection X16/g =>[signal: A2 w=1]]', 's: [connection X16/s =>[signal: a_193_47# w=1]]', 'b: [connection X16/b =>[signal: VNB w=1]]']]
X__36__16 VGND _36_:A2 _36__a_193_47# no_conn_98 sky130_fd_pr__nfet_01v8 w=420000u l=150000u
** [instance X17 of sky130_fd_pr__pfet_01v8_hvt, params={'w': '540000u', 'l': '150000u'} connections=['d: [connection X17/d =>[signal: a_288_47# w=1]]', 'g: [connection X17/g =>[signal: a_600_345# w=1]]', 's: [connection X17/s =>[signal: a_788_316# w=1]]', 'b: [connection X17/b =>[signal: VPB w=1]]']]
X__36__17 _36__a_288_47# _36__a_600_345# _36__a_788_316# no_conn_99 sky130_fd_pr__pfet_01v8_hvt w=540000u l=150000u
** [instance X18 of sky130_fd_pr__nfet_01v8, params={'w': '420000u', 'l': '150000u'} connections=['d: [connection X18/d =>[signal: a_397_47# w=1]]', 'g: [connection X18/g =>[signal: A3 w=1]]', 's: [connection X18/s =>[signal: VGND w=1]]', 'b: [connection X18/b =>[signal: VNB w=1]]']]
X__36__18 _36__a_397_47# _36_:A3 VGND no_conn_98 sky130_fd_pr__nfet_01v8 w=420000u l=150000u
** [instance X19 of sky130_fd_pr__nfet_01v8, params={'w': '420000u', 'l': '150000u'} connections=['d: [connection X19/d =>[signal: a_27_47# w=1]]', 'g: [connection X19/g =>[signal: S0 w=1]]', 's: [connection X19/s =>[signal: VGND w=1]]', 'b: [connection X19/b =>[signal: VNB w=1]]']]
X__36__19 _36__a_27_47# _36_:S0 VGND no_conn_98 sky130_fd_pr__nfet_01v8 w=420000u l=150000u
** [instance X20 of sky130_fd_pr__pfet_01v8_hvt, params={'w': '420000u', 'l': '150000u'} connections=['d: [connection X20/d =>[signal: a_1060_369# w=1]]', 'g: [connection X20/g =>[signal: a_27_47# w=1]]', 's: [connection X20/s =>[signal: a_872_316# w=1]]', 'b: [connection X20/b =>[signal: VPB w=1]]']]
X__36__20 _36__a_1060_369# _36__a_27_47# _36__a_872_316# no_conn_99 sky130_fd_pr__pfet_01v8_hvt w=420000u l=150000u
** [instance X21 of sky130_fd_pr__nfet_01v8, params={'w': '420000u', 'l': '150000u'} connections=['d: [connection X21/d =>[signal: VGND w=1]]', 'g: [connection X21/g =>[signal: S1 w=1]]', 's: [connection X21/s =>[signal: a_600_345# w=1]]', 'b: [connection X21/b =>[signal: VNB w=1]]']]
X__36__21 VGND _36_:S1 _36__a_600_345# no_conn_98 sky130_fd_pr__nfet_01v8 w=420000u l=150000u
** [instance X22 of sky130_fd_pr__nfet_01v8, params={'w': '420000u', 'l': '150000u'} connections=['d: [connection X22/d =>[signal: a_1281_47# w=1]]', 'g: [connection X22/g =>[signal: A0 w=1]]', 's: [connection X22/s =>[signal: VGND w=1]]', 'b: [connection X22/b =>[signal: VNB w=1]]']]
X__36__22 _36__a_1281_47# _36_:A0 VGND no_conn_98 sky130_fd_pr__nfet_01v8 w=420000u l=150000u
** [instance X23 of sky130_fd_pr__nfet_01v8, params={'w': '650000u', 'l': '150000u'} connections=['d: [connection X23/d =>[signal: X w=1]]', 'g: [connection X23/g =>[signal: a_788_316# w=1]]', 's: [connection X23/s =>[signal: VGND w=1]]', 'b: [connection X23/b =>[signal: VNB w=1]]']]
X__36__23 _36_:X _36__a_788_316# VGND no_conn_98 sky130_fd_pr__nfet_01v8 w=650000u l=150000u
** [instance X24 of sky130_fd_pr__nfet_01v8, params={'w': '360000u', 'l': '150000u'} connections=['d: [connection X24/d =>[signal: a_288_47# w=1]]', 'g: [connection X24/g =>[signal: S0 w=1]]', 's: [connection X24/s =>[signal: a_397_47# w=1]]', 'b: [connection X24/b =>[signal: VNB w=1]]']]
X__36__24 _36__a_288_47# _36_:S0 _36__a_397_47# no_conn_98 sky130_fd_pr__nfet_01v8 w=360000u l=150000u
** [instance X25 of sky130_fd_pr__pfet_01v8_hvt, params={'w': '540000u', 'l': '150000u'} connections=['d: [connection X25/d =>[signal: a_788_316# w=1]]', 'g: [connection X25/g =>[signal: S1 w=1]]', 's: [connection X25/s =>[signal: a_872_316# w=1]]', 'b: [connection X25/b =>[signal: VPB w=1]]']]
X__36__25 _36__a_788_316# _36_:S1 _36__a_872_316# no_conn_99 sky130_fd_pr__pfet_01v8_hvt w=540000u l=150000u
** [instance X26 of sky130_fd_pr__nfet_01v8, params={'w': '420000u', 'l': '150000u'} connections=['d: [connection X26/d =>[signal: a_788_316# w=1]]', 'g: [connection X26/g =>[signal: a_600_345# w=1]]', 's: [connection X26/s =>[signal: a_872_316# w=1]]', 'b: [connection X26/b =>[signal: VNB w=1]]']]
X__36__26 _36__a_788_316# _36__a_600_345# _36__a_872_316# no_conn_98 sky130_fd_pr__nfet_01v8 w=420000u l=150000u
** [instance X27 of sky130_fd_pr__nfet_01v8, params={'w': '360000u', 'l': '150000u'} connections=['d: [connection X27/d =>[signal: a_1064_47# w=1]]', 'g: [connection X27/g =>[signal: S0 w=1]]', 's: [connection X27/s =>[signal: a_872_316# w=1]]', 'b: [connection X27/b =>[signal: VNB w=1]]']]
X__36__27 _36__a_1064_47# _36_:S0 _36__a_872_316# no_conn_98 sky130_fd_pr__nfet_01v8 w=360000u l=150000u

** replacing _37_ with the contents of sky130_fd_sc_hd__mux2_1
** [instance X0 of sky130_fd_pr__pfet_01v8_hvt, params={'w': '420000u', 'l': '150000u'} connections=['d: [connection X0/d =>[signal: VPWR w=1]]', 'g: [connection X0/g =>[signal: S w=1]]', 's: [connection X0/s =>[signal: a_218_374# w=1]]', 'b: [connection X0/b =>[signal: VPB w=1]]']]
X__37__0 VPWR _37_:S _37__a_218_374# no_conn_101 sky130_fd_pr__pfet_01v8_hvt w=420000u l=150000u
** [instance X1 of sky130_fd_pr__nfet_01v8, params={'w': '420000u', 'l': '150000u'} connections=['d: [connection X1/d =>[signal: a_76_199# w=1]]', 'g: [connection X1/g =>[signal: A0 w=1]]', 's: [connection X1/s =>[signal: a_439_47# w=1]]', 'b: [connection X1/b =>[signal: VNB w=1]]']]
X__37__1 _37__a_76_199# _37_:A0 _37__a_439_47# no_conn_100 sky130_fd_pr__nfet_01v8 w=420000u l=150000u
** [instance X2 of sky130_fd_pr__pfet_01v8_hvt, params={'w': '420000u', 'l': '150000u'} connections=['d: [connection X2/d =>[signal: a_535_374# w=1]]', 'g: [connection X2/g =>[signal: a_505_21# w=1]]', 's: [connection X2/s =>[signal: VPWR w=1]]', 'b: [connection X2/b =>[signal: VPB w=1]]']]
X__37__2 _37__a_535_374# _37__a_505_21# VPWR no_conn_101 sky130_fd_pr__pfet_01v8_hvt w=420000u l=150000u
** [instance X3 of sky130_fd_pr__pfet_01v8_hvt, params={'w': '420000u', 'l': '150000u'} connections=['d: [connection X3/d =>[signal: VPWR w=1]]', 'g: [connection X3/g =>[signal: S w=1]]', 's: [connection X3/s =>[signal: a_505_21# w=1]]', 'b: [connection X3/b =>[signal: VPB w=1]]']]
X__37__3 VPWR _37_:S _37__a_505_21# no_conn_101 sky130_fd_pr__pfet_01v8_hvt w=420000u l=150000u
** [instance X4 of sky130_fd_pr__pfet_01v8_hvt, params={'w': '420000u', 'l': '150000u'} connections=['d: [connection X4/d =>[signal: a_76_199# w=1]]', 'g: [connection X4/g =>[signal: A1 w=1]]', 's: [connection X4/s =>[signal: a_535_374# w=1]]', 'b: [connection X4/b =>[signal: VPB w=1]]']]
X__37__4 _37__a_76_199# _37_:A1 _37__a_535_374# no_conn_101 sky130_fd_pr__pfet_01v8_hvt w=420000u l=150000u
** [instance X5 of sky130_fd_pr__nfet_01v8, params={'w': '420000u', 'l': '150000u'} connections=['d: [connection X5/d =>[signal: a_218_47# w=1]]', 'g: [connection X5/g =>[signal: A1 w=1]]', 's: [connection X5/s =>[signal: a_76_199# w=1]]', 'b: [connection X5/b =>[signal: VNB w=1]]']]
X__37__5 _37__a_218_47# _37_:A1 _37__a_76_199# no_conn_100 sky130_fd_pr__nfet_01v8 w=420000u l=150000u
** [instance X6 of sky130_fd_pr__pfet_01v8_hvt, params={'w': '420000u', 'l': '150000u'} connections=['d: [connection X6/d =>[signal: a_218_374# w=1]]', 'g: [connection X6/g =>[signal: A0 w=1]]', 's: [connection X6/s =>[signal: a_76_199# w=1]]', 'b: [connection X6/b =>[signal: VPB w=1]]']]
X__37__6 _37__a_218_374# _37_:A0 _37__a_76_199# no_conn_101 sky130_fd_pr__pfet_01v8_hvt w=420000u l=150000u
** [instance X7 of sky130_fd_pr__nfet_01v8, params={'w': '650000u', 'l': '150000u'} connections=['d: [connection X7/d =>[signal: X w=1]]', 'g: [connection X7/g =>[signal: a_76_199# w=1]]', 's: [connection X7/s =>[signal: VGND w=1]]', 'b: [connection X7/b =>[signal: VNB w=1]]']]
X__37__7 _37_:X _37__a_76_199# VGND no_conn_100 sky130_fd_pr__nfet_01v8 w=650000u l=150000u
** [instance X8 of sky130_fd_pr__pfet_01v8_hvt, params={'w': '1e+06u', 'l': '150000u'} connections=['d: [connection X8/d =>[signal: X w=1]]', 'g: [connection X8/g =>[signal: a_76_199# w=1]]', 's: [connection X8/s =>[signal: VPWR w=1]]', 'b: [connection X8/b =>[signal: VPB w=1]]']]
X__37__8 _37_:X _37__a_76_199# VPWR no_conn_101 sky130_fd_pr__pfet_01v8_hvt w=1e+06u l=150000u
** [instance X9 of sky130_fd_pr__nfet_01v8, params={'w': '420000u', 'l': '150000u'} connections=['d: [connection X9/d =>[signal: VGND w=1]]', 'g: [connection X9/g =>[signal: S w=1]]', 's: [connection X9/s =>[signal: a_218_47# w=1]]', 'b: [connection X9/b =>[signal: VNB w=1]]']]
X__37__9 VGND _37_:S _37__a_218_47# no_conn_100 sky130_fd_pr__nfet_01v8 w=420000u l=150000u
** [instance X10 of sky130_fd_pr__nfet_01v8, params={'w': '420000u', 'l': '150000u'} connections=['d: [connection X10/d =>[signal: VGND w=1]]', 'g: [connection X10/g =>[signal: S w=1]]', 's: [connection X10/s =>[signal: a_505_21# w=1]]', 'b: [connection X10/b =>[signal: VNB w=1]]']]
X__37__10 VGND _37_:S _37__a_505_21# no_conn_100 sky130_fd_pr__nfet_01v8 w=420000u l=150000u
** [instance X11 of sky130_fd_pr__nfet_01v8, params={'w': '420000u', 'l': '150000u'} connections=['d: [connection X11/d =>[signal: a_439_47# w=1]]', 'g: [connection X11/g =>[signal: a_505_21# w=1]]', 's: [connection X11/s =>[signal: VGND w=1]]', 'b: [connection X11/b =>[signal: VNB w=1]]']]
X__37__11 _37__a_439_47# _37__a_505_21# VGND no_conn_100 sky130_fd_pr__nfet_01v8 w=420000u l=150000u

** replacing hold19 with the contents of sky130_fd_sc_hd__dlygate4sd3_1
** [instance X0 of sky130_fd_pr__nfet_01v8, params={'w': '420000u', 'l': '500000u'} connections=['d: [connection X0/d =>[signal: a_391_47# w=1]]', 'g: [connection X0/g =>[signal: a_285_47# w=1]]', 's: [connection X0/s =>[signal: VGND w=1]]', 'b: [connection X0/b =>[signal: VNB w=1]]']]
X_hold19_0 hold19_a_391_47# hold19_a_285_47# VGND no_conn_102 sky130_fd_pr__nfet_01v8 w=420000u l=500000u
** [instance X1 of sky130_fd_pr__pfet_01v8_hvt, params={'w': '420000u', 'l': '500000u'} connections=['d: [connection X1/d =>[signal: VPWR w=1]]', 'g: [connection X1/g =>[signal: a_49_47# w=1]]', 's: [connection X1/s =>[signal: a_285_47# w=1]]', 'b: [connection X1/b =>[signal: VPB w=1]]']]
X_hold19_1 VPWR hold19_a_49_47# hold19_a_285_47# no_conn_103 sky130_fd_pr__pfet_01v8_hvt w=420000u l=500000u
** [instance X2 of sky130_fd_pr__nfet_01v8, params={'w': '420000u', 'l': '150000u'} connections=['d: [connection X2/d =>[signal: a_49_47# w=1]]', 'g: [connection X2/g =>[signal: A w=1]]', 's: [connection X2/s =>[signal: VGND w=1]]', 'b: [connection X2/b =>[signal: VNB w=1]]']]
X_hold19_2 hold19_a_49_47# hold19:A VGND no_conn_102 sky130_fd_pr__nfet_01v8 w=420000u l=150000u
** [instance X3 of sky130_fd_pr__pfet_01v8_hvt, params={'w': '1e+06u', 'l': '150000u'} connections=['d: [connection X3/d =>[signal: VPWR w=1]]', 'g: [connection X3/g =>[signal: a_391_47# w=1]]', 's: [connection X3/s =>[signal: X w=1]]', 'b: [connection X3/b =>[signal: VPB w=1]]']]
X_hold19_3 VPWR hold19_a_391_47# hold19:X no_conn_103 sky130_fd_pr__pfet_01v8_hvt w=1e+06u l=150000u
** [instance X4 of sky130_fd_pr__nfet_01v8, params={'w': '650000u', 'l': '150000u'} connections=['d: [connection X4/d =>[signal: VGND w=1]]', 'g: [connection X4/g =>[signal: a_391_47# w=1]]', 's: [connection X4/s =>[signal: X w=1]]', 'b: [connection X4/b =>[signal: VNB w=1]]']]
X_hold19_4 VGND hold19_a_391_47# hold19:X no_conn_102 sky130_fd_pr__nfet_01v8 w=650000u l=150000u
** [instance X5 of sky130_fd_pr__nfet_01v8, params={'w': '420000u', 'l': '500000u'} connections=['d: [connection X5/d =>[signal: VGND w=1]]', 'g: [connection X5/g =>[signal: a_49_47# w=1]]', 's: [connection X5/s =>[signal: a_285_47# w=1]]', 'b: [connection X5/b =>[signal: VNB w=1]]']]
X_hold19_5 VGND hold19_a_49_47# hold19_a_285_47# no_conn_102 sky130_fd_pr__nfet_01v8 w=420000u l=500000u
** [instance X6 of sky130_fd_pr__pfet_01v8_hvt, params={'w': '420000u', 'l': '500000u'} connections=['d: [connection X6/d =>[signal: a_391_47# w=1]]', 'g: [connection X6/g =>[signal: a_285_47# w=1]]', 's: [connection X6/s =>[signal: VPWR w=1]]', 'b: [connection X6/b =>[signal: VPB w=1]]']]
X_hold19_6 hold19_a_391_47# hold19_a_285_47# VPWR no_conn_103 sky130_fd_pr__pfet_01v8_hvt w=420000u l=500000u
** [instance X7 of sky130_fd_pr__pfet_01v8_hvt, params={'w': '420000u', 'l': '150000u'} connections=['d: [connection X7/d =>[signal: a_49_47# w=1]]', 'g: [connection X7/g =>[signal: A w=1]]', 's: [connection X7/s =>[signal: VPWR w=1]]', 'b: [connection X7/b =>[signal: VPB w=1]]']]
X_hold19_7 hold19_a_49_47# hold19:A VPWR no_conn_103 sky130_fd_pr__pfet_01v8_hvt w=420000u l=150000u

** replacing _49_ with the contents of sky130_fd_sc_hd__mux2_1
** [instance X0 of sky130_fd_pr__pfet_01v8_hvt, params={'w': '420000u', 'l': '150000u'} connections=['d: [connection X0/d =>[signal: VPWR w=1]]', 'g: [connection X0/g =>[signal: S w=1]]', 's: [connection X0/s =>[signal: a_218_374# w=1]]', 'b: [connection X0/b =>[signal: VPB w=1]]']]
X__49__0 VPWR _49_:S _49__a_218_374# no_conn_105 sky130_fd_pr__pfet_01v8_hvt w=420000u l=150000u
** [instance X1 of sky130_fd_pr__nfet_01v8, params={'w': '420000u', 'l': '150000u'} connections=['d: [connection X1/d =>[signal: a_76_199# w=1]]', 'g: [connection X1/g =>[signal: A0 w=1]]', 's: [connection X1/s =>[signal: a_439_47# w=1]]', 'b: [connection X1/b =>[signal: VNB w=1]]']]
X__49__1 _49__a_76_199# _49_:A0 _49__a_439_47# no_conn_104 sky130_fd_pr__nfet_01v8 w=420000u l=150000u
** [instance X2 of sky130_fd_pr__pfet_01v8_hvt, params={'w': '420000u', 'l': '150000u'} connections=['d: [connection X2/d =>[signal: a_535_374# w=1]]', 'g: [connection X2/g =>[signal: a_505_21# w=1]]', 's: [connection X2/s =>[signal: VPWR w=1]]', 'b: [connection X2/b =>[signal: VPB w=1]]']]
X__49__2 _49__a_535_374# _49__a_505_21# VPWR no_conn_105 sky130_fd_pr__pfet_01v8_hvt w=420000u l=150000u
** [instance X3 of sky130_fd_pr__pfet_01v8_hvt, params={'w': '420000u', 'l': '150000u'} connections=['d: [connection X3/d =>[signal: VPWR w=1]]', 'g: [connection X3/g =>[signal: S w=1]]', 's: [connection X3/s =>[signal: a_505_21# w=1]]', 'b: [connection X3/b =>[signal: VPB w=1]]']]
X__49__3 VPWR _49_:S _49__a_505_21# no_conn_105 sky130_fd_pr__pfet_01v8_hvt w=420000u l=150000u
** [instance X4 of sky130_fd_pr__pfet_01v8_hvt, params={'w': '420000u', 'l': '150000u'} connections=['d: [connection X4/d =>[signal: a_76_199# w=1]]', 'g: [connection X4/g =>[signal: A1 w=1]]', 's: [connection X4/s =>[signal: a_535_374# w=1]]', 'b: [connection X4/b =>[signal: VPB w=1]]']]
X__49__4 _49__a_76_199# _49_:A1 _49__a_535_374# no_conn_105 sky130_fd_pr__pfet_01v8_hvt w=420000u l=150000u
** [instance X5 of sky130_fd_pr__nfet_01v8, params={'w': '420000u', 'l': '150000u'} connections=['d: [connection X5/d =>[signal: a_218_47# w=1]]', 'g: [connection X5/g =>[signal: A1 w=1]]', 's: [connection X5/s =>[signal: a_76_199# w=1]]', 'b: [connection X5/b =>[signal: VNB w=1]]']]
X__49__5 _49__a_218_47# _49_:A1 _49__a_76_199# no_conn_104 sky130_fd_pr__nfet_01v8 w=420000u l=150000u
** [instance X6 of sky130_fd_pr__pfet_01v8_hvt, params={'w': '420000u', 'l': '150000u'} connections=['d: [connection X6/d =>[signal: a_218_374# w=1]]', 'g: [connection X6/g =>[signal: A0 w=1]]', 's: [connection X6/s =>[signal: a_76_199# w=1]]', 'b: [connection X6/b =>[signal: VPB w=1]]']]
X__49__6 _49__a_218_374# _49_:A0 _49__a_76_199# no_conn_105 sky130_fd_pr__pfet_01v8_hvt w=420000u l=150000u
** [instance X7 of sky130_fd_pr__nfet_01v8, params={'w': '650000u', 'l': '150000u'} connections=['d: [connection X7/d =>[signal: X w=1]]', 'g: [connection X7/g =>[signal: a_76_199# w=1]]', 's: [connection X7/s =>[signal: VGND w=1]]', 'b: [connection X7/b =>[signal: VNB w=1]]']]
X__49__7 _49_:X _49__a_76_199# VGND no_conn_104 sky130_fd_pr__nfet_01v8 w=650000u l=150000u
** [instance X8 of sky130_fd_pr__pfet_01v8_hvt, params={'w': '1e+06u', 'l': '150000u'} connections=['d: [connection X8/d =>[signal: X w=1]]', 'g: [connection X8/g =>[signal: a_76_199# w=1]]', 's: [connection X8/s =>[signal: VPWR w=1]]', 'b: [connection X8/b =>[signal: VPB w=1]]']]
X__49__8 _49_:X _49__a_76_199# VPWR no_conn_105 sky130_fd_pr__pfet_01v8_hvt w=1e+06u l=150000u
** [instance X9 of sky130_fd_pr__nfet_01v8, params={'w': '420000u', 'l': '150000u'} connections=['d: [connection X9/d =>[signal: VGND w=1]]', 'g: [connection X9/g =>[signal: S w=1]]', 's: [connection X9/s =>[signal: a_218_47# w=1]]', 'b: [connection X9/b =>[signal: VNB w=1]]']]
X__49__9 VGND _49_:S _49__a_218_47# no_conn_104 sky130_fd_pr__nfet_01v8 w=420000u l=150000u
** [instance X10 of sky130_fd_pr__nfet_01v8, params={'w': '420000u', 'l': '150000u'} connections=['d: [connection X10/d =>[signal: VGND w=1]]', 'g: [connection X10/g =>[signal: S w=1]]', 's: [connection X10/s =>[signal: a_505_21# w=1]]', 'b: [connection X10/b =>[signal: VNB w=1]]']]
X__49__10 VGND _49_:S _49__a_505_21# no_conn_104 sky130_fd_pr__nfet_01v8 w=420000u l=150000u
** [instance X11 of sky130_fd_pr__nfet_01v8, params={'w': '420000u', 'l': '150000u'} connections=['d: [connection X11/d =>[signal: a_439_47# w=1]]', 'g: [connection X11/g =>[signal: a_505_21# w=1]]', 's: [connection X11/s =>[signal: VGND w=1]]', 'b: [connection X11/b =>[signal: VNB w=1]]']]
X__49__11 _49__a_439_47# _49__a_505_21# VGND no_conn_104 sky130_fd_pr__nfet_01v8 w=420000u l=150000u

** replacing hold37 with the contents of sky130_fd_sc_hd__dlygate4sd3_1
** [instance X0 of sky130_fd_pr__nfet_01v8, params={'w': '420000u', 'l': '500000u'} connections=['d: [connection X0/d =>[signal: a_391_47# w=1]]', 'g: [connection X0/g =>[signal: a_285_47# w=1]]', 's: [connection X0/s =>[signal: VGND w=1]]', 'b: [connection X0/b =>[signal: VNB w=1]]']]
X_hold37_0 hold37_a_391_47# hold37_a_285_47# VGND no_conn_106 sky130_fd_pr__nfet_01v8 w=420000u l=500000u
** [instance X1 of sky130_fd_pr__pfet_01v8_hvt, params={'w': '420000u', 'l': '500000u'} connections=['d: [connection X1/d =>[signal: VPWR w=1]]', 'g: [connection X1/g =>[signal: a_49_47# w=1]]', 's: [connection X1/s =>[signal: a_285_47# w=1]]', 'b: [connection X1/b =>[signal: VPB w=1]]']]
X_hold37_1 VPWR hold37_a_49_47# hold37_a_285_47# no_conn_107 sky130_fd_pr__pfet_01v8_hvt w=420000u l=500000u
** [instance X2 of sky130_fd_pr__nfet_01v8, params={'w': '420000u', 'l': '150000u'} connections=['d: [connection X2/d =>[signal: a_49_47# w=1]]', 'g: [connection X2/g =>[signal: A w=1]]', 's: [connection X2/s =>[signal: VGND w=1]]', 'b: [connection X2/b =>[signal: VNB w=1]]']]
X_hold37_2 hold37_a_49_47# hold37:A VGND no_conn_106 sky130_fd_pr__nfet_01v8 w=420000u l=150000u
** [instance X3 of sky130_fd_pr__pfet_01v8_hvt, params={'w': '1e+06u', 'l': '150000u'} connections=['d: [connection X3/d =>[signal: VPWR w=1]]', 'g: [connection X3/g =>[signal: a_391_47# w=1]]', 's: [connection X3/s =>[signal: X w=1]]', 'b: [connection X3/b =>[signal: VPB w=1]]']]
X_hold37_3 VPWR hold37_a_391_47# hold37:X no_conn_107 sky130_fd_pr__pfet_01v8_hvt w=1e+06u l=150000u
** [instance X4 of sky130_fd_pr__nfet_01v8, params={'w': '650000u', 'l': '150000u'} connections=['d: [connection X4/d =>[signal: VGND w=1]]', 'g: [connection X4/g =>[signal: a_391_47# w=1]]', 's: [connection X4/s =>[signal: X w=1]]', 'b: [connection X4/b =>[signal: VNB w=1]]']]
X_hold37_4 VGND hold37_a_391_47# hold37:X no_conn_106 sky130_fd_pr__nfet_01v8 w=650000u l=150000u
** [instance X5 of sky130_fd_pr__nfet_01v8, params={'w': '420000u', 'l': '500000u'} connections=['d: [connection X5/d =>[signal: VGND w=1]]', 'g: [connection X5/g =>[signal: a_49_47# w=1]]', 's: [connection X5/s =>[signal: a_285_47# w=1]]', 'b: [connection X5/b =>[signal: VNB w=1]]']]
X_hold37_5 VGND hold37_a_49_47# hold37_a_285_47# no_conn_106 sky130_fd_pr__nfet_01v8 w=420000u l=500000u
** [instance X6 of sky130_fd_pr__pfet_01v8_hvt, params={'w': '420000u', 'l': '500000u'} connections=['d: [connection X6/d =>[signal: a_391_47# w=1]]', 'g: [connection X6/g =>[signal: a_285_47# w=1]]', 's: [connection X6/s =>[signal: VPWR w=1]]', 'b: [connection X6/b =>[signal: VPB w=1]]']]
X_hold37_6 hold37_a_391_47# hold37_a_285_47# VPWR no_conn_107 sky130_fd_pr__pfet_01v8_hvt w=420000u l=500000u
** [instance X7 of sky130_fd_pr__pfet_01v8_hvt, params={'w': '420000u', 'l': '150000u'} connections=['d: [connection X7/d =>[signal: a_49_47# w=1]]', 'g: [connection X7/g =>[signal: A w=1]]', 's: [connection X7/s =>[signal: VPWR w=1]]', 'b: [connection X7/b =>[signal: VPB w=1]]']]
X_hold37_7 hold37_a_49_47# hold37:A VPWR no_conn_107 sky130_fd_pr__pfet_01v8_hvt w=420000u l=150000u

** replacing _68_ with the contents of sky130_fd_sc_hd__dfxtp_2
** [instance X0 of sky130_fd_pr__pfet_01v8_hvt, params={'w': '420000u', 'l': '150000u'} connections=['d: [connection X0/d =>[signal: a_891_413# w=1]]', 'g: [connection X0/g =>[signal: a_193_47# w=1]]', 's: [connection X0/s =>[signal: a_975_413# w=1]]', 'b: [connection X0/b =>[signal: VPB w=1]]']]
X__68__0 _68__a_891_413# _68__a_193_47# _68__a_975_413# no_conn_109 sky130_fd_pr__pfet_01v8_hvt w=420000u l=150000u
** [instance X1 of sky130_fd_pr__nfet_01v8, params={'w': '650000u', 'l': '150000u'} connections=['d: [connection X1/d =>[signal: a_1059_315# w=1]]', 'g: [connection X1/g =>[signal: a_891_413# w=1]]', 's: [connection X1/s =>[signal: VGND w=1]]', 'b: [connection X1/b =>[signal: VNB w=1]]']]
X__68__1 _68__a_1059_315# _68__a_891_413# VGND no_conn_108 sky130_fd_pr__nfet_01v8 w=650000u l=150000u
** [instance X2 of sky130_fd_pr__pfet_01v8_hvt, params={'w': '420000u', 'l': '150000u'} connections=['d: [connection X2/d =>[signal: a_466_413# w=1]]', 'g: [connection X2/g =>[signal: a_27_47# w=1]]', 's: [connection X2/s =>[signal: a_561_413# w=1]]', 'b: [connection X2/b =>[signal: VPB w=1]]']]
X__68__2 _68__a_466_413# _68__a_27_47# _68__a_561_413# no_conn_109 sky130_fd_pr__pfet_01v8_hvt w=420000u l=150000u
** [instance X3 of sky130_fd_pr__pfet_01v8_hvt, params={'w': '420000u', 'l': '150000u'} connections=['d: [connection X3/d =>[signal: a_634_159# w=1]]', 'g: [connection X3/g =>[signal: a_27_47# w=1]]', 's: [connection X3/s =>[signal: a_891_413# w=1]]', 'b: [connection X3/b =>[signal: VPB w=1]]']]
X__68__3 _68__a_634_159# _68__a_27_47# _68__a_891_413# no_conn_109 sky130_fd_pr__pfet_01v8_hvt w=420000u l=150000u
** [instance X4 of sky130_fd_pr__pfet_01v8_hvt, params={'w': '420000u', 'l': '150000u'} connections=['d: [connection X4/d =>[signal: a_381_47# w=1]]', 'g: [connection X4/g =>[signal: a_193_47# w=1]]', 's: [connection X4/s =>[signal: a_466_413# w=1]]', 'b: [connection X4/b =>[signal: VPB w=1]]']]
X__68__4 _68__a_381_47# _68__a_193_47# _68__a_466_413# no_conn_109 sky130_fd_pr__pfet_01v8_hvt w=420000u l=150000u
** [instance X5 of sky130_fd_pr__pfet_01v8_hvt, params={'w': '420000u', 'l': '150000u'} connections=['d: [connection X5/d =>[signal: VPWR w=1]]', 'g: [connection X5/g =>[signal: D w=1]]', 's: [connection X5/s =>[signal: a_381_47# w=1]]', 'b: [connection X5/b =>[signal: VPB w=1]]']]
X__68__5 VPWR _68_:D _68__a_381_47# no_conn_109 sky130_fd_pr__pfet_01v8_hvt w=420000u l=150000u
** [instance X6 of sky130_fd_pr__pfet_01v8_hvt, params={'w': '750000u', 'l': '150000u'} connections=['d: [connection X6/d =>[signal: VPWR w=1]]', 'g: [connection X6/g =>[signal: a_466_413# w=1]]', 's: [connection X6/s =>[signal: a_634_159# w=1]]', 'b: [connection X6/b =>[signal: VPB w=1]]']]
X__68__6 VPWR _68__a_466_413# _68__a_634_159# no_conn_109 sky130_fd_pr__pfet_01v8_hvt w=750000u l=150000u
** [instance X7 of sky130_fd_pr__nfet_01v8, params={'w': '640000u', 'l': '150000u'} connections=['d: [connection X7/d =>[signal: VGND w=1]]', 'g: [connection X7/g =>[signal: a_466_413# w=1]]', 's: [connection X7/s =>[signal: a_634_159# w=1]]', 'b: [connection X7/b =>[signal: VNB w=1]]']]
X__68__7 VGND _68__a_466_413# _68__a_634_159# no_conn_108 sky130_fd_pr__nfet_01v8 w=640000u l=150000u
** [instance X8 of sky130_fd_pr__nfet_01v8, params={'w': '420000u', 'l': '150000u'} connections=['d: [connection X8/d =>[signal: a_1017_47# w=1]]', 'g: [connection X8/g =>[signal: a_1059_315# w=1]]', 's: [connection X8/s =>[signal: VGND w=1]]', 'b: [connection X8/b =>[signal: VNB w=1]]']]
X__68__8 _68__a_1017_47# _68__a_1059_315# VGND no_conn_108 sky130_fd_pr__nfet_01v8 w=420000u l=150000u
** [instance X9 of sky130_fd_pr__pfet_01v8_hvt, params={'w': '1e+06u', 'l': '150000u'} connections=['d: [connection X9/d =>[signal: a_1059_315# w=1]]', 'g: [connection X9/g =>[signal: a_891_413# w=1]]', 's: [connection X9/s =>[signal: VPWR w=1]]', 'b: [connection X9/b =>[signal: VPB w=1]]']]
X__68__9 _68__a_1059_315# _68__a_891_413# VPWR no_conn_109 sky130_fd_pr__pfet_01v8_hvt w=1e+06u l=150000u
** [instance X10 of sky130_fd_pr__pfet_01v8_hvt, params={'w': '1e+06u', 'l': '150000u'} connections=['d: [connection X10/d =>[signal: Q w=1]]', 'g: [connection X10/g =>[signal: a_1059_315# w=1]]', 's: [connection X10/s =>[signal: VPWR w=1]]', 'b: [connection X10/b =>[signal: VPB w=1]]']]
X__68__10 _68_:Q _68__a_1059_315# VPWR no_conn_109 sky130_fd_pr__pfet_01v8_hvt w=1e+06u l=150000u
** [instance X11 of sky130_fd_pr__pfet_01v8_hvt, params={'w': '420000u', 'l': '150000u'} connections=['d: [connection X11/d =>[signal: a_561_413# w=1]]', 'g: [connection X11/g =>[signal: a_634_159# w=1]]', 's: [connection X11/s =>[signal: VPWR w=1]]', 'b: [connection X11/b =>[signal: VPB w=1]]']]
X__68__11 _68__a_561_413# _68__a_634_159# VPWR no_conn_109 sky130_fd_pr__pfet_01v8_hvt w=420000u l=150000u
** [instance X12 of sky130_fd_pr__pfet_01v8_hvt, params={'w': '1e+06u', 'l': '150000u'} connections=['d: [connection X12/d =>[signal: VPWR w=1]]', 'g: [connection X12/g =>[signal: a_1059_315# w=1]]', 's: [connection X12/s =>[signal: Q w=1]]', 'b: [connection X12/b =>[signal: VPB w=1]]']]
X__68__12 VPWR _68__a_1059_315# _68_:Q no_conn_109 sky130_fd_pr__pfet_01v8_hvt w=1e+06u l=150000u
** [instance X13 of sky130_fd_pr__nfet_01v8, params={'w': '360000u', 'l': '150000u'} connections=['d: [connection X13/d =>[signal: a_891_413# w=1]]', 'g: [connection X13/g =>[signal: a_27_47# w=1]]', 's: [connection X13/s =>[signal: a_1017_47# w=1]]', 'b: [connection X13/b =>[signal: VNB w=1]]']]
X__68__13 _68__a_891_413# _68__a_27_47# _68__a_1017_47# no_conn_108 sky130_fd_pr__nfet_01v8 w=360000u l=150000u
** [instance X14 of sky130_fd_pr__nfet_01v8, params={'w': '360000u', 'l': '150000u'} connections=['d: [connection X14/d =>[signal: a_634_159# w=1]]', 'g: [connection X14/g =>[signal: a_193_47# w=1]]', 's: [connection X14/s =>[signal: a_891_413# w=1]]', 'b: [connection X14/b =>[signal: VNB w=1]]']]
X__68__14 _68__a_634_159# _68__a_193_47# _68__a_891_413# no_conn_108 sky130_fd_pr__nfet_01v8 w=360000u l=150000u
** [instance X15 of sky130_fd_pr__nfet_01v8, params={'w': '420000u', 'l': '150000u'} connections=['d: [connection X15/d =>[signal: a_592_47# w=1]]', 'g: [connection X15/g =>[signal: a_634_159# w=1]]', 's: [connection X15/s =>[signal: VGND w=1]]', 'b: [connection X15/b =>[signal: VNB w=1]]']]
X__68__15 _68__a_592_47# _68__a_634_159# VGND no_conn_108 sky130_fd_pr__nfet_01v8 w=420000u l=150000u
** [instance X16 of sky130_fd_pr__nfet_01v8, params={'w': '360000u', 'l': '150000u'} connections=['d: [connection X16/d =>[signal: a_466_413# w=1]]', 'g: [connection X16/g =>[signal: a_193_47# w=1]]', 's: [connection X16/s =>[signal: a_592_47# w=1]]', 'b: [connection X16/b =>[signal: VNB w=1]]']]
X__68__16 _68__a_466_413# _68__a_193_47# _68__a_592_47# no_conn_108 sky130_fd_pr__nfet_01v8 w=360000u l=150000u
** [instance X17 of sky130_fd_pr__nfet_01v8, params={'w': '420000u', 'l': '150000u'} connections=['d: [connection X17/d =>[signal: VGND w=1]]', 'g: [connection X17/g =>[signal: a_27_47# w=1]]', 's: [connection X17/s =>[signal: a_193_47# w=1]]', 'b: [connection X17/b =>[signal: VNB w=1]]']]
X__68__17 VGND _68__a_27_47# _68__a_193_47# no_conn_108 sky130_fd_pr__nfet_01v8 w=420000u l=150000u
** [instance X18 of sky130_fd_pr__nfet_01v8, params={'w': '360000u', 'l': '150000u'} connections=['d: [connection X18/d =>[signal: a_381_47# w=1]]', 'g: [connection X18/g =>[signal: a_27_47# w=1]]', 's: [connection X18/s =>[signal: a_466_413# w=1]]', 'b: [connection X18/b =>[signal: VNB w=1]]']]
X__68__18 _68__a_381_47# _68__a_27_47# _68__a_466_413# no_conn_108 sky130_fd_pr__nfet_01v8 w=360000u l=150000u
** [instance X19 of sky130_fd_pr__nfet_01v8, params={'w': '420000u', 'l': '150000u'} connections=['d: [connection X19/d =>[signal: a_27_47# w=1]]', 'g: [connection X19/g =>[signal: CLK w=1]]', 's: [connection X19/s =>[signal: VGND w=1]]', 'b: [connection X19/b =>[signal: VNB w=1]]']]
X__68__19 _68__a_27_47# _68_:CLK VGND no_conn_108 sky130_fd_pr__nfet_01v8 w=420000u l=150000u
** [instance X20 of sky130_fd_pr__pfet_01v8_hvt, params={'w': '640000u', 'l': '150000u'} connections=['d: [connection X20/d =>[signal: a_27_47# w=1]]', 'g: [connection X20/g =>[signal: CLK w=1]]', 's: [connection X20/s =>[signal: VPWR w=1]]', 'b: [connection X20/b =>[signal: VPB w=1]]']]
X__68__20 _68__a_27_47# _68_:CLK VPWR no_conn_109 sky130_fd_pr__pfet_01v8_hvt w=640000u l=150000u
** [instance X21 of sky130_fd_pr__nfet_01v8, params={'w': '650000u', 'l': '150000u'} connections=['d: [connection X21/d =>[signal: Q w=1]]', 'g: [connection X21/g =>[signal: a_1059_315# w=1]]', 's: [connection X21/s =>[signal: VGND w=1]]', 'b: [connection X21/b =>[signal: VNB w=1]]']]
X__68__21 _68_:Q _68__a_1059_315# VGND no_conn_108 sky130_fd_pr__nfet_01v8 w=650000u l=150000u
** [instance X22 of sky130_fd_pr__pfet_01v8_hvt, params={'w': '640000u', 'l': '150000u'} connections=['d: [connection X22/d =>[signal: VPWR w=1]]', 'g: [connection X22/g =>[signal: a_27_47# w=1]]', 's: [connection X22/s =>[signal: a_193_47# w=1]]', 'b: [connection X22/b =>[signal: VPB w=1]]']]
X__68__22 VPWR _68__a_27_47# _68__a_193_47# no_conn_109 sky130_fd_pr__pfet_01v8_hvt w=640000u l=150000u
** [instance X23 of sky130_fd_pr__nfet_01v8, params={'w': '420000u', 'l': '150000u'} connections=['d: [connection X23/d =>[signal: VGND w=1]]', 'g: [connection X23/g =>[signal: D w=1]]', 's: [connection X23/s =>[signal: a_381_47# w=1]]', 'b: [connection X23/b =>[signal: VNB w=1]]']]
X__68__23 VGND _68_:D _68__a_381_47# no_conn_108 sky130_fd_pr__nfet_01v8 w=420000u l=150000u
** [instance X24 of sky130_fd_pr__pfet_01v8_hvt, params={'w': '420000u', 'l': '150000u'} connections=['d: [connection X24/d =>[signal: a_975_413# w=1]]', 'g: [connection X24/g =>[signal: a_1059_315# w=1]]', 's: [connection X24/s =>[signal: VPWR w=1]]', 'b: [connection X24/b =>[signal: VPB w=1]]']]
X__68__24 _68__a_975_413# _68__a_1059_315# VPWR no_conn_109 sky130_fd_pr__pfet_01v8_hvt w=420000u l=150000u
** [instance X25 of sky130_fd_pr__nfet_01v8, params={'w': '650000u', 'l': '150000u'} connections=['d: [connection X25/d =>[signal: VGND w=1]]', 'g: [connection X25/g =>[signal: a_1059_315# w=1]]', 's: [connection X25/s =>[signal: Q w=1]]', 'b: [connection X25/b =>[signal: VNB w=1]]']]
X__68__25 VGND _68__a_1059_315# _68_:Q no_conn_108 sky130_fd_pr__nfet_01v8 w=650000u l=150000u

** replacing _54_ with the contents of sky130_fd_sc_hd__mux2_1
** [instance X0 of sky130_fd_pr__pfet_01v8_hvt, params={'w': '420000u', 'l': '150000u'} connections=['d: [connection X0/d =>[signal: VPWR w=1]]', 'g: [connection X0/g =>[signal: S w=1]]', 's: [connection X0/s =>[signal: a_218_374# w=1]]', 'b: [connection X0/b =>[signal: VPB w=1]]']]
X__54__0 VPWR _54_:S _54__a_218_374# no_conn_111 sky130_fd_pr__pfet_01v8_hvt w=420000u l=150000u
** [instance X1 of sky130_fd_pr__nfet_01v8, params={'w': '420000u', 'l': '150000u'} connections=['d: [connection X1/d =>[signal: a_76_199# w=1]]', 'g: [connection X1/g =>[signal: A0 w=1]]', 's: [connection X1/s =>[signal: a_439_47# w=1]]', 'b: [connection X1/b =>[signal: VNB w=1]]']]
X__54__1 _54__a_76_199# _54_:A0 _54__a_439_47# no_conn_110 sky130_fd_pr__nfet_01v8 w=420000u l=150000u
** [instance X2 of sky130_fd_pr__pfet_01v8_hvt, params={'w': '420000u', 'l': '150000u'} connections=['d: [connection X2/d =>[signal: a_535_374# w=1]]', 'g: [connection X2/g =>[signal: a_505_21# w=1]]', 's: [connection X2/s =>[signal: VPWR w=1]]', 'b: [connection X2/b =>[signal: VPB w=1]]']]
X__54__2 _54__a_535_374# _54__a_505_21# VPWR no_conn_111 sky130_fd_pr__pfet_01v8_hvt w=420000u l=150000u
** [instance X3 of sky130_fd_pr__pfet_01v8_hvt, params={'w': '420000u', 'l': '150000u'} connections=['d: [connection X3/d =>[signal: VPWR w=1]]', 'g: [connection X3/g =>[signal: S w=1]]', 's: [connection X3/s =>[signal: a_505_21# w=1]]', 'b: [connection X3/b =>[signal: VPB w=1]]']]
X__54__3 VPWR _54_:S _54__a_505_21# no_conn_111 sky130_fd_pr__pfet_01v8_hvt w=420000u l=150000u
** [instance X4 of sky130_fd_pr__pfet_01v8_hvt, params={'w': '420000u', 'l': '150000u'} connections=['d: [connection X4/d =>[signal: a_76_199# w=1]]', 'g: [connection X4/g =>[signal: A1 w=1]]', 's: [connection X4/s =>[signal: a_535_374# w=1]]', 'b: [connection X4/b =>[signal: VPB w=1]]']]
X__54__4 _54__a_76_199# _54_:A1 _54__a_535_374# no_conn_111 sky130_fd_pr__pfet_01v8_hvt w=420000u l=150000u
** [instance X5 of sky130_fd_pr__nfet_01v8, params={'w': '420000u', 'l': '150000u'} connections=['d: [connection X5/d =>[signal: a_218_47# w=1]]', 'g: [connection X5/g =>[signal: A1 w=1]]', 's: [connection X5/s =>[signal: a_76_199# w=1]]', 'b: [connection X5/b =>[signal: VNB w=1]]']]
X__54__5 _54__a_218_47# _54_:A1 _54__a_76_199# no_conn_110 sky130_fd_pr__nfet_01v8 w=420000u l=150000u
** [instance X6 of sky130_fd_pr__pfet_01v8_hvt, params={'w': '420000u', 'l': '150000u'} connections=['d: [connection X6/d =>[signal: a_218_374# w=1]]', 'g: [connection X6/g =>[signal: A0 w=1]]', 's: [connection X6/s =>[signal: a_76_199# w=1]]', 'b: [connection X6/b =>[signal: VPB w=1]]']]
X__54__6 _54__a_218_374# _54_:A0 _54__a_76_199# no_conn_111 sky130_fd_pr__pfet_01v8_hvt w=420000u l=150000u
** [instance X7 of sky130_fd_pr__nfet_01v8, params={'w': '650000u', 'l': '150000u'} connections=['d: [connection X7/d =>[signal: X w=1]]', 'g: [connection X7/g =>[signal: a_76_199# w=1]]', 's: [connection X7/s =>[signal: VGND w=1]]', 'b: [connection X7/b =>[signal: VNB w=1]]']]
X__54__7 _54_:X _54__a_76_199# VGND no_conn_110 sky130_fd_pr__nfet_01v8 w=650000u l=150000u
** [instance X8 of sky130_fd_pr__pfet_01v8_hvt, params={'w': '1e+06u', 'l': '150000u'} connections=['d: [connection X8/d =>[signal: X w=1]]', 'g: [connection X8/g =>[signal: a_76_199# w=1]]', 's: [connection X8/s =>[signal: VPWR w=1]]', 'b: [connection X8/b =>[signal: VPB w=1]]']]
X__54__8 _54_:X _54__a_76_199# VPWR no_conn_111 sky130_fd_pr__pfet_01v8_hvt w=1e+06u l=150000u
** [instance X9 of sky130_fd_pr__nfet_01v8, params={'w': '420000u', 'l': '150000u'} connections=['d: [connection X9/d =>[signal: VGND w=1]]', 'g: [connection X9/g =>[signal: S w=1]]', 's: [connection X9/s =>[signal: a_218_47# w=1]]', 'b: [connection X9/b =>[signal: VNB w=1]]']]
X__54__9 VGND _54_:S _54__a_218_47# no_conn_110 sky130_fd_pr__nfet_01v8 w=420000u l=150000u
** [instance X10 of sky130_fd_pr__nfet_01v8, params={'w': '420000u', 'l': '150000u'} connections=['d: [connection X10/d =>[signal: VGND w=1]]', 'g: [connection X10/g =>[signal: S w=1]]', 's: [connection X10/s =>[signal: a_505_21# w=1]]', 'b: [connection X10/b =>[signal: VNB w=1]]']]
X__54__10 VGND _54_:S _54__a_505_21# no_conn_110 sky130_fd_pr__nfet_01v8 w=420000u l=150000u
** [instance X11 of sky130_fd_pr__nfet_01v8, params={'w': '420000u', 'l': '150000u'} connections=['d: [connection X11/d =>[signal: a_439_47# w=1]]', 'g: [connection X11/g =>[signal: a_505_21# w=1]]', 's: [connection X11/s =>[signal: VGND w=1]]', 'b: [connection X11/b =>[signal: VNB w=1]]']]
X__54__11 _54__a_439_47# _54__a_505_21# VGND no_conn_110 sky130_fd_pr__nfet_01v8 w=420000u l=150000u

** replacing _55_ with the contents of sky130_fd_sc_hd__mux2_1
** [instance X0 of sky130_fd_pr__pfet_01v8_hvt, params={'w': '420000u', 'l': '150000u'} connections=['d: [connection X0/d =>[signal: VPWR w=1]]', 'g: [connection X0/g =>[signal: S w=1]]', 's: [connection X0/s =>[signal: a_218_374# w=1]]', 'b: [connection X0/b =>[signal: VPB w=1]]']]
X__55__0 VPWR _55_:S _55__a_218_374# no_conn_113 sky130_fd_pr__pfet_01v8_hvt w=420000u l=150000u
** [instance X1 of sky130_fd_pr__nfet_01v8, params={'w': '420000u', 'l': '150000u'} connections=['d: [connection X1/d =>[signal: a_76_199# w=1]]', 'g: [connection X1/g =>[signal: A0 w=1]]', 's: [connection X1/s =>[signal: a_439_47# w=1]]', 'b: [connection X1/b =>[signal: VNB w=1]]']]
X__55__1 _55__a_76_199# _55_:A0 _55__a_439_47# no_conn_112 sky130_fd_pr__nfet_01v8 w=420000u l=150000u
** [instance X2 of sky130_fd_pr__pfet_01v8_hvt, params={'w': '420000u', 'l': '150000u'} connections=['d: [connection X2/d =>[signal: a_535_374# w=1]]', 'g: [connection X2/g =>[signal: a_505_21# w=1]]', 's: [connection X2/s =>[signal: VPWR w=1]]', 'b: [connection X2/b =>[signal: VPB w=1]]']]
X__55__2 _55__a_535_374# _55__a_505_21# VPWR no_conn_113 sky130_fd_pr__pfet_01v8_hvt w=420000u l=150000u
** [instance X3 of sky130_fd_pr__pfet_01v8_hvt, params={'w': '420000u', 'l': '150000u'} connections=['d: [connection X3/d =>[signal: VPWR w=1]]', 'g: [connection X3/g =>[signal: S w=1]]', 's: [connection X3/s =>[signal: a_505_21# w=1]]', 'b: [connection X3/b =>[signal: VPB w=1]]']]
X__55__3 VPWR _55_:S _55__a_505_21# no_conn_113 sky130_fd_pr__pfet_01v8_hvt w=420000u l=150000u
** [instance X4 of sky130_fd_pr__pfet_01v8_hvt, params={'w': '420000u', 'l': '150000u'} connections=['d: [connection X4/d =>[signal: a_76_199# w=1]]', 'g: [connection X4/g =>[signal: A1 w=1]]', 's: [connection X4/s =>[signal: a_535_374# w=1]]', 'b: [connection X4/b =>[signal: VPB w=1]]']]
X__55__4 _55__a_76_199# _55_:A1 _55__a_535_374# no_conn_113 sky130_fd_pr__pfet_01v8_hvt w=420000u l=150000u
** [instance X5 of sky130_fd_pr__nfet_01v8, params={'w': '420000u', 'l': '150000u'} connections=['d: [connection X5/d =>[signal: a_218_47# w=1]]', 'g: [connection X5/g =>[signal: A1 w=1]]', 's: [connection X5/s =>[signal: a_76_199# w=1]]', 'b: [connection X5/b =>[signal: VNB w=1]]']]
X__55__5 _55__a_218_47# _55_:A1 _55__a_76_199# no_conn_112 sky130_fd_pr__nfet_01v8 w=420000u l=150000u
** [instance X6 of sky130_fd_pr__pfet_01v8_hvt, params={'w': '420000u', 'l': '150000u'} connections=['d: [connection X6/d =>[signal: a_218_374# w=1]]', 'g: [connection X6/g =>[signal: A0 w=1]]', 's: [connection X6/s =>[signal: a_76_199# w=1]]', 'b: [connection X6/b =>[signal: VPB w=1]]']]
X__55__6 _55__a_218_374# _55_:A0 _55__a_76_199# no_conn_113 sky130_fd_pr__pfet_01v8_hvt w=420000u l=150000u
** [instance X7 of sky130_fd_pr__nfet_01v8, params={'w': '650000u', 'l': '150000u'} connections=['d: [connection X7/d =>[signal: X w=1]]', 'g: [connection X7/g =>[signal: a_76_199# w=1]]', 's: [connection X7/s =>[signal: VGND w=1]]', 'b: [connection X7/b =>[signal: VNB w=1]]']]
X__55__7 _55_:X _55__a_76_199# VGND no_conn_112 sky130_fd_pr__nfet_01v8 w=650000u l=150000u
** [instance X8 of sky130_fd_pr__pfet_01v8_hvt, params={'w': '1e+06u', 'l': '150000u'} connections=['d: [connection X8/d =>[signal: X w=1]]', 'g: [connection X8/g =>[signal: a_76_199# w=1]]', 's: [connection X8/s =>[signal: VPWR w=1]]', 'b: [connection X8/b =>[signal: VPB w=1]]']]
X__55__8 _55_:X _55__a_76_199# VPWR no_conn_113 sky130_fd_pr__pfet_01v8_hvt w=1e+06u l=150000u
** [instance X9 of sky130_fd_pr__nfet_01v8, params={'w': '420000u', 'l': '150000u'} connections=['d: [connection X9/d =>[signal: VGND w=1]]', 'g: [connection X9/g =>[signal: S w=1]]', 's: [connection X9/s =>[signal: a_218_47# w=1]]', 'b: [connection X9/b =>[signal: VNB w=1]]']]
X__55__9 VGND _55_:S _55__a_218_47# no_conn_112 sky130_fd_pr__nfet_01v8 w=420000u l=150000u
** [instance X10 of sky130_fd_pr__nfet_01v8, params={'w': '420000u', 'l': '150000u'} connections=['d: [connection X10/d =>[signal: VGND w=1]]', 'g: [connection X10/g =>[signal: S w=1]]', 's: [connection X10/s =>[signal: a_505_21# w=1]]', 'b: [connection X10/b =>[signal: VNB w=1]]']]
X__55__10 VGND _55_:S _55__a_505_21# no_conn_112 sky130_fd_pr__nfet_01v8 w=420000u l=150000u
** [instance X11 of sky130_fd_pr__nfet_01v8, params={'w': '420000u', 'l': '150000u'} connections=['d: [connection X11/d =>[signal: a_439_47# w=1]]', 'g: [connection X11/g =>[signal: a_505_21# w=1]]', 's: [connection X11/s =>[signal: VGND w=1]]', 'b: [connection X11/b =>[signal: VNB w=1]]']]
X__55__11 _55__a_439_47# _55__a_505_21# VGND no_conn_112 sky130_fd_pr__nfet_01v8 w=420000u l=150000u

** replacing _70_ with the contents of sky130_fd_sc_hd__dfxtp_2
** [instance X0 of sky130_fd_pr__pfet_01v8_hvt, params={'w': '420000u', 'l': '150000u'} connections=['d: [connection X0/d =>[signal: a_891_413# w=1]]', 'g: [connection X0/g =>[signal: a_193_47# w=1]]', 's: [connection X0/s =>[signal: a_975_413# w=1]]', 'b: [connection X0/b =>[signal: VPB w=1]]']]
X__70__0 _70__a_891_413# _70__a_193_47# _70__a_975_413# no_conn_115 sky130_fd_pr__pfet_01v8_hvt w=420000u l=150000u
** [instance X1 of sky130_fd_pr__nfet_01v8, params={'w': '650000u', 'l': '150000u'} connections=['d: [connection X1/d =>[signal: a_1059_315# w=1]]', 'g: [connection X1/g =>[signal: a_891_413# w=1]]', 's: [connection X1/s =>[signal: VGND w=1]]', 'b: [connection X1/b =>[signal: VNB w=1]]']]
X__70__1 _70__a_1059_315# _70__a_891_413# VGND no_conn_114 sky130_fd_pr__nfet_01v8 w=650000u l=150000u
** [instance X2 of sky130_fd_pr__pfet_01v8_hvt, params={'w': '420000u', 'l': '150000u'} connections=['d: [connection X2/d =>[signal: a_466_413# w=1]]', 'g: [connection X2/g =>[signal: a_27_47# w=1]]', 's: [connection X2/s =>[signal: a_561_413# w=1]]', 'b: [connection X2/b =>[signal: VPB w=1]]']]
X__70__2 _70__a_466_413# _70__a_27_47# _70__a_561_413# no_conn_115 sky130_fd_pr__pfet_01v8_hvt w=420000u l=150000u
** [instance X3 of sky130_fd_pr__pfet_01v8_hvt, params={'w': '420000u', 'l': '150000u'} connections=['d: [connection X3/d =>[signal: a_634_159# w=1]]', 'g: [connection X3/g =>[signal: a_27_47# w=1]]', 's: [connection X3/s =>[signal: a_891_413# w=1]]', 'b: [connection X3/b =>[signal: VPB w=1]]']]
X__70__3 _70__a_634_159# _70__a_27_47# _70__a_891_413# no_conn_115 sky130_fd_pr__pfet_01v8_hvt w=420000u l=150000u
** [instance X4 of sky130_fd_pr__pfet_01v8_hvt, params={'w': '420000u', 'l': '150000u'} connections=['d: [connection X4/d =>[signal: a_381_47# w=1]]', 'g: [connection X4/g =>[signal: a_193_47# w=1]]', 's: [connection X4/s =>[signal: a_466_413# w=1]]', 'b: [connection X4/b =>[signal: VPB w=1]]']]
X__70__4 _70__a_381_47# _70__a_193_47# _70__a_466_413# no_conn_115 sky130_fd_pr__pfet_01v8_hvt w=420000u l=150000u
** [instance X5 of sky130_fd_pr__pfet_01v8_hvt, params={'w': '420000u', 'l': '150000u'} connections=['d: [connection X5/d =>[signal: VPWR w=1]]', 'g: [connection X5/g =>[signal: D w=1]]', 's: [connection X5/s =>[signal: a_381_47# w=1]]', 'b: [connection X5/b =>[signal: VPB w=1]]']]
X__70__5 VPWR _70_:D _70__a_381_47# no_conn_115 sky130_fd_pr__pfet_01v8_hvt w=420000u l=150000u
** [instance X6 of sky130_fd_pr__pfet_01v8_hvt, params={'w': '750000u', 'l': '150000u'} connections=['d: [connection X6/d =>[signal: VPWR w=1]]', 'g: [connection X6/g =>[signal: a_466_413# w=1]]', 's: [connection X6/s =>[signal: a_634_159# w=1]]', 'b: [connection X6/b =>[signal: VPB w=1]]']]
X__70__6 VPWR _70__a_466_413# _70__a_634_159# no_conn_115 sky130_fd_pr__pfet_01v8_hvt w=750000u l=150000u
** [instance X7 of sky130_fd_pr__nfet_01v8, params={'w': '640000u', 'l': '150000u'} connections=['d: [connection X7/d =>[signal: VGND w=1]]', 'g: [connection X7/g =>[signal: a_466_413# w=1]]', 's: [connection X7/s =>[signal: a_634_159# w=1]]', 'b: [connection X7/b =>[signal: VNB w=1]]']]
X__70__7 VGND _70__a_466_413# _70__a_634_159# no_conn_114 sky130_fd_pr__nfet_01v8 w=640000u l=150000u
** [instance X8 of sky130_fd_pr__nfet_01v8, params={'w': '420000u', 'l': '150000u'} connections=['d: [connection X8/d =>[signal: a_1017_47# w=1]]', 'g: [connection X8/g =>[signal: a_1059_315# w=1]]', 's: [connection X8/s =>[signal: VGND w=1]]', 'b: [connection X8/b =>[signal: VNB w=1]]']]
X__70__8 _70__a_1017_47# _70__a_1059_315# VGND no_conn_114 sky130_fd_pr__nfet_01v8 w=420000u l=150000u
** [instance X9 of sky130_fd_pr__pfet_01v8_hvt, params={'w': '1e+06u', 'l': '150000u'} connections=['d: [connection X9/d =>[signal: a_1059_315# w=1]]', 'g: [connection X9/g =>[signal: a_891_413# w=1]]', 's: [connection X9/s =>[signal: VPWR w=1]]', 'b: [connection X9/b =>[signal: VPB w=1]]']]
X__70__9 _70__a_1059_315# _70__a_891_413# VPWR no_conn_115 sky130_fd_pr__pfet_01v8_hvt w=1e+06u l=150000u
** [instance X10 of sky130_fd_pr__pfet_01v8_hvt, params={'w': '1e+06u', 'l': '150000u'} connections=['d: [connection X10/d =>[signal: Q w=1]]', 'g: [connection X10/g =>[signal: a_1059_315# w=1]]', 's: [connection X10/s =>[signal: VPWR w=1]]', 'b: [connection X10/b =>[signal: VPB w=1]]']]
X__70__10 _70_:Q _70__a_1059_315# VPWR no_conn_115 sky130_fd_pr__pfet_01v8_hvt w=1e+06u l=150000u
** [instance X11 of sky130_fd_pr__pfet_01v8_hvt, params={'w': '420000u', 'l': '150000u'} connections=['d: [connection X11/d =>[signal: a_561_413# w=1]]', 'g: [connection X11/g =>[signal: a_634_159# w=1]]', 's: [connection X11/s =>[signal: VPWR w=1]]', 'b: [connection X11/b =>[signal: VPB w=1]]']]
X__70__11 _70__a_561_413# _70__a_634_159# VPWR no_conn_115 sky130_fd_pr__pfet_01v8_hvt w=420000u l=150000u
** [instance X12 of sky130_fd_pr__pfet_01v8_hvt, params={'w': '1e+06u', 'l': '150000u'} connections=['d: [connection X12/d =>[signal: VPWR w=1]]', 'g: [connection X12/g =>[signal: a_1059_315# w=1]]', 's: [connection X12/s =>[signal: Q w=1]]', 'b: [connection X12/b =>[signal: VPB w=1]]']]
X__70__12 VPWR _70__a_1059_315# _70_:Q no_conn_115 sky130_fd_pr__pfet_01v8_hvt w=1e+06u l=150000u
** [instance X13 of sky130_fd_pr__nfet_01v8, params={'w': '360000u', 'l': '150000u'} connections=['d: [connection X13/d =>[signal: a_891_413# w=1]]', 'g: [connection X13/g =>[signal: a_27_47# w=1]]', 's: [connection X13/s =>[signal: a_1017_47# w=1]]', 'b: [connection X13/b =>[signal: VNB w=1]]']]
X__70__13 _70__a_891_413# _70__a_27_47# _70__a_1017_47# no_conn_114 sky130_fd_pr__nfet_01v8 w=360000u l=150000u
** [instance X14 of sky130_fd_pr__nfet_01v8, params={'w': '360000u', 'l': '150000u'} connections=['d: [connection X14/d =>[signal: a_634_159# w=1]]', 'g: [connection X14/g =>[signal: a_193_47# w=1]]', 's: [connection X14/s =>[signal: a_891_413# w=1]]', 'b: [connection X14/b =>[signal: VNB w=1]]']]
X__70__14 _70__a_634_159# _70__a_193_47# _70__a_891_413# no_conn_114 sky130_fd_pr__nfet_01v8 w=360000u l=150000u
** [instance X15 of sky130_fd_pr__nfet_01v8, params={'w': '420000u', 'l': '150000u'} connections=['d: [connection X15/d =>[signal: a_592_47# w=1]]', 'g: [connection X15/g =>[signal: a_634_159# w=1]]', 's: [connection X15/s =>[signal: VGND w=1]]', 'b: [connection X15/b =>[signal: VNB w=1]]']]
X__70__15 _70__a_592_47# _70__a_634_159# VGND no_conn_114 sky130_fd_pr__nfet_01v8 w=420000u l=150000u
** [instance X16 of sky130_fd_pr__nfet_01v8, params={'w': '360000u', 'l': '150000u'} connections=['d: [connection X16/d =>[signal: a_466_413# w=1]]', 'g: [connection X16/g =>[signal: a_193_47# w=1]]', 's: [connection X16/s =>[signal: a_592_47# w=1]]', 'b: [connection X16/b =>[signal: VNB w=1]]']]
X__70__16 _70__a_466_413# _70__a_193_47# _70__a_592_47# no_conn_114 sky130_fd_pr__nfet_01v8 w=360000u l=150000u
** [instance X17 of sky130_fd_pr__nfet_01v8, params={'w': '420000u', 'l': '150000u'} connections=['d: [connection X17/d =>[signal: VGND w=1]]', 'g: [connection X17/g =>[signal: a_27_47# w=1]]', 's: [connection X17/s =>[signal: a_193_47# w=1]]', 'b: [connection X17/b =>[signal: VNB w=1]]']]
X__70__17 VGND _70__a_27_47# _70__a_193_47# no_conn_114 sky130_fd_pr__nfet_01v8 w=420000u l=150000u
** [instance X18 of sky130_fd_pr__nfet_01v8, params={'w': '360000u', 'l': '150000u'} connections=['d: [connection X18/d =>[signal: a_381_47# w=1]]', 'g: [connection X18/g =>[signal: a_27_47# w=1]]', 's: [connection X18/s =>[signal: a_466_413# w=1]]', 'b: [connection X18/b =>[signal: VNB w=1]]']]
X__70__18 _70__a_381_47# _70__a_27_47# _70__a_466_413# no_conn_114 sky130_fd_pr__nfet_01v8 w=360000u l=150000u
** [instance X19 of sky130_fd_pr__nfet_01v8, params={'w': '420000u', 'l': '150000u'} connections=['d: [connection X19/d =>[signal: a_27_47# w=1]]', 'g: [connection X19/g =>[signal: CLK w=1]]', 's: [connection X19/s =>[signal: VGND w=1]]', 'b: [connection X19/b =>[signal: VNB w=1]]']]
X__70__19 _70__a_27_47# _70_:CLK VGND no_conn_114 sky130_fd_pr__nfet_01v8 w=420000u l=150000u
** [instance X20 of sky130_fd_pr__pfet_01v8_hvt, params={'w': '640000u', 'l': '150000u'} connections=['d: [connection X20/d =>[signal: a_27_47# w=1]]', 'g: [connection X20/g =>[signal: CLK w=1]]', 's: [connection X20/s =>[signal: VPWR w=1]]', 'b: [connection X20/b =>[signal: VPB w=1]]']]
X__70__20 _70__a_27_47# _70_:CLK VPWR no_conn_115 sky130_fd_pr__pfet_01v8_hvt w=640000u l=150000u
** [instance X21 of sky130_fd_pr__nfet_01v8, params={'w': '650000u', 'l': '150000u'} connections=['d: [connection X21/d =>[signal: Q w=1]]', 'g: [connection X21/g =>[signal: a_1059_315# w=1]]', 's: [connection X21/s =>[signal: VGND w=1]]', 'b: [connection X21/b =>[signal: VNB w=1]]']]
X__70__21 _70_:Q _70__a_1059_315# VGND no_conn_114 sky130_fd_pr__nfet_01v8 w=650000u l=150000u
** [instance X22 of sky130_fd_pr__pfet_01v8_hvt, params={'w': '640000u', 'l': '150000u'} connections=['d: [connection X22/d =>[signal: VPWR w=1]]', 'g: [connection X22/g =>[signal: a_27_47# w=1]]', 's: [connection X22/s =>[signal: a_193_47# w=1]]', 'b: [connection X22/b =>[signal: VPB w=1]]']]
X__70__22 VPWR _70__a_27_47# _70__a_193_47# no_conn_115 sky130_fd_pr__pfet_01v8_hvt w=640000u l=150000u
** [instance X23 of sky130_fd_pr__nfet_01v8, params={'w': '420000u', 'l': '150000u'} connections=['d: [connection X23/d =>[signal: VGND w=1]]', 'g: [connection X23/g =>[signal: D w=1]]', 's: [connection X23/s =>[signal: a_381_47# w=1]]', 'b: [connection X23/b =>[signal: VNB w=1]]']]
X__70__23 VGND _70_:D _70__a_381_47# no_conn_114 sky130_fd_pr__nfet_01v8 w=420000u l=150000u
** [instance X24 of sky130_fd_pr__pfet_01v8_hvt, params={'w': '420000u', 'l': '150000u'} connections=['d: [connection X24/d =>[signal: a_975_413# w=1]]', 'g: [connection X24/g =>[signal: a_1059_315# w=1]]', 's: [connection X24/s =>[signal: VPWR w=1]]', 'b: [connection X24/b =>[signal: VPB w=1]]']]
X__70__24 _70__a_975_413# _70__a_1059_315# VPWR no_conn_115 sky130_fd_pr__pfet_01v8_hvt w=420000u l=150000u
** [instance X25 of sky130_fd_pr__nfet_01v8, params={'w': '650000u', 'l': '150000u'} connections=['d: [connection X25/d =>[signal: VGND w=1]]', 'g: [connection X25/g =>[signal: a_1059_315# w=1]]', 's: [connection X25/s =>[signal: Q w=1]]', 'b: [connection X25/b =>[signal: VNB w=1]]']]
X__70__25 VGND _70__a_1059_315# _70_:Q no_conn_114 sky130_fd_pr__nfet_01v8 w=650000u l=150000u

** replacing _71_ with the contents of sky130_fd_sc_hd__dfxtp_2
** [instance X0 of sky130_fd_pr__pfet_01v8_hvt, params={'w': '420000u', 'l': '150000u'} connections=['d: [connection X0/d =>[signal: a_891_413# w=1]]', 'g: [connection X0/g =>[signal: a_193_47# w=1]]', 's: [connection X0/s =>[signal: a_975_413# w=1]]', 'b: [connection X0/b =>[signal: VPB w=1]]']]
X__71__0 _71__a_891_413# _71__a_193_47# _71__a_975_413# no_conn_117 sky130_fd_pr__pfet_01v8_hvt w=420000u l=150000u
** [instance X1 of sky130_fd_pr__nfet_01v8, params={'w': '650000u', 'l': '150000u'} connections=['d: [connection X1/d =>[signal: a_1059_315# w=1]]', 'g: [connection X1/g =>[signal: a_891_413# w=1]]', 's: [connection X1/s =>[signal: VGND w=1]]', 'b: [connection X1/b =>[signal: VNB w=1]]']]
X__71__1 _71__a_1059_315# _71__a_891_413# VGND no_conn_116 sky130_fd_pr__nfet_01v8 w=650000u l=150000u
** [instance X2 of sky130_fd_pr__pfet_01v8_hvt, params={'w': '420000u', 'l': '150000u'} connections=['d: [connection X2/d =>[signal: a_466_413# w=1]]', 'g: [connection X2/g =>[signal: a_27_47# w=1]]', 's: [connection X2/s =>[signal: a_561_413# w=1]]', 'b: [connection X2/b =>[signal: VPB w=1]]']]
X__71__2 _71__a_466_413# _71__a_27_47# _71__a_561_413# no_conn_117 sky130_fd_pr__pfet_01v8_hvt w=420000u l=150000u
** [instance X3 of sky130_fd_pr__pfet_01v8_hvt, params={'w': '420000u', 'l': '150000u'} connections=['d: [connection X3/d =>[signal: a_634_159# w=1]]', 'g: [connection X3/g =>[signal: a_27_47# w=1]]', 's: [connection X3/s =>[signal: a_891_413# w=1]]', 'b: [connection X3/b =>[signal: VPB w=1]]']]
X__71__3 _71__a_634_159# _71__a_27_47# _71__a_891_413# no_conn_117 sky130_fd_pr__pfet_01v8_hvt w=420000u l=150000u
** [instance X4 of sky130_fd_pr__pfet_01v8_hvt, params={'w': '420000u', 'l': '150000u'} connections=['d: [connection X4/d =>[signal: a_381_47# w=1]]', 'g: [connection X4/g =>[signal: a_193_47# w=1]]', 's: [connection X4/s =>[signal: a_466_413# w=1]]', 'b: [connection X4/b =>[signal: VPB w=1]]']]
X__71__4 _71__a_381_47# _71__a_193_47# _71__a_466_413# no_conn_117 sky130_fd_pr__pfet_01v8_hvt w=420000u l=150000u
** [instance X5 of sky130_fd_pr__pfet_01v8_hvt, params={'w': '420000u', 'l': '150000u'} connections=['d: [connection X5/d =>[signal: VPWR w=1]]', 'g: [connection X5/g =>[signal: D w=1]]', 's: [connection X5/s =>[signal: a_381_47# w=1]]', 'b: [connection X5/b =>[signal: VPB w=1]]']]
X__71__5 VPWR _71_:D _71__a_381_47# no_conn_117 sky130_fd_pr__pfet_01v8_hvt w=420000u l=150000u
** [instance X6 of sky130_fd_pr__pfet_01v8_hvt, params={'w': '750000u', 'l': '150000u'} connections=['d: [connection X6/d =>[signal: VPWR w=1]]', 'g: [connection X6/g =>[signal: a_466_413# w=1]]', 's: [connection X6/s =>[signal: a_634_159# w=1]]', 'b: [connection X6/b =>[signal: VPB w=1]]']]
X__71__6 VPWR _71__a_466_413# _71__a_634_159# no_conn_117 sky130_fd_pr__pfet_01v8_hvt w=750000u l=150000u
** [instance X7 of sky130_fd_pr__nfet_01v8, params={'w': '640000u', 'l': '150000u'} connections=['d: [connection X7/d =>[signal: VGND w=1]]', 'g: [connection X7/g =>[signal: a_466_413# w=1]]', 's: [connection X7/s =>[signal: a_634_159# w=1]]', 'b: [connection X7/b =>[signal: VNB w=1]]']]
X__71__7 VGND _71__a_466_413# _71__a_634_159# no_conn_116 sky130_fd_pr__nfet_01v8 w=640000u l=150000u
** [instance X8 of sky130_fd_pr__nfet_01v8, params={'w': '420000u', 'l': '150000u'} connections=['d: [connection X8/d =>[signal: a_1017_47# w=1]]', 'g: [connection X8/g =>[signal: a_1059_315# w=1]]', 's: [connection X8/s =>[signal: VGND w=1]]', 'b: [connection X8/b =>[signal: VNB w=1]]']]
X__71__8 _71__a_1017_47# _71__a_1059_315# VGND no_conn_116 sky130_fd_pr__nfet_01v8 w=420000u l=150000u
** [instance X9 of sky130_fd_pr__pfet_01v8_hvt, params={'w': '1e+06u', 'l': '150000u'} connections=['d: [connection X9/d =>[signal: a_1059_315# w=1]]', 'g: [connection X9/g =>[signal: a_891_413# w=1]]', 's: [connection X9/s =>[signal: VPWR w=1]]', 'b: [connection X9/b =>[signal: VPB w=1]]']]
X__71__9 _71__a_1059_315# _71__a_891_413# VPWR no_conn_117 sky130_fd_pr__pfet_01v8_hvt w=1e+06u l=150000u
** [instance X10 of sky130_fd_pr__pfet_01v8_hvt, params={'w': '1e+06u', 'l': '150000u'} connections=['d: [connection X10/d =>[signal: Q w=1]]', 'g: [connection X10/g =>[signal: a_1059_315# w=1]]', 's: [connection X10/s =>[signal: VPWR w=1]]', 'b: [connection X10/b =>[signal: VPB w=1]]']]
X__71__10 _71_:Q _71__a_1059_315# VPWR no_conn_117 sky130_fd_pr__pfet_01v8_hvt w=1e+06u l=150000u
** [instance X11 of sky130_fd_pr__pfet_01v8_hvt, params={'w': '420000u', 'l': '150000u'} connections=['d: [connection X11/d =>[signal: a_561_413# w=1]]', 'g: [connection X11/g =>[signal: a_634_159# w=1]]', 's: [connection X11/s =>[signal: VPWR w=1]]', 'b: [connection X11/b =>[signal: VPB w=1]]']]
X__71__11 _71__a_561_413# _71__a_634_159# VPWR no_conn_117 sky130_fd_pr__pfet_01v8_hvt w=420000u l=150000u
** [instance X12 of sky130_fd_pr__pfet_01v8_hvt, params={'w': '1e+06u', 'l': '150000u'} connections=['d: [connection X12/d =>[signal: VPWR w=1]]', 'g: [connection X12/g =>[signal: a_1059_315# w=1]]', 's: [connection X12/s =>[signal: Q w=1]]', 'b: [connection X12/b =>[signal: VPB w=1]]']]
X__71__12 VPWR _71__a_1059_315# _71_:Q no_conn_117 sky130_fd_pr__pfet_01v8_hvt w=1e+06u l=150000u
** [instance X13 of sky130_fd_pr__nfet_01v8, params={'w': '360000u', 'l': '150000u'} connections=['d: [connection X13/d =>[signal: a_891_413# w=1]]', 'g: [connection X13/g =>[signal: a_27_47# w=1]]', 's: [connection X13/s =>[signal: a_1017_47# w=1]]', 'b: [connection X13/b =>[signal: VNB w=1]]']]
X__71__13 _71__a_891_413# _71__a_27_47# _71__a_1017_47# no_conn_116 sky130_fd_pr__nfet_01v8 w=360000u l=150000u
** [instance X14 of sky130_fd_pr__nfet_01v8, params={'w': '360000u', 'l': '150000u'} connections=['d: [connection X14/d =>[signal: a_634_159# w=1]]', 'g: [connection X14/g =>[signal: a_193_47# w=1]]', 's: [connection X14/s =>[signal: a_891_413# w=1]]', 'b: [connection X14/b =>[signal: VNB w=1]]']]
X__71__14 _71__a_634_159# _71__a_193_47# _71__a_891_413# no_conn_116 sky130_fd_pr__nfet_01v8 w=360000u l=150000u
** [instance X15 of sky130_fd_pr__nfet_01v8, params={'w': '420000u', 'l': '150000u'} connections=['d: [connection X15/d =>[signal: a_592_47# w=1]]', 'g: [connection X15/g =>[signal: a_634_159# w=1]]', 's: [connection X15/s =>[signal: VGND w=1]]', 'b: [connection X15/b =>[signal: VNB w=1]]']]
X__71__15 _71__a_592_47# _71__a_634_159# VGND no_conn_116 sky130_fd_pr__nfet_01v8 w=420000u l=150000u
** [instance X16 of sky130_fd_pr__nfet_01v8, params={'w': '360000u', 'l': '150000u'} connections=['d: [connection X16/d =>[signal: a_466_413# w=1]]', 'g: [connection X16/g =>[signal: a_193_47# w=1]]', 's: [connection X16/s =>[signal: a_592_47# w=1]]', 'b: [connection X16/b =>[signal: VNB w=1]]']]
X__71__16 _71__a_466_413# _71__a_193_47# _71__a_592_47# no_conn_116 sky130_fd_pr__nfet_01v8 w=360000u l=150000u
** [instance X17 of sky130_fd_pr__nfet_01v8, params={'w': '420000u', 'l': '150000u'} connections=['d: [connection X17/d =>[signal: VGND w=1]]', 'g: [connection X17/g =>[signal: a_27_47# w=1]]', 's: [connection X17/s =>[signal: a_193_47# w=1]]', 'b: [connection X17/b =>[signal: VNB w=1]]']]
X__71__17 VGND _71__a_27_47# _71__a_193_47# no_conn_116 sky130_fd_pr__nfet_01v8 w=420000u l=150000u
** [instance X18 of sky130_fd_pr__nfet_01v8, params={'w': '360000u', 'l': '150000u'} connections=['d: [connection X18/d =>[signal: a_381_47# w=1]]', 'g: [connection X18/g =>[signal: a_27_47# w=1]]', 's: [connection X18/s =>[signal: a_466_413# w=1]]', 'b: [connection X18/b =>[signal: VNB w=1]]']]
X__71__18 _71__a_381_47# _71__a_27_47# _71__a_466_413# no_conn_116 sky130_fd_pr__nfet_01v8 w=360000u l=150000u
** [instance X19 of sky130_fd_pr__nfet_01v8, params={'w': '420000u', 'l': '150000u'} connections=['d: [connection X19/d =>[signal: a_27_47# w=1]]', 'g: [connection X19/g =>[signal: CLK w=1]]', 's: [connection X19/s =>[signal: VGND w=1]]', 'b: [connection X19/b =>[signal: VNB w=1]]']]
X__71__19 _71__a_27_47# _71_:CLK VGND no_conn_116 sky130_fd_pr__nfet_01v8 w=420000u l=150000u
** [instance X20 of sky130_fd_pr__pfet_01v8_hvt, params={'w': '640000u', 'l': '150000u'} connections=['d: [connection X20/d =>[signal: a_27_47# w=1]]', 'g: [connection X20/g =>[signal: CLK w=1]]', 's: [connection X20/s =>[signal: VPWR w=1]]', 'b: [connection X20/b =>[signal: VPB w=1]]']]
X__71__20 _71__a_27_47# _71_:CLK VPWR no_conn_117 sky130_fd_pr__pfet_01v8_hvt w=640000u l=150000u
** [instance X21 of sky130_fd_pr__nfet_01v8, params={'w': '650000u', 'l': '150000u'} connections=['d: [connection X21/d =>[signal: Q w=1]]', 'g: [connection X21/g =>[signal: a_1059_315# w=1]]', 's: [connection X21/s =>[signal: VGND w=1]]', 'b: [connection X21/b =>[signal: VNB w=1]]']]
X__71__21 _71_:Q _71__a_1059_315# VGND no_conn_116 sky130_fd_pr__nfet_01v8 w=650000u l=150000u
** [instance X22 of sky130_fd_pr__pfet_01v8_hvt, params={'w': '640000u', 'l': '150000u'} connections=['d: [connection X22/d =>[signal: VPWR w=1]]', 'g: [connection X22/g =>[signal: a_27_47# w=1]]', 's: [connection X22/s =>[signal: a_193_47# w=1]]', 'b: [connection X22/b =>[signal: VPB w=1]]']]
X__71__22 VPWR _71__a_27_47# _71__a_193_47# no_conn_117 sky130_fd_pr__pfet_01v8_hvt w=640000u l=150000u
** [instance X23 of sky130_fd_pr__nfet_01v8, params={'w': '420000u', 'l': '150000u'} connections=['d: [connection X23/d =>[signal: VGND w=1]]', 'g: [connection X23/g =>[signal: D w=1]]', 's: [connection X23/s =>[signal: a_381_47# w=1]]', 'b: [connection X23/b =>[signal: VNB w=1]]']]
X__71__23 VGND _71_:D _71__a_381_47# no_conn_116 sky130_fd_pr__nfet_01v8 w=420000u l=150000u
** [instance X24 of sky130_fd_pr__pfet_01v8_hvt, params={'w': '420000u', 'l': '150000u'} connections=['d: [connection X24/d =>[signal: a_975_413# w=1]]', 'g: [connection X24/g =>[signal: a_1059_315# w=1]]', 's: [connection X24/s =>[signal: VPWR w=1]]', 'b: [connection X24/b =>[signal: VPB w=1]]']]
X__71__24 _71__a_975_413# _71__a_1059_315# VPWR no_conn_117 sky130_fd_pr__pfet_01v8_hvt w=420000u l=150000u
** [instance X25 of sky130_fd_pr__nfet_01v8, params={'w': '650000u', 'l': '150000u'} connections=['d: [connection X25/d =>[signal: VGND w=1]]', 'g: [connection X25/g =>[signal: a_1059_315# w=1]]', 's: [connection X25/s =>[signal: Q w=1]]', 'b: [connection X25/b =>[signal: VNB w=1]]']]
X__71__25 VGND _71__a_1059_315# _71_:Q no_conn_116 sky130_fd_pr__nfet_01v8 w=650000u l=150000u

** replacing _72_ with the contents of sky130_fd_sc_hd__dfxtp_2
** [instance X0 of sky130_fd_pr__pfet_01v8_hvt, params={'w': '420000u', 'l': '150000u'} connections=['d: [connection X0/d =>[signal: a_891_413# w=1]]', 'g: [connection X0/g =>[signal: a_193_47# w=1]]', 's: [connection X0/s =>[signal: a_975_413# w=1]]', 'b: [connection X0/b =>[signal: VPB w=1]]']]
X__72__0 _72__a_891_413# _72__a_193_47# _72__a_975_413# no_conn_119 sky130_fd_pr__pfet_01v8_hvt w=420000u l=150000u
** [instance X1 of sky130_fd_pr__nfet_01v8, params={'w': '650000u', 'l': '150000u'} connections=['d: [connection X1/d =>[signal: a_1059_315# w=1]]', 'g: [connection X1/g =>[signal: a_891_413# w=1]]', 's: [connection X1/s =>[signal: VGND w=1]]', 'b: [connection X1/b =>[signal: VNB w=1]]']]
X__72__1 _72__a_1059_315# _72__a_891_413# VGND no_conn_118 sky130_fd_pr__nfet_01v8 w=650000u l=150000u
** [instance X2 of sky130_fd_pr__pfet_01v8_hvt, params={'w': '420000u', 'l': '150000u'} connections=['d: [connection X2/d =>[signal: a_466_413# w=1]]', 'g: [connection X2/g =>[signal: a_27_47# w=1]]', 's: [connection X2/s =>[signal: a_561_413# w=1]]', 'b: [connection X2/b =>[signal: VPB w=1]]']]
X__72__2 _72__a_466_413# _72__a_27_47# _72__a_561_413# no_conn_119 sky130_fd_pr__pfet_01v8_hvt w=420000u l=150000u
** [instance X3 of sky130_fd_pr__pfet_01v8_hvt, params={'w': '420000u', 'l': '150000u'} connections=['d: [connection X3/d =>[signal: a_634_159# w=1]]', 'g: [connection X3/g =>[signal: a_27_47# w=1]]', 's: [connection X3/s =>[signal: a_891_413# w=1]]', 'b: [connection X3/b =>[signal: VPB w=1]]']]
X__72__3 _72__a_634_159# _72__a_27_47# _72__a_891_413# no_conn_119 sky130_fd_pr__pfet_01v8_hvt w=420000u l=150000u
** [instance X4 of sky130_fd_pr__pfet_01v8_hvt, params={'w': '420000u', 'l': '150000u'} connections=['d: [connection X4/d =>[signal: a_381_47# w=1]]', 'g: [connection X4/g =>[signal: a_193_47# w=1]]', 's: [connection X4/s =>[signal: a_466_413# w=1]]', 'b: [connection X4/b =>[signal: VPB w=1]]']]
X__72__4 _72__a_381_47# _72__a_193_47# _72__a_466_413# no_conn_119 sky130_fd_pr__pfet_01v8_hvt w=420000u l=150000u
** [instance X5 of sky130_fd_pr__pfet_01v8_hvt, params={'w': '420000u', 'l': '150000u'} connections=['d: [connection X5/d =>[signal: VPWR w=1]]', 'g: [connection X5/g =>[signal: D w=1]]', 's: [connection X5/s =>[signal: a_381_47# w=1]]', 'b: [connection X5/b =>[signal: VPB w=1]]']]
X__72__5 VPWR _72_:D _72__a_381_47# no_conn_119 sky130_fd_pr__pfet_01v8_hvt w=420000u l=150000u
** [instance X6 of sky130_fd_pr__pfet_01v8_hvt, params={'w': '750000u', 'l': '150000u'} connections=['d: [connection X6/d =>[signal: VPWR w=1]]', 'g: [connection X6/g =>[signal: a_466_413# w=1]]', 's: [connection X6/s =>[signal: a_634_159# w=1]]', 'b: [connection X6/b =>[signal: VPB w=1]]']]
X__72__6 VPWR _72__a_466_413# _72__a_634_159# no_conn_119 sky130_fd_pr__pfet_01v8_hvt w=750000u l=150000u
** [instance X7 of sky130_fd_pr__nfet_01v8, params={'w': '640000u', 'l': '150000u'} connections=['d: [connection X7/d =>[signal: VGND w=1]]', 'g: [connection X7/g =>[signal: a_466_413# w=1]]', 's: [connection X7/s =>[signal: a_634_159# w=1]]', 'b: [connection X7/b =>[signal: VNB w=1]]']]
X__72__7 VGND _72__a_466_413# _72__a_634_159# no_conn_118 sky130_fd_pr__nfet_01v8 w=640000u l=150000u
** [instance X8 of sky130_fd_pr__nfet_01v8, params={'w': '420000u', 'l': '150000u'} connections=['d: [connection X8/d =>[signal: a_1017_47# w=1]]', 'g: [connection X8/g =>[signal: a_1059_315# w=1]]', 's: [connection X8/s =>[signal: VGND w=1]]', 'b: [connection X8/b =>[signal: VNB w=1]]']]
X__72__8 _72__a_1017_47# _72__a_1059_315# VGND no_conn_118 sky130_fd_pr__nfet_01v8 w=420000u l=150000u
** [instance X9 of sky130_fd_pr__pfet_01v8_hvt, params={'w': '1e+06u', 'l': '150000u'} connections=['d: [connection X9/d =>[signal: a_1059_315# w=1]]', 'g: [connection X9/g =>[signal: a_891_413# w=1]]', 's: [connection X9/s =>[signal: VPWR w=1]]', 'b: [connection X9/b =>[signal: VPB w=1]]']]
X__72__9 _72__a_1059_315# _72__a_891_413# VPWR no_conn_119 sky130_fd_pr__pfet_01v8_hvt w=1e+06u l=150000u
** [instance X10 of sky130_fd_pr__pfet_01v8_hvt, params={'w': '1e+06u', 'l': '150000u'} connections=['d: [connection X10/d =>[signal: Q w=1]]', 'g: [connection X10/g =>[signal: a_1059_315# w=1]]', 's: [connection X10/s =>[signal: VPWR w=1]]', 'b: [connection X10/b =>[signal: VPB w=1]]']]
X__72__10 _72_:Q _72__a_1059_315# VPWR no_conn_119 sky130_fd_pr__pfet_01v8_hvt w=1e+06u l=150000u
** [instance X11 of sky130_fd_pr__pfet_01v8_hvt, params={'w': '420000u', 'l': '150000u'} connections=['d: [connection X11/d =>[signal: a_561_413# w=1]]', 'g: [connection X11/g =>[signal: a_634_159# w=1]]', 's: [connection X11/s =>[signal: VPWR w=1]]', 'b: [connection X11/b =>[signal: VPB w=1]]']]
X__72__11 _72__a_561_413# _72__a_634_159# VPWR no_conn_119 sky130_fd_pr__pfet_01v8_hvt w=420000u l=150000u
** [instance X12 of sky130_fd_pr__pfet_01v8_hvt, params={'w': '1e+06u', 'l': '150000u'} connections=['d: [connection X12/d =>[signal: VPWR w=1]]', 'g: [connection X12/g =>[signal: a_1059_315# w=1]]', 's: [connection X12/s =>[signal: Q w=1]]', 'b: [connection X12/b =>[signal: VPB w=1]]']]
X__72__12 VPWR _72__a_1059_315# _72_:Q no_conn_119 sky130_fd_pr__pfet_01v8_hvt w=1e+06u l=150000u
** [instance X13 of sky130_fd_pr__nfet_01v8, params={'w': '360000u', 'l': '150000u'} connections=['d: [connection X13/d =>[signal: a_891_413# w=1]]', 'g: [connection X13/g =>[signal: a_27_47# w=1]]', 's: [connection X13/s =>[signal: a_1017_47# w=1]]', 'b: [connection X13/b =>[signal: VNB w=1]]']]
X__72__13 _72__a_891_413# _72__a_27_47# _72__a_1017_47# no_conn_118 sky130_fd_pr__nfet_01v8 w=360000u l=150000u
** [instance X14 of sky130_fd_pr__nfet_01v8, params={'w': '360000u', 'l': '150000u'} connections=['d: [connection X14/d =>[signal: a_634_159# w=1]]', 'g: [connection X14/g =>[signal: a_193_47# w=1]]', 's: [connection X14/s =>[signal: a_891_413# w=1]]', 'b: [connection X14/b =>[signal: VNB w=1]]']]
X__72__14 _72__a_634_159# _72__a_193_47# _72__a_891_413# no_conn_118 sky130_fd_pr__nfet_01v8 w=360000u l=150000u
** [instance X15 of sky130_fd_pr__nfet_01v8, params={'w': '420000u', 'l': '150000u'} connections=['d: [connection X15/d =>[signal: a_592_47# w=1]]', 'g: [connection X15/g =>[signal: a_634_159# w=1]]', 's: [connection X15/s =>[signal: VGND w=1]]', 'b: [connection X15/b =>[signal: VNB w=1]]']]
X__72__15 _72__a_592_47# _72__a_634_159# VGND no_conn_118 sky130_fd_pr__nfet_01v8 w=420000u l=150000u
** [instance X16 of sky130_fd_pr__nfet_01v8, params={'w': '360000u', 'l': '150000u'} connections=['d: [connection X16/d =>[signal: a_466_413# w=1]]', 'g: [connection X16/g =>[signal: a_193_47# w=1]]', 's: [connection X16/s =>[signal: a_592_47# w=1]]', 'b: [connection X16/b =>[signal: VNB w=1]]']]
X__72__16 _72__a_466_413# _72__a_193_47# _72__a_592_47# no_conn_118 sky130_fd_pr__nfet_01v8 w=360000u l=150000u
** [instance X17 of sky130_fd_pr__nfet_01v8, params={'w': '420000u', 'l': '150000u'} connections=['d: [connection X17/d =>[signal: VGND w=1]]', 'g: [connection X17/g =>[signal: a_27_47# w=1]]', 's: [connection X17/s =>[signal: a_193_47# w=1]]', 'b: [connection X17/b =>[signal: VNB w=1]]']]
X__72__17 VGND _72__a_27_47# _72__a_193_47# no_conn_118 sky130_fd_pr__nfet_01v8 w=420000u l=150000u
** [instance X18 of sky130_fd_pr__nfet_01v8, params={'w': '360000u', 'l': '150000u'} connections=['d: [connection X18/d =>[signal: a_381_47# w=1]]', 'g: [connection X18/g =>[signal: a_27_47# w=1]]', 's: [connection X18/s =>[signal: a_466_413# w=1]]', 'b: [connection X18/b =>[signal: VNB w=1]]']]
X__72__18 _72__a_381_47# _72__a_27_47# _72__a_466_413# no_conn_118 sky130_fd_pr__nfet_01v8 w=360000u l=150000u
** [instance X19 of sky130_fd_pr__nfet_01v8, params={'w': '420000u', 'l': '150000u'} connections=['d: [connection X19/d =>[signal: a_27_47# w=1]]', 'g: [connection X19/g =>[signal: CLK w=1]]', 's: [connection X19/s =>[signal: VGND w=1]]', 'b: [connection X19/b =>[signal: VNB w=1]]']]
X__72__19 _72__a_27_47# _72_:CLK VGND no_conn_118 sky130_fd_pr__nfet_01v8 w=420000u l=150000u
** [instance X20 of sky130_fd_pr__pfet_01v8_hvt, params={'w': '640000u', 'l': '150000u'} connections=['d: [connection X20/d =>[signal: a_27_47# w=1]]', 'g: [connection X20/g =>[signal: CLK w=1]]', 's: [connection X20/s =>[signal: VPWR w=1]]', 'b: [connection X20/b =>[signal: VPB w=1]]']]
X__72__20 _72__a_27_47# _72_:CLK VPWR no_conn_119 sky130_fd_pr__pfet_01v8_hvt w=640000u l=150000u
** [instance X21 of sky130_fd_pr__nfet_01v8, params={'w': '650000u', 'l': '150000u'} connections=['d: [connection X21/d =>[signal: Q w=1]]', 'g: [connection X21/g =>[signal: a_1059_315# w=1]]', 's: [connection X21/s =>[signal: VGND w=1]]', 'b: [connection X21/b =>[signal: VNB w=1]]']]
X__72__21 _72_:Q _72__a_1059_315# VGND no_conn_118 sky130_fd_pr__nfet_01v8 w=650000u l=150000u
** [instance X22 of sky130_fd_pr__pfet_01v8_hvt, params={'w': '640000u', 'l': '150000u'} connections=['d: [connection X22/d =>[signal: VPWR w=1]]', 'g: [connection X22/g =>[signal: a_27_47# w=1]]', 's: [connection X22/s =>[signal: a_193_47# w=1]]', 'b: [connection X22/b =>[signal: VPB w=1]]']]
X__72__22 VPWR _72__a_27_47# _72__a_193_47# no_conn_119 sky130_fd_pr__pfet_01v8_hvt w=640000u l=150000u
** [instance X23 of sky130_fd_pr__nfet_01v8, params={'w': '420000u', 'l': '150000u'} connections=['d: [connection X23/d =>[signal: VGND w=1]]', 'g: [connection X23/g =>[signal: D w=1]]', 's: [connection X23/s =>[signal: a_381_47# w=1]]', 'b: [connection X23/b =>[signal: VNB w=1]]']]
X__72__23 VGND _72_:D _72__a_381_47# no_conn_118 sky130_fd_pr__nfet_01v8 w=420000u l=150000u
** [instance X24 of sky130_fd_pr__pfet_01v8_hvt, params={'w': '420000u', 'l': '150000u'} connections=['d: [connection X24/d =>[signal: a_975_413# w=1]]', 'g: [connection X24/g =>[signal: a_1059_315# w=1]]', 's: [connection X24/s =>[signal: VPWR w=1]]', 'b: [connection X24/b =>[signal: VPB w=1]]']]
X__72__24 _72__a_975_413# _72__a_1059_315# VPWR no_conn_119 sky130_fd_pr__pfet_01v8_hvt w=420000u l=150000u
** [instance X25 of sky130_fd_pr__nfet_01v8, params={'w': '650000u', 'l': '150000u'} connections=['d: [connection X25/d =>[signal: VGND w=1]]', 'g: [connection X25/g =>[signal: a_1059_315# w=1]]', 's: [connection X25/s =>[signal: Q w=1]]', 'b: [connection X25/b =>[signal: VNB w=1]]']]
X__72__25 VGND _72__a_1059_315# _72_:Q no_conn_118 sky130_fd_pr__nfet_01v8 w=650000u l=150000u

** replacing _73_ with the contents of sky130_fd_sc_hd__dfxtp_2
** [instance X0 of sky130_fd_pr__pfet_01v8_hvt, params={'w': '420000u', 'l': '150000u'} connections=['d: [connection X0/d =>[signal: a_891_413# w=1]]', 'g: [connection X0/g =>[signal: a_193_47# w=1]]', 's: [connection X0/s =>[signal: a_975_413# w=1]]', 'b: [connection X0/b =>[signal: VPB w=1]]']]
X__73__0 _73__a_891_413# _73__a_193_47# _73__a_975_413# no_conn_121 sky130_fd_pr__pfet_01v8_hvt w=420000u l=150000u
** [instance X1 of sky130_fd_pr__nfet_01v8, params={'w': '650000u', 'l': '150000u'} connections=['d: [connection X1/d =>[signal: a_1059_315# w=1]]', 'g: [connection X1/g =>[signal: a_891_413# w=1]]', 's: [connection X1/s =>[signal: VGND w=1]]', 'b: [connection X1/b =>[signal: VNB w=1]]']]
X__73__1 _73__a_1059_315# _73__a_891_413# VGND no_conn_120 sky130_fd_pr__nfet_01v8 w=650000u l=150000u
** [instance X2 of sky130_fd_pr__pfet_01v8_hvt, params={'w': '420000u', 'l': '150000u'} connections=['d: [connection X2/d =>[signal: a_466_413# w=1]]', 'g: [connection X2/g =>[signal: a_27_47# w=1]]', 's: [connection X2/s =>[signal: a_561_413# w=1]]', 'b: [connection X2/b =>[signal: VPB w=1]]']]
X__73__2 _73__a_466_413# _73__a_27_47# _73__a_561_413# no_conn_121 sky130_fd_pr__pfet_01v8_hvt w=420000u l=150000u
** [instance X3 of sky130_fd_pr__pfet_01v8_hvt, params={'w': '420000u', 'l': '150000u'} connections=['d: [connection X3/d =>[signal: a_634_159# w=1]]', 'g: [connection X3/g =>[signal: a_27_47# w=1]]', 's: [connection X3/s =>[signal: a_891_413# w=1]]', 'b: [connection X3/b =>[signal: VPB w=1]]']]
X__73__3 _73__a_634_159# _73__a_27_47# _73__a_891_413# no_conn_121 sky130_fd_pr__pfet_01v8_hvt w=420000u l=150000u
** [instance X4 of sky130_fd_pr__pfet_01v8_hvt, params={'w': '420000u', 'l': '150000u'} connections=['d: [connection X4/d =>[signal: a_381_47# w=1]]', 'g: [connection X4/g =>[signal: a_193_47# w=1]]', 's: [connection X4/s =>[signal: a_466_413# w=1]]', 'b: [connection X4/b =>[signal: VPB w=1]]']]
X__73__4 _73__a_381_47# _73__a_193_47# _73__a_466_413# no_conn_121 sky130_fd_pr__pfet_01v8_hvt w=420000u l=150000u
** [instance X5 of sky130_fd_pr__pfet_01v8_hvt, params={'w': '420000u', 'l': '150000u'} connections=['d: [connection X5/d =>[signal: VPWR w=1]]', 'g: [connection X5/g =>[signal: D w=1]]', 's: [connection X5/s =>[signal: a_381_47# w=1]]', 'b: [connection X5/b =>[signal: VPB w=1]]']]
X__73__5 VPWR _73_:D _73__a_381_47# no_conn_121 sky130_fd_pr__pfet_01v8_hvt w=420000u l=150000u
** [instance X6 of sky130_fd_pr__pfet_01v8_hvt, params={'w': '750000u', 'l': '150000u'} connections=['d: [connection X6/d =>[signal: VPWR w=1]]', 'g: [connection X6/g =>[signal: a_466_413# w=1]]', 's: [connection X6/s =>[signal: a_634_159# w=1]]', 'b: [connection X6/b =>[signal: VPB w=1]]']]
X__73__6 VPWR _73__a_466_413# _73__a_634_159# no_conn_121 sky130_fd_pr__pfet_01v8_hvt w=750000u l=150000u
** [instance X7 of sky130_fd_pr__nfet_01v8, params={'w': '640000u', 'l': '150000u'} connections=['d: [connection X7/d =>[signal: VGND w=1]]', 'g: [connection X7/g =>[signal: a_466_413# w=1]]', 's: [connection X7/s =>[signal: a_634_159# w=1]]', 'b: [connection X7/b =>[signal: VNB w=1]]']]
X__73__7 VGND _73__a_466_413# _73__a_634_159# no_conn_120 sky130_fd_pr__nfet_01v8 w=640000u l=150000u
** [instance X8 of sky130_fd_pr__nfet_01v8, params={'w': '420000u', 'l': '150000u'} connections=['d: [connection X8/d =>[signal: a_1017_47# w=1]]', 'g: [connection X8/g =>[signal: a_1059_315# w=1]]', 's: [connection X8/s =>[signal: VGND w=1]]', 'b: [connection X8/b =>[signal: VNB w=1]]']]
X__73__8 _73__a_1017_47# _73__a_1059_315# VGND no_conn_120 sky130_fd_pr__nfet_01v8 w=420000u l=150000u
** [instance X9 of sky130_fd_pr__pfet_01v8_hvt, params={'w': '1e+06u', 'l': '150000u'} connections=['d: [connection X9/d =>[signal: a_1059_315# w=1]]', 'g: [connection X9/g =>[signal: a_891_413# w=1]]', 's: [connection X9/s =>[signal: VPWR w=1]]', 'b: [connection X9/b =>[signal: VPB w=1]]']]
X__73__9 _73__a_1059_315# _73__a_891_413# VPWR no_conn_121 sky130_fd_pr__pfet_01v8_hvt w=1e+06u l=150000u
** [instance X10 of sky130_fd_pr__pfet_01v8_hvt, params={'w': '1e+06u', 'l': '150000u'} connections=['d: [connection X10/d =>[signal: Q w=1]]', 'g: [connection X10/g =>[signal: a_1059_315# w=1]]', 's: [connection X10/s =>[signal: VPWR w=1]]', 'b: [connection X10/b =>[signal: VPB w=1]]']]
X__73__10 _73_:Q _73__a_1059_315# VPWR no_conn_121 sky130_fd_pr__pfet_01v8_hvt w=1e+06u l=150000u
** [instance X11 of sky130_fd_pr__pfet_01v8_hvt, params={'w': '420000u', 'l': '150000u'} connections=['d: [connection X11/d =>[signal: a_561_413# w=1]]', 'g: [connection X11/g =>[signal: a_634_159# w=1]]', 's: [connection X11/s =>[signal: VPWR w=1]]', 'b: [connection X11/b =>[signal: VPB w=1]]']]
X__73__11 _73__a_561_413# _73__a_634_159# VPWR no_conn_121 sky130_fd_pr__pfet_01v8_hvt w=420000u l=150000u
** [instance X12 of sky130_fd_pr__pfet_01v8_hvt, params={'w': '1e+06u', 'l': '150000u'} connections=['d: [connection X12/d =>[signal: VPWR w=1]]', 'g: [connection X12/g =>[signal: a_1059_315# w=1]]', 's: [connection X12/s =>[signal: Q w=1]]', 'b: [connection X12/b =>[signal: VPB w=1]]']]
X__73__12 VPWR _73__a_1059_315# _73_:Q no_conn_121 sky130_fd_pr__pfet_01v8_hvt w=1e+06u l=150000u
** [instance X13 of sky130_fd_pr__nfet_01v8, params={'w': '360000u', 'l': '150000u'} connections=['d: [connection X13/d =>[signal: a_891_413# w=1]]', 'g: [connection X13/g =>[signal: a_27_47# w=1]]', 's: [connection X13/s =>[signal: a_1017_47# w=1]]', 'b: [connection X13/b =>[signal: VNB w=1]]']]
X__73__13 _73__a_891_413# _73__a_27_47# _73__a_1017_47# no_conn_120 sky130_fd_pr__nfet_01v8 w=360000u l=150000u
** [instance X14 of sky130_fd_pr__nfet_01v8, params={'w': '360000u', 'l': '150000u'} connections=['d: [connection X14/d =>[signal: a_634_159# w=1]]', 'g: [connection X14/g =>[signal: a_193_47# w=1]]', 's: [connection X14/s =>[signal: a_891_413# w=1]]', 'b: [connection X14/b =>[signal: VNB w=1]]']]
X__73__14 _73__a_634_159# _73__a_193_47# _73__a_891_413# no_conn_120 sky130_fd_pr__nfet_01v8 w=360000u l=150000u
** [instance X15 of sky130_fd_pr__nfet_01v8, params={'w': '420000u', 'l': '150000u'} connections=['d: [connection X15/d =>[signal: a_592_47# w=1]]', 'g: [connection X15/g =>[signal: a_634_159# w=1]]', 's: [connection X15/s =>[signal: VGND w=1]]', 'b: [connection X15/b =>[signal: VNB w=1]]']]
X__73__15 _73__a_592_47# _73__a_634_159# VGND no_conn_120 sky130_fd_pr__nfet_01v8 w=420000u l=150000u
** [instance X16 of sky130_fd_pr__nfet_01v8, params={'w': '360000u', 'l': '150000u'} connections=['d: [connection X16/d =>[signal: a_466_413# w=1]]', 'g: [connection X16/g =>[signal: a_193_47# w=1]]', 's: [connection X16/s =>[signal: a_592_47# w=1]]', 'b: [connection X16/b =>[signal: VNB w=1]]']]
X__73__16 _73__a_466_413# _73__a_193_47# _73__a_592_47# no_conn_120 sky130_fd_pr__nfet_01v8 w=360000u l=150000u
** [instance X17 of sky130_fd_pr__nfet_01v8, params={'w': '420000u', 'l': '150000u'} connections=['d: [connection X17/d =>[signal: VGND w=1]]', 'g: [connection X17/g =>[signal: a_27_47# w=1]]', 's: [connection X17/s =>[signal: a_193_47# w=1]]', 'b: [connection X17/b =>[signal: VNB w=1]]']]
X__73__17 VGND _73__a_27_47# _73__a_193_47# no_conn_120 sky130_fd_pr__nfet_01v8 w=420000u l=150000u
** [instance X18 of sky130_fd_pr__nfet_01v8, params={'w': '360000u', 'l': '150000u'} connections=['d: [connection X18/d =>[signal: a_381_47# w=1]]', 'g: [connection X18/g =>[signal: a_27_47# w=1]]', 's: [connection X18/s =>[signal: a_466_413# w=1]]', 'b: [connection X18/b =>[signal: VNB w=1]]']]
X__73__18 _73__a_381_47# _73__a_27_47# _73__a_466_413# no_conn_120 sky130_fd_pr__nfet_01v8 w=360000u l=150000u
** [instance X19 of sky130_fd_pr__nfet_01v8, params={'w': '420000u', 'l': '150000u'} connections=['d: [connection X19/d =>[signal: a_27_47# w=1]]', 'g: [connection X19/g =>[signal: CLK w=1]]', 's: [connection X19/s =>[signal: VGND w=1]]', 'b: [connection X19/b =>[signal: VNB w=1]]']]
X__73__19 _73__a_27_47# _73_:CLK VGND no_conn_120 sky130_fd_pr__nfet_01v8 w=420000u l=150000u
** [instance X20 of sky130_fd_pr__pfet_01v8_hvt, params={'w': '640000u', 'l': '150000u'} connections=['d: [connection X20/d =>[signal: a_27_47# w=1]]', 'g: [connection X20/g =>[signal: CLK w=1]]', 's: [connection X20/s =>[signal: VPWR w=1]]', 'b: [connection X20/b =>[signal: VPB w=1]]']]
X__73__20 _73__a_27_47# _73_:CLK VPWR no_conn_121 sky130_fd_pr__pfet_01v8_hvt w=640000u l=150000u
** [instance X21 of sky130_fd_pr__nfet_01v8, params={'w': '650000u', 'l': '150000u'} connections=['d: [connection X21/d =>[signal: Q w=1]]', 'g: [connection X21/g =>[signal: a_1059_315# w=1]]', 's: [connection X21/s =>[signal: VGND w=1]]', 'b: [connection X21/b =>[signal: VNB w=1]]']]
X__73__21 _73_:Q _73__a_1059_315# VGND no_conn_120 sky130_fd_pr__nfet_01v8 w=650000u l=150000u
** [instance X22 of sky130_fd_pr__pfet_01v8_hvt, params={'w': '640000u', 'l': '150000u'} connections=['d: [connection X22/d =>[signal: VPWR w=1]]', 'g: [connection X22/g =>[signal: a_27_47# w=1]]', 's: [connection X22/s =>[signal: a_193_47# w=1]]', 'b: [connection X22/b =>[signal: VPB w=1]]']]
X__73__22 VPWR _73__a_27_47# _73__a_193_47# no_conn_121 sky130_fd_pr__pfet_01v8_hvt w=640000u l=150000u
** [instance X23 of sky130_fd_pr__nfet_01v8, params={'w': '420000u', 'l': '150000u'} connections=['d: [connection X23/d =>[signal: VGND w=1]]', 'g: [connection X23/g =>[signal: D w=1]]', 's: [connection X23/s =>[signal: a_381_47# w=1]]', 'b: [connection X23/b =>[signal: VNB w=1]]']]
X__73__23 VGND _73_:D _73__a_381_47# no_conn_120 sky130_fd_pr__nfet_01v8 w=420000u l=150000u
** [instance X24 of sky130_fd_pr__pfet_01v8_hvt, params={'w': '420000u', 'l': '150000u'} connections=['d: [connection X24/d =>[signal: a_975_413# w=1]]', 'g: [connection X24/g =>[signal: a_1059_315# w=1]]', 's: [connection X24/s =>[signal: VPWR w=1]]', 'b: [connection X24/b =>[signal: VPB w=1]]']]
X__73__24 _73__a_975_413# _73__a_1059_315# VPWR no_conn_121 sky130_fd_pr__pfet_01v8_hvt w=420000u l=150000u
** [instance X25 of sky130_fd_pr__nfet_01v8, params={'w': '650000u', 'l': '150000u'} connections=['d: [connection X25/d =>[signal: VGND w=1]]', 'g: [connection X25/g =>[signal: a_1059_315# w=1]]', 's: [connection X25/s =>[signal: Q w=1]]', 'b: [connection X25/b =>[signal: VNB w=1]]']]
X__73__25 VGND _73__a_1059_315# _73_:Q no_conn_120 sky130_fd_pr__nfet_01v8 w=650000u l=150000u

** replacing hold24 with the contents of sky130_fd_sc_hd__dlygate4sd3_1
** [instance X0 of sky130_fd_pr__nfet_01v8, params={'w': '420000u', 'l': '500000u'} connections=['d: [connection X0/d =>[signal: a_391_47# w=1]]', 'g: [connection X0/g =>[signal: a_285_47# w=1]]', 's: [connection X0/s =>[signal: VGND w=1]]', 'b: [connection X0/b =>[signal: VNB w=1]]']]
X_hold24_0 hold24_a_391_47# hold24_a_285_47# VGND no_conn_122 sky130_fd_pr__nfet_01v8 w=420000u l=500000u
** [instance X1 of sky130_fd_pr__pfet_01v8_hvt, params={'w': '420000u', 'l': '500000u'} connections=['d: [connection X1/d =>[signal: VPWR w=1]]', 'g: [connection X1/g =>[signal: a_49_47# w=1]]', 's: [connection X1/s =>[signal: a_285_47# w=1]]', 'b: [connection X1/b =>[signal: VPB w=1]]']]
X_hold24_1 VPWR hold24_a_49_47# hold24_a_285_47# no_conn_123 sky130_fd_pr__pfet_01v8_hvt w=420000u l=500000u
** [instance X2 of sky130_fd_pr__nfet_01v8, params={'w': '420000u', 'l': '150000u'} connections=['d: [connection X2/d =>[signal: a_49_47# w=1]]', 'g: [connection X2/g =>[signal: A w=1]]', 's: [connection X2/s =>[signal: VGND w=1]]', 'b: [connection X2/b =>[signal: VNB w=1]]']]
X_hold24_2 hold24_a_49_47# hold24:A VGND no_conn_122 sky130_fd_pr__nfet_01v8 w=420000u l=150000u
** [instance X3 of sky130_fd_pr__pfet_01v8_hvt, params={'w': '1e+06u', 'l': '150000u'} connections=['d: [connection X3/d =>[signal: VPWR w=1]]', 'g: [connection X3/g =>[signal: a_391_47# w=1]]', 's: [connection X3/s =>[signal: X w=1]]', 'b: [connection X3/b =>[signal: VPB w=1]]']]
X_hold24_3 VPWR hold24_a_391_47# hold24:X no_conn_123 sky130_fd_pr__pfet_01v8_hvt w=1e+06u l=150000u
** [instance X4 of sky130_fd_pr__nfet_01v8, params={'w': '650000u', 'l': '150000u'} connections=['d: [connection X4/d =>[signal: VGND w=1]]', 'g: [connection X4/g =>[signal: a_391_47# w=1]]', 's: [connection X4/s =>[signal: X w=1]]', 'b: [connection X4/b =>[signal: VNB w=1]]']]
X_hold24_4 VGND hold24_a_391_47# hold24:X no_conn_122 sky130_fd_pr__nfet_01v8 w=650000u l=150000u
** [instance X5 of sky130_fd_pr__nfet_01v8, params={'w': '420000u', 'l': '500000u'} connections=['d: [connection X5/d =>[signal: VGND w=1]]', 'g: [connection X5/g =>[signal: a_49_47# w=1]]', 's: [connection X5/s =>[signal: a_285_47# w=1]]', 'b: [connection X5/b =>[signal: VNB w=1]]']]
X_hold24_5 VGND hold24_a_49_47# hold24_a_285_47# no_conn_122 sky130_fd_pr__nfet_01v8 w=420000u l=500000u
** [instance X6 of sky130_fd_pr__pfet_01v8_hvt, params={'w': '420000u', 'l': '500000u'} connections=['d: [connection X6/d =>[signal: a_391_47# w=1]]', 'g: [connection X6/g =>[signal: a_285_47# w=1]]', 's: [connection X6/s =>[signal: VPWR w=1]]', 'b: [connection X6/b =>[signal: VPB w=1]]']]
X_hold24_6 hold24_a_391_47# hold24_a_285_47# VPWR no_conn_123 sky130_fd_pr__pfet_01v8_hvt w=420000u l=500000u
** [instance X7 of sky130_fd_pr__pfet_01v8_hvt, params={'w': '420000u', 'l': '150000u'} connections=['d: [connection X7/d =>[signal: a_49_47# w=1]]', 'g: [connection X7/g =>[signal: A w=1]]', 's: [connection X7/s =>[signal: VPWR w=1]]', 'b: [connection X7/b =>[signal: VPB w=1]]']]
X_hold24_7 hold24_a_49_47# hold24:A VPWR no_conn_123 sky130_fd_pr__pfet_01v8_hvt w=420000u l=150000u

** replacing _69_ with the contents of sky130_fd_sc_hd__dfxtp_2
** [instance X0 of sky130_fd_pr__pfet_01v8_hvt, params={'w': '420000u', 'l': '150000u'} connections=['d: [connection X0/d =>[signal: a_891_413# w=1]]', 'g: [connection X0/g =>[signal: a_193_47# w=1]]', 's: [connection X0/s =>[signal: a_975_413# w=1]]', 'b: [connection X0/b =>[signal: VPB w=1]]']]
X__69__0 _69__a_891_413# _69__a_193_47# _69__a_975_413# no_conn_125 sky130_fd_pr__pfet_01v8_hvt w=420000u l=150000u
** [instance X1 of sky130_fd_pr__nfet_01v8, params={'w': '650000u', 'l': '150000u'} connections=['d: [connection X1/d =>[signal: a_1059_315# w=1]]', 'g: [connection X1/g =>[signal: a_891_413# w=1]]', 's: [connection X1/s =>[signal: VGND w=1]]', 'b: [connection X1/b =>[signal: VNB w=1]]']]
X__69__1 _69__a_1059_315# _69__a_891_413# VGND no_conn_124 sky130_fd_pr__nfet_01v8 w=650000u l=150000u
** [instance X2 of sky130_fd_pr__pfet_01v8_hvt, params={'w': '420000u', 'l': '150000u'} connections=['d: [connection X2/d =>[signal: a_466_413# w=1]]', 'g: [connection X2/g =>[signal: a_27_47# w=1]]', 's: [connection X2/s =>[signal: a_561_413# w=1]]', 'b: [connection X2/b =>[signal: VPB w=1]]']]
X__69__2 _69__a_466_413# _69__a_27_47# _69__a_561_413# no_conn_125 sky130_fd_pr__pfet_01v8_hvt w=420000u l=150000u
** [instance X3 of sky130_fd_pr__pfet_01v8_hvt, params={'w': '420000u', 'l': '150000u'} connections=['d: [connection X3/d =>[signal: a_634_159# w=1]]', 'g: [connection X3/g =>[signal: a_27_47# w=1]]', 's: [connection X3/s =>[signal: a_891_413# w=1]]', 'b: [connection X3/b =>[signal: VPB w=1]]']]
X__69__3 _69__a_634_159# _69__a_27_47# _69__a_891_413# no_conn_125 sky130_fd_pr__pfet_01v8_hvt w=420000u l=150000u
** [instance X4 of sky130_fd_pr__pfet_01v8_hvt, params={'w': '420000u', 'l': '150000u'} connections=['d: [connection X4/d =>[signal: a_381_47# w=1]]', 'g: [connection X4/g =>[signal: a_193_47# w=1]]', 's: [connection X4/s =>[signal: a_466_413# w=1]]', 'b: [connection X4/b =>[signal: VPB w=1]]']]
X__69__4 _69__a_381_47# _69__a_193_47# _69__a_466_413# no_conn_125 sky130_fd_pr__pfet_01v8_hvt w=420000u l=150000u
** [instance X5 of sky130_fd_pr__pfet_01v8_hvt, params={'w': '420000u', 'l': '150000u'} connections=['d: [connection X5/d =>[signal: VPWR w=1]]', 'g: [connection X5/g =>[signal: D w=1]]', 's: [connection X5/s =>[signal: a_381_47# w=1]]', 'b: [connection X5/b =>[signal: VPB w=1]]']]
X__69__5 VPWR _69_:D _69__a_381_47# no_conn_125 sky130_fd_pr__pfet_01v8_hvt w=420000u l=150000u
** [instance X6 of sky130_fd_pr__pfet_01v8_hvt, params={'w': '750000u', 'l': '150000u'} connections=['d: [connection X6/d =>[signal: VPWR w=1]]', 'g: [connection X6/g =>[signal: a_466_413# w=1]]', 's: [connection X6/s =>[signal: a_634_159# w=1]]', 'b: [connection X6/b =>[signal: VPB w=1]]']]
X__69__6 VPWR _69__a_466_413# _69__a_634_159# no_conn_125 sky130_fd_pr__pfet_01v8_hvt w=750000u l=150000u
** [instance X7 of sky130_fd_pr__nfet_01v8, params={'w': '640000u', 'l': '150000u'} connections=['d: [connection X7/d =>[signal: VGND w=1]]', 'g: [connection X7/g =>[signal: a_466_413# w=1]]', 's: [connection X7/s =>[signal: a_634_159# w=1]]', 'b: [connection X7/b =>[signal: VNB w=1]]']]
X__69__7 VGND _69__a_466_413# _69__a_634_159# no_conn_124 sky130_fd_pr__nfet_01v8 w=640000u l=150000u
** [instance X8 of sky130_fd_pr__nfet_01v8, params={'w': '420000u', 'l': '150000u'} connections=['d: [connection X8/d =>[signal: a_1017_47# w=1]]', 'g: [connection X8/g =>[signal: a_1059_315# w=1]]', 's: [connection X8/s =>[signal: VGND w=1]]', 'b: [connection X8/b =>[signal: VNB w=1]]']]
X__69__8 _69__a_1017_47# _69__a_1059_315# VGND no_conn_124 sky130_fd_pr__nfet_01v8 w=420000u l=150000u
** [instance X9 of sky130_fd_pr__pfet_01v8_hvt, params={'w': '1e+06u', 'l': '150000u'} connections=['d: [connection X9/d =>[signal: a_1059_315# w=1]]', 'g: [connection X9/g =>[signal: a_891_413# w=1]]', 's: [connection X9/s =>[signal: VPWR w=1]]', 'b: [connection X9/b =>[signal: VPB w=1]]']]
X__69__9 _69__a_1059_315# _69__a_891_413# VPWR no_conn_125 sky130_fd_pr__pfet_01v8_hvt w=1e+06u l=150000u
** [instance X10 of sky130_fd_pr__pfet_01v8_hvt, params={'w': '1e+06u', 'l': '150000u'} connections=['d: [connection X10/d =>[signal: Q w=1]]', 'g: [connection X10/g =>[signal: a_1059_315# w=1]]', 's: [connection X10/s =>[signal: VPWR w=1]]', 'b: [connection X10/b =>[signal: VPB w=1]]']]
X__69__10 _69_:Q _69__a_1059_315# VPWR no_conn_125 sky130_fd_pr__pfet_01v8_hvt w=1e+06u l=150000u
** [instance X11 of sky130_fd_pr__pfet_01v8_hvt, params={'w': '420000u', 'l': '150000u'} connections=['d: [connection X11/d =>[signal: a_561_413# w=1]]', 'g: [connection X11/g =>[signal: a_634_159# w=1]]', 's: [connection X11/s =>[signal: VPWR w=1]]', 'b: [connection X11/b =>[signal: VPB w=1]]']]
X__69__11 _69__a_561_413# _69__a_634_159# VPWR no_conn_125 sky130_fd_pr__pfet_01v8_hvt w=420000u l=150000u
** [instance X12 of sky130_fd_pr__pfet_01v8_hvt, params={'w': '1e+06u', 'l': '150000u'} connections=['d: [connection X12/d =>[signal: VPWR w=1]]', 'g: [connection X12/g =>[signal: a_1059_315# w=1]]', 's: [connection X12/s =>[signal: Q w=1]]', 'b: [connection X12/b =>[signal: VPB w=1]]']]
X__69__12 VPWR _69__a_1059_315# _69_:Q no_conn_125 sky130_fd_pr__pfet_01v8_hvt w=1e+06u l=150000u
** [instance X13 of sky130_fd_pr__nfet_01v8, params={'w': '360000u', 'l': '150000u'} connections=['d: [connection X13/d =>[signal: a_891_413# w=1]]', 'g: [connection X13/g =>[signal: a_27_47# w=1]]', 's: [connection X13/s =>[signal: a_1017_47# w=1]]', 'b: [connection X13/b =>[signal: VNB w=1]]']]
X__69__13 _69__a_891_413# _69__a_27_47# _69__a_1017_47# no_conn_124 sky130_fd_pr__nfet_01v8 w=360000u l=150000u
** [instance X14 of sky130_fd_pr__nfet_01v8, params={'w': '360000u', 'l': '150000u'} connections=['d: [connection X14/d =>[signal: a_634_159# w=1]]', 'g: [connection X14/g =>[signal: a_193_47# w=1]]', 's: [connection X14/s =>[signal: a_891_413# w=1]]', 'b: [connection X14/b =>[signal: VNB w=1]]']]
X__69__14 _69__a_634_159# _69__a_193_47# _69__a_891_413# no_conn_124 sky130_fd_pr__nfet_01v8 w=360000u l=150000u
** [instance X15 of sky130_fd_pr__nfet_01v8, params={'w': '420000u', 'l': '150000u'} connections=['d: [connection X15/d =>[signal: a_592_47# w=1]]', 'g: [connection X15/g =>[signal: a_634_159# w=1]]', 's: [connection X15/s =>[signal: VGND w=1]]', 'b: [connection X15/b =>[signal: VNB w=1]]']]
X__69__15 _69__a_592_47# _69__a_634_159# VGND no_conn_124 sky130_fd_pr__nfet_01v8 w=420000u l=150000u
** [instance X16 of sky130_fd_pr__nfet_01v8, params={'w': '360000u', 'l': '150000u'} connections=['d: [connection X16/d =>[signal: a_466_413# w=1]]', 'g: [connection X16/g =>[signal: a_193_47# w=1]]', 's: [connection X16/s =>[signal: a_592_47# w=1]]', 'b: [connection X16/b =>[signal: VNB w=1]]']]
X__69__16 _69__a_466_413# _69__a_193_47# _69__a_592_47# no_conn_124 sky130_fd_pr__nfet_01v8 w=360000u l=150000u
** [instance X17 of sky130_fd_pr__nfet_01v8, params={'w': '420000u', 'l': '150000u'} connections=['d: [connection X17/d =>[signal: VGND w=1]]', 'g: [connection X17/g =>[signal: a_27_47# w=1]]', 's: [connection X17/s =>[signal: a_193_47# w=1]]', 'b: [connection X17/b =>[signal: VNB w=1]]']]
X__69__17 VGND _69__a_27_47# _69__a_193_47# no_conn_124 sky130_fd_pr__nfet_01v8 w=420000u l=150000u
** [instance X18 of sky130_fd_pr__nfet_01v8, params={'w': '360000u', 'l': '150000u'} connections=['d: [connection X18/d =>[signal: a_381_47# w=1]]', 'g: [connection X18/g =>[signal: a_27_47# w=1]]', 's: [connection X18/s =>[signal: a_466_413# w=1]]', 'b: [connection X18/b =>[signal: VNB w=1]]']]
X__69__18 _69__a_381_47# _69__a_27_47# _69__a_466_413# no_conn_124 sky130_fd_pr__nfet_01v8 w=360000u l=150000u
** [instance X19 of sky130_fd_pr__nfet_01v8, params={'w': '420000u', 'l': '150000u'} connections=['d: [connection X19/d =>[signal: a_27_47# w=1]]', 'g: [connection X19/g =>[signal: CLK w=1]]', 's: [connection X19/s =>[signal: VGND w=1]]', 'b: [connection X19/b =>[signal: VNB w=1]]']]
X__69__19 _69__a_27_47# _69_:CLK VGND no_conn_124 sky130_fd_pr__nfet_01v8 w=420000u l=150000u
** [instance X20 of sky130_fd_pr__pfet_01v8_hvt, params={'w': '640000u', 'l': '150000u'} connections=['d: [connection X20/d =>[signal: a_27_47# w=1]]', 'g: [connection X20/g =>[signal: CLK w=1]]', 's: [connection X20/s =>[signal: VPWR w=1]]', 'b: [connection X20/b =>[signal: VPB w=1]]']]
X__69__20 _69__a_27_47# _69_:CLK VPWR no_conn_125 sky130_fd_pr__pfet_01v8_hvt w=640000u l=150000u
** [instance X21 of sky130_fd_pr__nfet_01v8, params={'w': '650000u', 'l': '150000u'} connections=['d: [connection X21/d =>[signal: Q w=1]]', 'g: [connection X21/g =>[signal: a_1059_315# w=1]]', 's: [connection X21/s =>[signal: VGND w=1]]', 'b: [connection X21/b =>[signal: VNB w=1]]']]
X__69__21 _69_:Q _69__a_1059_315# VGND no_conn_124 sky130_fd_pr__nfet_01v8 w=650000u l=150000u
** [instance X22 of sky130_fd_pr__pfet_01v8_hvt, params={'w': '640000u', 'l': '150000u'} connections=['d: [connection X22/d =>[signal: VPWR w=1]]', 'g: [connection X22/g =>[signal: a_27_47# w=1]]', 's: [connection X22/s =>[signal: a_193_47# w=1]]', 'b: [connection X22/b =>[signal: VPB w=1]]']]
X__69__22 VPWR _69__a_27_47# _69__a_193_47# no_conn_125 sky130_fd_pr__pfet_01v8_hvt w=640000u l=150000u
** [instance X23 of sky130_fd_pr__nfet_01v8, params={'w': '420000u', 'l': '150000u'} connections=['d: [connection X23/d =>[signal: VGND w=1]]', 'g: [connection X23/g =>[signal: D w=1]]', 's: [connection X23/s =>[signal: a_381_47# w=1]]', 'b: [connection X23/b =>[signal: VNB w=1]]']]
X__69__23 VGND _69_:D _69__a_381_47# no_conn_124 sky130_fd_pr__nfet_01v8 w=420000u l=150000u
** [instance X24 of sky130_fd_pr__pfet_01v8_hvt, params={'w': '420000u', 'l': '150000u'} connections=['d: [connection X24/d =>[signal: a_975_413# w=1]]', 'g: [connection X24/g =>[signal: a_1059_315# w=1]]', 's: [connection X24/s =>[signal: VPWR w=1]]', 'b: [connection X24/b =>[signal: VPB w=1]]']]
X__69__24 _69__a_975_413# _69__a_1059_315# VPWR no_conn_125 sky130_fd_pr__pfet_01v8_hvt w=420000u l=150000u
** [instance X25 of sky130_fd_pr__nfet_01v8, params={'w': '650000u', 'l': '150000u'} connections=['d: [connection X25/d =>[signal: VGND w=1]]', 'g: [connection X25/g =>[signal: a_1059_315# w=1]]', 's: [connection X25/s =>[signal: Q w=1]]', 'b: [connection X25/b =>[signal: VNB w=1]]']]
X__69__25 VGND _69__a_1059_315# _69_:Q no_conn_124 sky130_fd_pr__nfet_01v8 w=650000u l=150000u

** replacing _51_ with the contents of sky130_fd_sc_hd__mux2_1
** [instance X0 of sky130_fd_pr__pfet_01v8_hvt, params={'w': '420000u', 'l': '150000u'} connections=['d: [connection X0/d =>[signal: VPWR w=1]]', 'g: [connection X0/g =>[signal: S w=1]]', 's: [connection X0/s =>[signal: a_218_374# w=1]]', 'b: [connection X0/b =>[signal: VPB w=1]]']]
X__51__0 VPWR _51_:S _51__a_218_374# no_conn_127 sky130_fd_pr__pfet_01v8_hvt w=420000u l=150000u
** [instance X1 of sky130_fd_pr__nfet_01v8, params={'w': '420000u', 'l': '150000u'} connections=['d: [connection X1/d =>[signal: a_76_199# w=1]]', 'g: [connection X1/g =>[signal: A0 w=1]]', 's: [connection X1/s =>[signal: a_439_47# w=1]]', 'b: [connection X1/b =>[signal: VNB w=1]]']]
X__51__1 _51__a_76_199# _51_:A0 _51__a_439_47# no_conn_126 sky130_fd_pr__nfet_01v8 w=420000u l=150000u
** [instance X2 of sky130_fd_pr__pfet_01v8_hvt, params={'w': '420000u', 'l': '150000u'} connections=['d: [connection X2/d =>[signal: a_535_374# w=1]]', 'g: [connection X2/g =>[signal: a_505_21# w=1]]', 's: [connection X2/s =>[signal: VPWR w=1]]', 'b: [connection X2/b =>[signal: VPB w=1]]']]
X__51__2 _51__a_535_374# _51__a_505_21# VPWR no_conn_127 sky130_fd_pr__pfet_01v8_hvt w=420000u l=150000u
** [instance X3 of sky130_fd_pr__pfet_01v8_hvt, params={'w': '420000u', 'l': '150000u'} connections=['d: [connection X3/d =>[signal: VPWR w=1]]', 'g: [connection X3/g =>[signal: S w=1]]', 's: [connection X3/s =>[signal: a_505_21# w=1]]', 'b: [connection X3/b =>[signal: VPB w=1]]']]
X__51__3 VPWR _51_:S _51__a_505_21# no_conn_127 sky130_fd_pr__pfet_01v8_hvt w=420000u l=150000u
** [instance X4 of sky130_fd_pr__pfet_01v8_hvt, params={'w': '420000u', 'l': '150000u'} connections=['d: [connection X4/d =>[signal: a_76_199# w=1]]', 'g: [connection X4/g =>[signal: A1 w=1]]', 's: [connection X4/s =>[signal: a_535_374# w=1]]', 'b: [connection X4/b =>[signal: VPB w=1]]']]
X__51__4 _51__a_76_199# _51_:A1 _51__a_535_374# no_conn_127 sky130_fd_pr__pfet_01v8_hvt w=420000u l=150000u
** [instance X5 of sky130_fd_pr__nfet_01v8, params={'w': '420000u', 'l': '150000u'} connections=['d: [connection X5/d =>[signal: a_218_47# w=1]]', 'g: [connection X5/g =>[signal: A1 w=1]]', 's: [connection X5/s =>[signal: a_76_199# w=1]]', 'b: [connection X5/b =>[signal: VNB w=1]]']]
X__51__5 _51__a_218_47# _51_:A1 _51__a_76_199# no_conn_126 sky130_fd_pr__nfet_01v8 w=420000u l=150000u
** [instance X6 of sky130_fd_pr__pfet_01v8_hvt, params={'w': '420000u', 'l': '150000u'} connections=['d: [connection X6/d =>[signal: a_218_374# w=1]]', 'g: [connection X6/g =>[signal: A0 w=1]]', 's: [connection X6/s =>[signal: a_76_199# w=1]]', 'b: [connection X6/b =>[signal: VPB w=1]]']]
X__51__6 _51__a_218_374# _51_:A0 _51__a_76_199# no_conn_127 sky130_fd_pr__pfet_01v8_hvt w=420000u l=150000u
** [instance X7 of sky130_fd_pr__nfet_01v8, params={'w': '650000u', 'l': '150000u'} connections=['d: [connection X7/d =>[signal: X w=1]]', 'g: [connection X7/g =>[signal: a_76_199# w=1]]', 's: [connection X7/s =>[signal: VGND w=1]]', 'b: [connection X7/b =>[signal: VNB w=1]]']]
X__51__7 _51_:X _51__a_76_199# VGND no_conn_126 sky130_fd_pr__nfet_01v8 w=650000u l=150000u
** [instance X8 of sky130_fd_pr__pfet_01v8_hvt, params={'w': '1e+06u', 'l': '150000u'} connections=['d: [connection X8/d =>[signal: X w=1]]', 'g: [connection X8/g =>[signal: a_76_199# w=1]]', 's: [connection X8/s =>[signal: VPWR w=1]]', 'b: [connection X8/b =>[signal: VPB w=1]]']]
X__51__8 _51_:X _51__a_76_199# VPWR no_conn_127 sky130_fd_pr__pfet_01v8_hvt w=1e+06u l=150000u
** [instance X9 of sky130_fd_pr__nfet_01v8, params={'w': '420000u', 'l': '150000u'} connections=['d: [connection X9/d =>[signal: VGND w=1]]', 'g: [connection X9/g =>[signal: S w=1]]', 's: [connection X9/s =>[signal: a_218_47# w=1]]', 'b: [connection X9/b =>[signal: VNB w=1]]']]
X__51__9 VGND _51_:S _51__a_218_47# no_conn_126 sky130_fd_pr__nfet_01v8 w=420000u l=150000u
** [instance X10 of sky130_fd_pr__nfet_01v8, params={'w': '420000u', 'l': '150000u'} connections=['d: [connection X10/d =>[signal: VGND w=1]]', 'g: [connection X10/g =>[signal: S w=1]]', 's: [connection X10/s =>[signal: a_505_21# w=1]]', 'b: [connection X10/b =>[signal: VNB w=1]]']]
X__51__10 VGND _51_:S _51__a_505_21# no_conn_126 sky130_fd_pr__nfet_01v8 w=420000u l=150000u
** [instance X11 of sky130_fd_pr__nfet_01v8, params={'w': '420000u', 'l': '150000u'} connections=['d: [connection X11/d =>[signal: a_439_47# w=1]]', 'g: [connection X11/g =>[signal: a_505_21# w=1]]', 's: [connection X11/s =>[signal: VGND w=1]]', 'b: [connection X11/b =>[signal: VNB w=1]]']]
X__51__11 _51__a_439_47# _51__a_505_21# VGND no_conn_126 sky130_fd_pr__nfet_01v8 w=420000u l=150000u

** replacing hold34 with the contents of sky130_fd_sc_hd__dlygate4sd3_1
** [instance X0 of sky130_fd_pr__nfet_01v8, params={'w': '420000u', 'l': '500000u'} connections=['d: [connection X0/d =>[signal: a_391_47# w=1]]', 'g: [connection X0/g =>[signal: a_285_47# w=1]]', 's: [connection X0/s =>[signal: VGND w=1]]', 'b: [connection X0/b =>[signal: VNB w=1]]']]
X_hold34_0 hold34_a_391_47# hold34_a_285_47# VGND no_conn_128 sky130_fd_pr__nfet_01v8 w=420000u l=500000u
** [instance X1 of sky130_fd_pr__pfet_01v8_hvt, params={'w': '420000u', 'l': '500000u'} connections=['d: [connection X1/d =>[signal: VPWR w=1]]', 'g: [connection X1/g =>[signal: a_49_47# w=1]]', 's: [connection X1/s =>[signal: a_285_47# w=1]]', 'b: [connection X1/b =>[signal: VPB w=1]]']]
X_hold34_1 VPWR hold34_a_49_47# hold34_a_285_47# no_conn_129 sky130_fd_pr__pfet_01v8_hvt w=420000u l=500000u
** [instance X2 of sky130_fd_pr__nfet_01v8, params={'w': '420000u', 'l': '150000u'} connections=['d: [connection X2/d =>[signal: a_49_47# w=1]]', 'g: [connection X2/g =>[signal: A w=1]]', 's: [connection X2/s =>[signal: VGND w=1]]', 'b: [connection X2/b =>[signal: VNB w=1]]']]
X_hold34_2 hold34_a_49_47# hold34:A VGND no_conn_128 sky130_fd_pr__nfet_01v8 w=420000u l=150000u
** [instance X3 of sky130_fd_pr__pfet_01v8_hvt, params={'w': '1e+06u', 'l': '150000u'} connections=['d: [connection X3/d =>[signal: VPWR w=1]]', 'g: [connection X3/g =>[signal: a_391_47# w=1]]', 's: [connection X3/s =>[signal: X w=1]]', 'b: [connection X3/b =>[signal: VPB w=1]]']]
X_hold34_3 VPWR hold34_a_391_47# hold34:X no_conn_129 sky130_fd_pr__pfet_01v8_hvt w=1e+06u l=150000u
** [instance X4 of sky130_fd_pr__nfet_01v8, params={'w': '650000u', 'l': '150000u'} connections=['d: [connection X4/d =>[signal: VGND w=1]]', 'g: [connection X4/g =>[signal: a_391_47# w=1]]', 's: [connection X4/s =>[signal: X w=1]]', 'b: [connection X4/b =>[signal: VNB w=1]]']]
X_hold34_4 VGND hold34_a_391_47# hold34:X no_conn_128 sky130_fd_pr__nfet_01v8 w=650000u l=150000u
** [instance X5 of sky130_fd_pr__nfet_01v8, params={'w': '420000u', 'l': '500000u'} connections=['d: [connection X5/d =>[signal: VGND w=1]]', 'g: [connection X5/g =>[signal: a_49_47# w=1]]', 's: [connection X5/s =>[signal: a_285_47# w=1]]', 'b: [connection X5/b =>[signal: VNB w=1]]']]
X_hold34_5 VGND hold34_a_49_47# hold34_a_285_47# no_conn_128 sky130_fd_pr__nfet_01v8 w=420000u l=500000u
** [instance X6 of sky130_fd_pr__pfet_01v8_hvt, params={'w': '420000u', 'l': '500000u'} connections=['d: [connection X6/d =>[signal: a_391_47# w=1]]', 'g: [connection X6/g =>[signal: a_285_47# w=1]]', 's: [connection X6/s =>[signal: VPWR w=1]]', 'b: [connection X6/b =>[signal: VPB w=1]]']]
X_hold34_6 hold34_a_391_47# hold34_a_285_47# VPWR no_conn_129 sky130_fd_pr__pfet_01v8_hvt w=420000u l=500000u
** [instance X7 of sky130_fd_pr__pfet_01v8_hvt, params={'w': '420000u', 'l': '150000u'} connections=['d: [connection X7/d =>[signal: a_49_47# w=1]]', 'g: [connection X7/g =>[signal: A w=1]]', 's: [connection X7/s =>[signal: VPWR w=1]]', 'b: [connection X7/b =>[signal: VPB w=1]]']]
X_hold34_7 hold34_a_49_47# hold34:A VPWR no_conn_129 sky130_fd_pr__pfet_01v8_hvt w=420000u l=150000u

** replacing _52_ with the contents of sky130_fd_sc_hd__mux2_1
** [instance X0 of sky130_fd_pr__pfet_01v8_hvt, params={'w': '420000u', 'l': '150000u'} connections=['d: [connection X0/d =>[signal: VPWR w=1]]', 'g: [connection X0/g =>[signal: S w=1]]', 's: [connection X0/s =>[signal: a_218_374# w=1]]', 'b: [connection X0/b =>[signal: VPB w=1]]']]
X__52__0 VPWR _52_:S _52__a_218_374# no_conn_131 sky130_fd_pr__pfet_01v8_hvt w=420000u l=150000u
** [instance X1 of sky130_fd_pr__nfet_01v8, params={'w': '420000u', 'l': '150000u'} connections=['d: [connection X1/d =>[signal: a_76_199# w=1]]', 'g: [connection X1/g =>[signal: A0 w=1]]', 's: [connection X1/s =>[signal: a_439_47# w=1]]', 'b: [connection X1/b =>[signal: VNB w=1]]']]
X__52__1 _52__a_76_199# _52_:A0 _52__a_439_47# no_conn_130 sky130_fd_pr__nfet_01v8 w=420000u l=150000u
** [instance X2 of sky130_fd_pr__pfet_01v8_hvt, params={'w': '420000u', 'l': '150000u'} connections=['d: [connection X2/d =>[signal: a_535_374# w=1]]', 'g: [connection X2/g =>[signal: a_505_21# w=1]]', 's: [connection X2/s =>[signal: VPWR w=1]]', 'b: [connection X2/b =>[signal: VPB w=1]]']]
X__52__2 _52__a_535_374# _52__a_505_21# VPWR no_conn_131 sky130_fd_pr__pfet_01v8_hvt w=420000u l=150000u
** [instance X3 of sky130_fd_pr__pfet_01v8_hvt, params={'w': '420000u', 'l': '150000u'} connections=['d: [connection X3/d =>[signal: VPWR w=1]]', 'g: [connection X3/g =>[signal: S w=1]]', 's: [connection X3/s =>[signal: a_505_21# w=1]]', 'b: [connection X3/b =>[signal: VPB w=1]]']]
X__52__3 VPWR _52_:S _52__a_505_21# no_conn_131 sky130_fd_pr__pfet_01v8_hvt w=420000u l=150000u
** [instance X4 of sky130_fd_pr__pfet_01v8_hvt, params={'w': '420000u', 'l': '150000u'} connections=['d: [connection X4/d =>[signal: a_76_199# w=1]]', 'g: [connection X4/g =>[signal: A1 w=1]]', 's: [connection X4/s =>[signal: a_535_374# w=1]]', 'b: [connection X4/b =>[signal: VPB w=1]]']]
X__52__4 _52__a_76_199# _52_:A1 _52__a_535_374# no_conn_131 sky130_fd_pr__pfet_01v8_hvt w=420000u l=150000u
** [instance X5 of sky130_fd_pr__nfet_01v8, params={'w': '420000u', 'l': '150000u'} connections=['d: [connection X5/d =>[signal: a_218_47# w=1]]', 'g: [connection X5/g =>[signal: A1 w=1]]', 's: [connection X5/s =>[signal: a_76_199# w=1]]', 'b: [connection X5/b =>[signal: VNB w=1]]']]
X__52__5 _52__a_218_47# _52_:A1 _52__a_76_199# no_conn_130 sky130_fd_pr__nfet_01v8 w=420000u l=150000u
** [instance X6 of sky130_fd_pr__pfet_01v8_hvt, params={'w': '420000u', 'l': '150000u'} connections=['d: [connection X6/d =>[signal: a_218_374# w=1]]', 'g: [connection X6/g =>[signal: A0 w=1]]', 's: [connection X6/s =>[signal: a_76_199# w=1]]', 'b: [connection X6/b =>[signal: VPB w=1]]']]
X__52__6 _52__a_218_374# _52_:A0 _52__a_76_199# no_conn_131 sky130_fd_pr__pfet_01v8_hvt w=420000u l=150000u
** [instance X7 of sky130_fd_pr__nfet_01v8, params={'w': '650000u', 'l': '150000u'} connections=['d: [connection X7/d =>[signal: X w=1]]', 'g: [connection X7/g =>[signal: a_76_199# w=1]]', 's: [connection X7/s =>[signal: VGND w=1]]', 'b: [connection X7/b =>[signal: VNB w=1]]']]
X__52__7 _52_:X _52__a_76_199# VGND no_conn_130 sky130_fd_pr__nfet_01v8 w=650000u l=150000u
** [instance X8 of sky130_fd_pr__pfet_01v8_hvt, params={'w': '1e+06u', 'l': '150000u'} connections=['d: [connection X8/d =>[signal: X w=1]]', 'g: [connection X8/g =>[signal: a_76_199# w=1]]', 's: [connection X8/s =>[signal: VPWR w=1]]', 'b: [connection X8/b =>[signal: VPB w=1]]']]
X__52__8 _52_:X _52__a_76_199# VPWR no_conn_131 sky130_fd_pr__pfet_01v8_hvt w=1e+06u l=150000u
** [instance X9 of sky130_fd_pr__nfet_01v8, params={'w': '420000u', 'l': '150000u'} connections=['d: [connection X9/d =>[signal: VGND w=1]]', 'g: [connection X9/g =>[signal: S w=1]]', 's: [connection X9/s =>[signal: a_218_47# w=1]]', 'b: [connection X9/b =>[signal: VNB w=1]]']]
X__52__9 VGND _52_:S _52__a_218_47# no_conn_130 sky130_fd_pr__nfet_01v8 w=420000u l=150000u
** [instance X10 of sky130_fd_pr__nfet_01v8, params={'w': '420000u', 'l': '150000u'} connections=['d: [connection X10/d =>[signal: VGND w=1]]', 'g: [connection X10/g =>[signal: S w=1]]', 's: [connection X10/s =>[signal: a_505_21# w=1]]', 'b: [connection X10/b =>[signal: VNB w=1]]']]
X__52__10 VGND _52_:S _52__a_505_21# no_conn_130 sky130_fd_pr__nfet_01v8 w=420000u l=150000u
** [instance X11 of sky130_fd_pr__nfet_01v8, params={'w': '420000u', 'l': '150000u'} connections=['d: [connection X11/d =>[signal: a_439_47# w=1]]', 'g: [connection X11/g =>[signal: a_505_21# w=1]]', 's: [connection X11/s =>[signal: VGND w=1]]', 'b: [connection X11/b =>[signal: VNB w=1]]']]
X__52__11 _52__a_439_47# _52__a_505_21# VGND no_conn_130 sky130_fd_pr__nfet_01v8 w=420000u l=150000u

** replacing _53_ with the contents of sky130_fd_sc_hd__mux2_1
** [instance X0 of sky130_fd_pr__pfet_01v8_hvt, params={'w': '420000u', 'l': '150000u'} connections=['d: [connection X0/d =>[signal: VPWR w=1]]', 'g: [connection X0/g =>[signal: S w=1]]', 's: [connection X0/s =>[signal: a_218_374# w=1]]', 'b: [connection X0/b =>[signal: VPB w=1]]']]
X__53__0 VPWR _53_:S _53__a_218_374# no_conn_133 sky130_fd_pr__pfet_01v8_hvt w=420000u l=150000u
** [instance X1 of sky130_fd_pr__nfet_01v8, params={'w': '420000u', 'l': '150000u'} connections=['d: [connection X1/d =>[signal: a_76_199# w=1]]', 'g: [connection X1/g =>[signal: A0 w=1]]', 's: [connection X1/s =>[signal: a_439_47# w=1]]', 'b: [connection X1/b =>[signal: VNB w=1]]']]
X__53__1 _53__a_76_199# _53_:A0 _53__a_439_47# no_conn_132 sky130_fd_pr__nfet_01v8 w=420000u l=150000u
** [instance X2 of sky130_fd_pr__pfet_01v8_hvt, params={'w': '420000u', 'l': '150000u'} connections=['d: [connection X2/d =>[signal: a_535_374# w=1]]', 'g: [connection X2/g =>[signal: a_505_21# w=1]]', 's: [connection X2/s =>[signal: VPWR w=1]]', 'b: [connection X2/b =>[signal: VPB w=1]]']]
X__53__2 _53__a_535_374# _53__a_505_21# VPWR no_conn_133 sky130_fd_pr__pfet_01v8_hvt w=420000u l=150000u
** [instance X3 of sky130_fd_pr__pfet_01v8_hvt, params={'w': '420000u', 'l': '150000u'} connections=['d: [connection X3/d =>[signal: VPWR w=1]]', 'g: [connection X3/g =>[signal: S w=1]]', 's: [connection X3/s =>[signal: a_505_21# w=1]]', 'b: [connection X3/b =>[signal: VPB w=1]]']]
X__53__3 VPWR _53_:S _53__a_505_21# no_conn_133 sky130_fd_pr__pfet_01v8_hvt w=420000u l=150000u
** [instance X4 of sky130_fd_pr__pfet_01v8_hvt, params={'w': '420000u', 'l': '150000u'} connections=['d: [connection X4/d =>[signal: a_76_199# w=1]]', 'g: [connection X4/g =>[signal: A1 w=1]]', 's: [connection X4/s =>[signal: a_535_374# w=1]]', 'b: [connection X4/b =>[signal: VPB w=1]]']]
X__53__4 _53__a_76_199# _53_:A1 _53__a_535_374# no_conn_133 sky130_fd_pr__pfet_01v8_hvt w=420000u l=150000u
** [instance X5 of sky130_fd_pr__nfet_01v8, params={'w': '420000u', 'l': '150000u'} connections=['d: [connection X5/d =>[signal: a_218_47# w=1]]', 'g: [connection X5/g =>[signal: A1 w=1]]', 's: [connection X5/s =>[signal: a_76_199# w=1]]', 'b: [connection X5/b =>[signal: VNB w=1]]']]
X__53__5 _53__a_218_47# _53_:A1 _53__a_76_199# no_conn_132 sky130_fd_pr__nfet_01v8 w=420000u l=150000u
** [instance X6 of sky130_fd_pr__pfet_01v8_hvt, params={'w': '420000u', 'l': '150000u'} connections=['d: [connection X6/d =>[signal: a_218_374# w=1]]', 'g: [connection X6/g =>[signal: A0 w=1]]', 's: [connection X6/s =>[signal: a_76_199# w=1]]', 'b: [connection X6/b =>[signal: VPB w=1]]']]
X__53__6 _53__a_218_374# _53_:A0 _53__a_76_199# no_conn_133 sky130_fd_pr__pfet_01v8_hvt w=420000u l=150000u
** [instance X7 of sky130_fd_pr__nfet_01v8, params={'w': '650000u', 'l': '150000u'} connections=['d: [connection X7/d =>[signal: X w=1]]', 'g: [connection X7/g =>[signal: a_76_199# w=1]]', 's: [connection X7/s =>[signal: VGND w=1]]', 'b: [connection X7/b =>[signal: VNB w=1]]']]
X__53__7 _53_:X _53__a_76_199# VGND no_conn_132 sky130_fd_pr__nfet_01v8 w=650000u l=150000u
** [instance X8 of sky130_fd_pr__pfet_01v8_hvt, params={'w': '1e+06u', 'l': '150000u'} connections=['d: [connection X8/d =>[signal: X w=1]]', 'g: [connection X8/g =>[signal: a_76_199# w=1]]', 's: [connection X8/s =>[signal: VPWR w=1]]', 'b: [connection X8/b =>[signal: VPB w=1]]']]
X__53__8 _53_:X _53__a_76_199# VPWR no_conn_133 sky130_fd_pr__pfet_01v8_hvt w=1e+06u l=150000u
** [instance X9 of sky130_fd_pr__nfet_01v8, params={'w': '420000u', 'l': '150000u'} connections=['d: [connection X9/d =>[signal: VGND w=1]]', 'g: [connection X9/g =>[signal: S w=1]]', 's: [connection X9/s =>[signal: a_218_47# w=1]]', 'b: [connection X9/b =>[signal: VNB w=1]]']]
X__53__9 VGND _53_:S _53__a_218_47# no_conn_132 sky130_fd_pr__nfet_01v8 w=420000u l=150000u
** [instance X10 of sky130_fd_pr__nfet_01v8, params={'w': '420000u', 'l': '150000u'} connections=['d: [connection X10/d =>[signal: VGND w=1]]', 'g: [connection X10/g =>[signal: S w=1]]', 's: [connection X10/s =>[signal: a_505_21# w=1]]', 'b: [connection X10/b =>[signal: VNB w=1]]']]
X__53__10 VGND _53_:S _53__a_505_21# no_conn_132 sky130_fd_pr__nfet_01v8 w=420000u l=150000u
** [instance X11 of sky130_fd_pr__nfet_01v8, params={'w': '420000u', 'l': '150000u'} connections=['d: [connection X11/d =>[signal: a_439_47# w=1]]', 'g: [connection X11/g =>[signal: a_505_21# w=1]]', 's: [connection X11/s =>[signal: VGND w=1]]', 'b: [connection X11/b =>[signal: VNB w=1]]']]
X__53__11 _53__a_439_47# _53__a_505_21# VGND no_conn_132 sky130_fd_pr__nfet_01v8 w=420000u l=150000u

** replacing _34_ with the contents of sky130_fd_sc_hd__o21a_2
** [instance X0 of sky130_fd_pr__nfet_01v8, params={'w': '650000u', 'l': '150000u'} connections=['d: [connection X0/d =>[signal: a_384_47# w=1]]', 'g: [connection X0/g =>[signal: A2 w=1]]', 's: [connection X0/s =>[signal: VGND w=1]]', 'b: [connection X0/b =>[signal: VNB w=1]]']]
X__34__0 _34__a_384_47# _34_:A2 VGND no_conn_134 sky130_fd_pr__nfet_01v8 w=650000u l=150000u
** [instance X1 of sky130_fd_pr__nfet_01v8, params={'w': '650000u', 'l': '150000u'} connections=['d: [connection X1/d =>[signal: X w=1]]', 'g: [connection X1/g =>[signal: a_79_21# w=1]]', 's: [connection X1/s =>[signal: VGND w=1]]', 'b: [connection X1/b =>[signal: VNB w=1]]']]
X__34__1 _34_:X _34__a_79_21# VGND no_conn_134 sky130_fd_pr__nfet_01v8 w=650000u l=150000u
** [instance X2 of sky130_fd_pr__pfet_01v8_hvt, params={'w': '1e+06u', 'l': '150000u'} connections=['d: [connection X2/d =>[signal: a_470_297# w=1]]', 'g: [connection X2/g =>[signal: A1 w=1]]', 's: [connection X2/s =>[signal: VPWR w=1]]', 'b: [connection X2/b =>[signal: VPB w=1]]']]
X__34__2 _34__a_470_297# _34_:A1 VPWR no_conn_135 sky130_fd_pr__pfet_01v8_hvt w=1e+06u l=150000u
** [instance X3 of sky130_fd_pr__pfet_01v8_hvt, params={'w': '1e+06u', 'l': '150000u'} connections=['d: [connection X3/d =>[signal: VPWR w=1]]', 'g: [connection X3/g =>[signal: B1 w=1]]', 's: [connection X3/s =>[signal: a_79_21# w=1]]', 'b: [connection X3/b =>[signal: VPB w=1]]']]
X__34__3 VPWR _34_:B1 _34__a_79_21# no_conn_135 sky130_fd_pr__pfet_01v8_hvt w=1e+06u l=150000u
** [instance X4 of sky130_fd_pr__nfet_01v8, params={'w': '650000u', 'l': '150000u'} connections=['d: [connection X4/d =>[signal: VGND w=1]]', 'g: [connection X4/g =>[signal: A1 w=1]]', 's: [connection X4/s =>[signal: a_384_47# w=1]]', 'b: [connection X4/b =>[signal: VNB w=1]]']]
X__34__4 VGND _34_:A1 _34__a_384_47# no_conn_134 sky130_fd_pr__nfet_01v8 w=650000u l=150000u
** [instance X5 of sky130_fd_pr__nfet_01v8, params={'w': '650000u', 'l': '150000u'} connections=['d: [connection X5/d =>[signal: VGND w=1]]', 'g: [connection X5/g =>[signal: a_79_21# w=1]]', 's: [connection X5/s =>[signal: X w=1]]', 'b: [connection X5/b =>[signal: VNB w=1]]']]
X__34__5 VGND _34__a_79_21# _34_:X no_conn_134 sky130_fd_pr__nfet_01v8 w=650000u l=150000u
** [instance X6 of sky130_fd_pr__pfet_01v8_hvt, params={'w': '1e+06u', 'l': '150000u'} connections=['d: [connection X6/d =>[signal: VPWR w=1]]', 'g: [connection X6/g =>[signal: a_79_21# w=1]]', 's: [connection X6/s =>[signal: X w=1]]', 'b: [connection X6/b =>[signal: VPB w=1]]']]
X__34__6 VPWR _34__a_79_21# _34_:X no_conn_135 sky130_fd_pr__pfet_01v8_hvt w=1e+06u l=150000u
** [instance X7 of sky130_fd_pr__pfet_01v8_hvt, params={'w': '1e+06u', 'l': '150000u'} connections=['d: [connection X7/d =>[signal: a_79_21# w=1]]', 'g: [connection X7/g =>[signal: A2 w=1]]', 's: [connection X7/s =>[signal: a_470_297# w=1]]', 'b: [connection X7/b =>[signal: VPB w=1]]']]
X__34__7 _34__a_79_21# _34_:A2 _34__a_470_297# no_conn_135 sky130_fd_pr__pfet_01v8_hvt w=1e+06u l=150000u
** [instance X8 of sky130_fd_pr__pfet_01v8_hvt, params={'w': '1e+06u', 'l': '150000u'} connections=['d: [connection X8/d =>[signal: X w=1]]', 'g: [connection X8/g =>[signal: a_79_21# w=1]]', 's: [connection X8/s =>[signal: VPWR w=1]]', 'b: [connection X8/b =>[signal: VPB w=1]]']]
X__34__8 _34_:X _34__a_79_21# VPWR no_conn_135 sky130_fd_pr__pfet_01v8_hvt w=1e+06u l=150000u
** [instance X9 of sky130_fd_pr__nfet_01v8, params={'w': '650000u', 'l': '150000u'} connections=['d: [connection X9/d =>[signal: a_79_21# w=1]]', 'g: [connection X9/g =>[signal: B1 w=1]]', 's: [connection X9/s =>[signal: a_384_47# w=1]]', 'b: [connection X9/b =>[signal: VNB w=1]]']]
X__34__9 _34__a_79_21# _34_:B1 _34__a_384_47# no_conn_134 sky130_fd_pr__nfet_01v8 w=650000u l=150000u

** replacing hold25 with the contents of sky130_fd_sc_hd__dlygate4sd3_1
** [instance X0 of sky130_fd_pr__nfet_01v8, params={'w': '420000u', 'l': '500000u'} connections=['d: [connection X0/d =>[signal: a_391_47# w=1]]', 'g: [connection X0/g =>[signal: a_285_47# w=1]]', 's: [connection X0/s =>[signal: VGND w=1]]', 'b: [connection X0/b =>[signal: VNB w=1]]']]
X_hold25_0 hold25_a_391_47# hold25_a_285_47# VGND no_conn_136 sky130_fd_pr__nfet_01v8 w=420000u l=500000u
** [instance X1 of sky130_fd_pr__pfet_01v8_hvt, params={'w': '420000u', 'l': '500000u'} connections=['d: [connection X1/d =>[signal: VPWR w=1]]', 'g: [connection X1/g =>[signal: a_49_47# w=1]]', 's: [connection X1/s =>[signal: a_285_47# w=1]]', 'b: [connection X1/b =>[signal: VPB w=1]]']]
X_hold25_1 VPWR hold25_a_49_47# hold25_a_285_47# no_conn_137 sky130_fd_pr__pfet_01v8_hvt w=420000u l=500000u
** [instance X2 of sky130_fd_pr__nfet_01v8, params={'w': '420000u', 'l': '150000u'} connections=['d: [connection X2/d =>[signal: a_49_47# w=1]]', 'g: [connection X2/g =>[signal: A w=1]]', 's: [connection X2/s =>[signal: VGND w=1]]', 'b: [connection X2/b =>[signal: VNB w=1]]']]
X_hold25_2 hold25_a_49_47# hold25:A VGND no_conn_136 sky130_fd_pr__nfet_01v8 w=420000u l=150000u
** [instance X3 of sky130_fd_pr__pfet_01v8_hvt, params={'w': '1e+06u', 'l': '150000u'} connections=['d: [connection X3/d =>[signal: VPWR w=1]]', 'g: [connection X3/g =>[signal: a_391_47# w=1]]', 's: [connection X3/s =>[signal: X w=1]]', 'b: [connection X3/b =>[signal: VPB w=1]]']]
X_hold25_3 VPWR hold25_a_391_47# hold25:X no_conn_137 sky130_fd_pr__pfet_01v8_hvt w=1e+06u l=150000u
** [instance X4 of sky130_fd_pr__nfet_01v8, params={'w': '650000u', 'l': '150000u'} connections=['d: [connection X4/d =>[signal: VGND w=1]]', 'g: [connection X4/g =>[signal: a_391_47# w=1]]', 's: [connection X4/s =>[signal: X w=1]]', 'b: [connection X4/b =>[signal: VNB w=1]]']]
X_hold25_4 VGND hold25_a_391_47# hold25:X no_conn_136 sky130_fd_pr__nfet_01v8 w=650000u l=150000u
** [instance X5 of sky130_fd_pr__nfet_01v8, params={'w': '420000u', 'l': '500000u'} connections=['d: [connection X5/d =>[signal: VGND w=1]]', 'g: [connection X5/g =>[signal: a_49_47# w=1]]', 's: [connection X5/s =>[signal: a_285_47# w=1]]', 'b: [connection X5/b =>[signal: VNB w=1]]']]
X_hold25_5 VGND hold25_a_49_47# hold25_a_285_47# no_conn_136 sky130_fd_pr__nfet_01v8 w=420000u l=500000u
** [instance X6 of sky130_fd_pr__pfet_01v8_hvt, params={'w': '420000u', 'l': '500000u'} connections=['d: [connection X6/d =>[signal: a_391_47# w=1]]', 'g: [connection X6/g =>[signal: a_285_47# w=1]]', 's: [connection X6/s =>[signal: VPWR w=1]]', 'b: [connection X6/b =>[signal: VPB w=1]]']]
X_hold25_6 hold25_a_391_47# hold25_a_285_47# VPWR no_conn_137 sky130_fd_pr__pfet_01v8_hvt w=420000u l=500000u
** [instance X7 of sky130_fd_pr__pfet_01v8_hvt, params={'w': '420000u', 'l': '150000u'} connections=['d: [connection X7/d =>[signal: a_49_47# w=1]]', 'g: [connection X7/g =>[signal: A w=1]]', 's: [connection X7/s =>[signal: VPWR w=1]]', 'b: [connection X7/b =>[signal: VPB w=1]]']]
X_hold25_7 hold25_a_49_47# hold25:A VPWR no_conn_137 sky130_fd_pr__pfet_01v8_hvt w=420000u l=150000u

** replacing _76_ with the contents of sky130_fd_sc_hd__dfxtp_2
** [instance X0 of sky130_fd_pr__pfet_01v8_hvt, params={'w': '420000u', 'l': '150000u'} connections=['d: [connection X0/d =>[signal: a_891_413# w=1]]', 'g: [connection X0/g =>[signal: a_193_47# w=1]]', 's: [connection X0/s =>[signal: a_975_413# w=1]]', 'b: [connection X0/b =>[signal: VPB w=1]]']]
X__76__0 _76__a_891_413# _76__a_193_47# _76__a_975_413# no_conn_139 sky130_fd_pr__pfet_01v8_hvt w=420000u l=150000u
** [instance X1 of sky130_fd_pr__nfet_01v8, params={'w': '650000u', 'l': '150000u'} connections=['d: [connection X1/d =>[signal: a_1059_315# w=1]]', 'g: [connection X1/g =>[signal: a_891_413# w=1]]', 's: [connection X1/s =>[signal: VGND w=1]]', 'b: [connection X1/b =>[signal: VNB w=1]]']]
X__76__1 _76__a_1059_315# _76__a_891_413# VGND no_conn_138 sky130_fd_pr__nfet_01v8 w=650000u l=150000u
** [instance X2 of sky130_fd_pr__pfet_01v8_hvt, params={'w': '420000u', 'l': '150000u'} connections=['d: [connection X2/d =>[signal: a_466_413# w=1]]', 'g: [connection X2/g =>[signal: a_27_47# w=1]]', 's: [connection X2/s =>[signal: a_561_413# w=1]]', 'b: [connection X2/b =>[signal: VPB w=1]]']]
X__76__2 _76__a_466_413# _76__a_27_47# _76__a_561_413# no_conn_139 sky130_fd_pr__pfet_01v8_hvt w=420000u l=150000u
** [instance X3 of sky130_fd_pr__pfet_01v8_hvt, params={'w': '420000u', 'l': '150000u'} connections=['d: [connection X3/d =>[signal: a_634_159# w=1]]', 'g: [connection X3/g =>[signal: a_27_47# w=1]]', 's: [connection X3/s =>[signal: a_891_413# w=1]]', 'b: [connection X3/b =>[signal: VPB w=1]]']]
X__76__3 _76__a_634_159# _76__a_27_47# _76__a_891_413# no_conn_139 sky130_fd_pr__pfet_01v8_hvt w=420000u l=150000u
** [instance X4 of sky130_fd_pr__pfet_01v8_hvt, params={'w': '420000u', 'l': '150000u'} connections=['d: [connection X4/d =>[signal: a_381_47# w=1]]', 'g: [connection X4/g =>[signal: a_193_47# w=1]]', 's: [connection X4/s =>[signal: a_466_413# w=1]]', 'b: [connection X4/b =>[signal: VPB w=1]]']]
X__76__4 _76__a_381_47# _76__a_193_47# _76__a_466_413# no_conn_139 sky130_fd_pr__pfet_01v8_hvt w=420000u l=150000u
** [instance X5 of sky130_fd_pr__pfet_01v8_hvt, params={'w': '420000u', 'l': '150000u'} connections=['d: [connection X5/d =>[signal: VPWR w=1]]', 'g: [connection X5/g =>[signal: D w=1]]', 's: [connection X5/s =>[signal: a_381_47# w=1]]', 'b: [connection X5/b =>[signal: VPB w=1]]']]
X__76__5 VPWR _76_:D _76__a_381_47# no_conn_139 sky130_fd_pr__pfet_01v8_hvt w=420000u l=150000u
** [instance X6 of sky130_fd_pr__pfet_01v8_hvt, params={'w': '750000u', 'l': '150000u'} connections=['d: [connection X6/d =>[signal: VPWR w=1]]', 'g: [connection X6/g =>[signal: a_466_413# w=1]]', 's: [connection X6/s =>[signal: a_634_159# w=1]]', 'b: [connection X6/b =>[signal: VPB w=1]]']]
X__76__6 VPWR _76__a_466_413# _76__a_634_159# no_conn_139 sky130_fd_pr__pfet_01v8_hvt w=750000u l=150000u
** [instance X7 of sky130_fd_pr__nfet_01v8, params={'w': '640000u', 'l': '150000u'} connections=['d: [connection X7/d =>[signal: VGND w=1]]', 'g: [connection X7/g =>[signal: a_466_413# w=1]]', 's: [connection X7/s =>[signal: a_634_159# w=1]]', 'b: [connection X7/b =>[signal: VNB w=1]]']]
X__76__7 VGND _76__a_466_413# _76__a_634_159# no_conn_138 sky130_fd_pr__nfet_01v8 w=640000u l=150000u
** [instance X8 of sky130_fd_pr__nfet_01v8, params={'w': '420000u', 'l': '150000u'} connections=['d: [connection X8/d =>[signal: a_1017_47# w=1]]', 'g: [connection X8/g =>[signal: a_1059_315# w=1]]', 's: [connection X8/s =>[signal: VGND w=1]]', 'b: [connection X8/b =>[signal: VNB w=1]]']]
X__76__8 _76__a_1017_47# _76__a_1059_315# VGND no_conn_138 sky130_fd_pr__nfet_01v8 w=420000u l=150000u
** [instance X9 of sky130_fd_pr__pfet_01v8_hvt, params={'w': '1e+06u', 'l': '150000u'} connections=['d: [connection X9/d =>[signal: a_1059_315# w=1]]', 'g: [connection X9/g =>[signal: a_891_413# w=1]]', 's: [connection X9/s =>[signal: VPWR w=1]]', 'b: [connection X9/b =>[signal: VPB w=1]]']]
X__76__9 _76__a_1059_315# _76__a_891_413# VPWR no_conn_139 sky130_fd_pr__pfet_01v8_hvt w=1e+06u l=150000u
** [instance X10 of sky130_fd_pr__pfet_01v8_hvt, params={'w': '1e+06u', 'l': '150000u'} connections=['d: [connection X10/d =>[signal: Q w=1]]', 'g: [connection X10/g =>[signal: a_1059_315# w=1]]', 's: [connection X10/s =>[signal: VPWR w=1]]', 'b: [connection X10/b =>[signal: VPB w=1]]']]
X__76__10 _76_:Q _76__a_1059_315# VPWR no_conn_139 sky130_fd_pr__pfet_01v8_hvt w=1e+06u l=150000u
** [instance X11 of sky130_fd_pr__pfet_01v8_hvt, params={'w': '420000u', 'l': '150000u'} connections=['d: [connection X11/d =>[signal: a_561_413# w=1]]', 'g: [connection X11/g =>[signal: a_634_159# w=1]]', 's: [connection X11/s =>[signal: VPWR w=1]]', 'b: [connection X11/b =>[signal: VPB w=1]]']]
X__76__11 _76__a_561_413# _76__a_634_159# VPWR no_conn_139 sky130_fd_pr__pfet_01v8_hvt w=420000u l=150000u
** [instance X12 of sky130_fd_pr__pfet_01v8_hvt, params={'w': '1e+06u', 'l': '150000u'} connections=['d: [connection X12/d =>[signal: VPWR w=1]]', 'g: [connection X12/g =>[signal: a_1059_315# w=1]]', 's: [connection X12/s =>[signal: Q w=1]]', 'b: [connection X12/b =>[signal: VPB w=1]]']]
X__76__12 VPWR _76__a_1059_315# _76_:Q no_conn_139 sky130_fd_pr__pfet_01v8_hvt w=1e+06u l=150000u
** [instance X13 of sky130_fd_pr__nfet_01v8, params={'w': '360000u', 'l': '150000u'} connections=['d: [connection X13/d =>[signal: a_891_413# w=1]]', 'g: [connection X13/g =>[signal: a_27_47# w=1]]', 's: [connection X13/s =>[signal: a_1017_47# w=1]]', 'b: [connection X13/b =>[signal: VNB w=1]]']]
X__76__13 _76__a_891_413# _76__a_27_47# _76__a_1017_47# no_conn_138 sky130_fd_pr__nfet_01v8 w=360000u l=150000u
** [instance X14 of sky130_fd_pr__nfet_01v8, params={'w': '360000u', 'l': '150000u'} connections=['d: [connection X14/d =>[signal: a_634_159# w=1]]', 'g: [connection X14/g =>[signal: a_193_47# w=1]]', 's: [connection X14/s =>[signal: a_891_413# w=1]]', 'b: [connection X14/b =>[signal: VNB w=1]]']]
X__76__14 _76__a_634_159# _76__a_193_47# _76__a_891_413# no_conn_138 sky130_fd_pr__nfet_01v8 w=360000u l=150000u
** [instance X15 of sky130_fd_pr__nfet_01v8, params={'w': '420000u', 'l': '150000u'} connections=['d: [connection X15/d =>[signal: a_592_47# w=1]]', 'g: [connection X15/g =>[signal: a_634_159# w=1]]', 's: [connection X15/s =>[signal: VGND w=1]]', 'b: [connection X15/b =>[signal: VNB w=1]]']]
X__76__15 _76__a_592_47# _76__a_634_159# VGND no_conn_138 sky130_fd_pr__nfet_01v8 w=420000u l=150000u
** [instance X16 of sky130_fd_pr__nfet_01v8, params={'w': '360000u', 'l': '150000u'} connections=['d: [connection X16/d =>[signal: a_466_413# w=1]]', 'g: [connection X16/g =>[signal: a_193_47# w=1]]', 's: [connection X16/s =>[signal: a_592_47# w=1]]', 'b: [connection X16/b =>[signal: VNB w=1]]']]
X__76__16 _76__a_466_413# _76__a_193_47# _76__a_592_47# no_conn_138 sky130_fd_pr__nfet_01v8 w=360000u l=150000u
** [instance X17 of sky130_fd_pr__nfet_01v8, params={'w': '420000u', 'l': '150000u'} connections=['d: [connection X17/d =>[signal: VGND w=1]]', 'g: [connection X17/g =>[signal: a_27_47# w=1]]', 's: [connection X17/s =>[signal: a_193_47# w=1]]', 'b: [connection X17/b =>[signal: VNB w=1]]']]
X__76__17 VGND _76__a_27_47# _76__a_193_47# no_conn_138 sky130_fd_pr__nfet_01v8 w=420000u l=150000u
** [instance X18 of sky130_fd_pr__nfet_01v8, params={'w': '360000u', 'l': '150000u'} connections=['d: [connection X18/d =>[signal: a_381_47# w=1]]', 'g: [connection X18/g =>[signal: a_27_47# w=1]]', 's: [connection X18/s =>[signal: a_466_413# w=1]]', 'b: [connection X18/b =>[signal: VNB w=1]]']]
X__76__18 _76__a_381_47# _76__a_27_47# _76__a_466_413# no_conn_138 sky130_fd_pr__nfet_01v8 w=360000u l=150000u
** [instance X19 of sky130_fd_pr__nfet_01v8, params={'w': '420000u', 'l': '150000u'} connections=['d: [connection X19/d =>[signal: a_27_47# w=1]]', 'g: [connection X19/g =>[signal: CLK w=1]]', 's: [connection X19/s =>[signal: VGND w=1]]', 'b: [connection X19/b =>[signal: VNB w=1]]']]
X__76__19 _76__a_27_47# _76_:CLK VGND no_conn_138 sky130_fd_pr__nfet_01v8 w=420000u l=150000u
** [instance X20 of sky130_fd_pr__pfet_01v8_hvt, params={'w': '640000u', 'l': '150000u'} connections=['d: [connection X20/d =>[signal: a_27_47# w=1]]', 'g: [connection X20/g =>[signal: CLK w=1]]', 's: [connection X20/s =>[signal: VPWR w=1]]', 'b: [connection X20/b =>[signal: VPB w=1]]']]
X__76__20 _76__a_27_47# _76_:CLK VPWR no_conn_139 sky130_fd_pr__pfet_01v8_hvt w=640000u l=150000u
** [instance X21 of sky130_fd_pr__nfet_01v8, params={'w': '650000u', 'l': '150000u'} connections=['d: [connection X21/d =>[signal: Q w=1]]', 'g: [connection X21/g =>[signal: a_1059_315# w=1]]', 's: [connection X21/s =>[signal: VGND w=1]]', 'b: [connection X21/b =>[signal: VNB w=1]]']]
X__76__21 _76_:Q _76__a_1059_315# VGND no_conn_138 sky130_fd_pr__nfet_01v8 w=650000u l=150000u
** [instance X22 of sky130_fd_pr__pfet_01v8_hvt, params={'w': '640000u', 'l': '150000u'} connections=['d: [connection X22/d =>[signal: VPWR w=1]]', 'g: [connection X22/g =>[signal: a_27_47# w=1]]', 's: [connection X22/s =>[signal: a_193_47# w=1]]', 'b: [connection X22/b =>[signal: VPB w=1]]']]
X__76__22 VPWR _76__a_27_47# _76__a_193_47# no_conn_139 sky130_fd_pr__pfet_01v8_hvt w=640000u l=150000u
** [instance X23 of sky130_fd_pr__nfet_01v8, params={'w': '420000u', 'l': '150000u'} connections=['d: [connection X23/d =>[signal: VGND w=1]]', 'g: [connection X23/g =>[signal: D w=1]]', 's: [connection X23/s =>[signal: a_381_47# w=1]]', 'b: [connection X23/b =>[signal: VNB w=1]]']]
X__76__23 VGND _76_:D _76__a_381_47# no_conn_138 sky130_fd_pr__nfet_01v8 w=420000u l=150000u
** [instance X24 of sky130_fd_pr__pfet_01v8_hvt, params={'w': '420000u', 'l': '150000u'} connections=['d: [connection X24/d =>[signal: a_975_413# w=1]]', 'g: [connection X24/g =>[signal: a_1059_315# w=1]]', 's: [connection X24/s =>[signal: VPWR w=1]]', 'b: [connection X24/b =>[signal: VPB w=1]]']]
X__76__24 _76__a_975_413# _76__a_1059_315# VPWR no_conn_139 sky130_fd_pr__pfet_01v8_hvt w=420000u l=150000u
** [instance X25 of sky130_fd_pr__nfet_01v8, params={'w': '650000u', 'l': '150000u'} connections=['d: [connection X25/d =>[signal: VGND w=1]]', 'g: [connection X25/g =>[signal: a_1059_315# w=1]]', 's: [connection X25/s =>[signal: Q w=1]]', 'b: [connection X25/b =>[signal: VNB w=1]]']]
X__76__25 VGND _76__a_1059_315# _76_:Q no_conn_138 sky130_fd_pr__nfet_01v8 w=650000u l=150000u

** replacing _29_ with the contents of sky130_fd_sc_hd__inv_2
** [instance X0 of sky130_fd_pr__nfet_01v8, params={'w': '650000u', 'l': '150000u'} connections=['d: [connection X0/d =>[signal: Y w=1]]', 'g: [connection X0/g =>[signal: A w=1]]', 's: [connection X0/s =>[signal: VGND w=1]]', 'b: [connection X0/b =>[signal: VNB w=1]]']]
X__29__0 _29_:Y _29_:A VGND no_conn_140 sky130_fd_pr__nfet_01v8 w=650000u l=150000u
** [instance X1 of sky130_fd_pr__pfet_01v8_hvt, params={'w': '1e+06u', 'l': '150000u'} connections=['d: [connection X1/d =>[signal: VPWR w=1]]', 'g: [connection X1/g =>[signal: A w=1]]', 's: [connection X1/s =>[signal: Y w=1]]', 'b: [connection X1/b =>[signal: VPB w=1]]']]
X__29__1 VPWR _29_:A _29_:Y no_conn_141 sky130_fd_pr__pfet_01v8_hvt w=1e+06u l=150000u
** [instance X2 of sky130_fd_pr__nfet_01v8, params={'w': '650000u', 'l': '150000u'} connections=['d: [connection X2/d =>[signal: VGND w=1]]', 'g: [connection X2/g =>[signal: A w=1]]', 's: [connection X2/s =>[signal: Y w=1]]', 'b: [connection X2/b =>[signal: VNB w=1]]']]
X__29__2 VGND _29_:A _29_:Y no_conn_140 sky130_fd_pr__nfet_01v8 w=650000u l=150000u
** [instance X3 of sky130_fd_pr__pfet_01v8_hvt, params={'w': '1e+06u', 'l': '150000u'} connections=['d: [connection X3/d =>[signal: Y w=1]]', 'g: [connection X3/g =>[signal: A w=1]]', 's: [connection X3/s =>[signal: VPWR w=1]]', 'b: [connection X3/b =>[signal: VPB w=1]]']]
X__29__3 _29_:Y _29_:A VPWR no_conn_141 sky130_fd_pr__pfet_01v8_hvt w=1e+06u l=150000u

** replacing _30_ with the contents of sky130_fd_sc_hd__inv_2
** [instance X0 of sky130_fd_pr__nfet_01v8, params={'w': '650000u', 'l': '150000u'} connections=['d: [connection X0/d =>[signal: Y w=1]]', 'g: [connection X0/g =>[signal: A w=1]]', 's: [connection X0/s =>[signal: VGND w=1]]', 'b: [connection X0/b =>[signal: VNB w=1]]']]
X__30__0 _30_:Y _30_:A VGND no_conn_142 sky130_fd_pr__nfet_01v8 w=650000u l=150000u
** [instance X1 of sky130_fd_pr__pfet_01v8_hvt, params={'w': '1e+06u', 'l': '150000u'} connections=['d: [connection X1/d =>[signal: VPWR w=1]]', 'g: [connection X1/g =>[signal: A w=1]]', 's: [connection X1/s =>[signal: Y w=1]]', 'b: [connection X1/b =>[signal: VPB w=1]]']]
X__30__1 VPWR _30_:A _30_:Y no_conn_143 sky130_fd_pr__pfet_01v8_hvt w=1e+06u l=150000u
** [instance X2 of sky130_fd_pr__nfet_01v8, params={'w': '650000u', 'l': '150000u'} connections=['d: [connection X2/d =>[signal: VGND w=1]]', 'g: [connection X2/g =>[signal: A w=1]]', 's: [connection X2/s =>[signal: Y w=1]]', 'b: [connection X2/b =>[signal: VNB w=1]]']]
X__30__2 VGND _30_:A _30_:Y no_conn_142 sky130_fd_pr__nfet_01v8 w=650000u l=150000u
** [instance X3 of sky130_fd_pr__pfet_01v8_hvt, params={'w': '1e+06u', 'l': '150000u'} connections=['d: [connection X3/d =>[signal: Y w=1]]', 'g: [connection X3/g =>[signal: A w=1]]', 's: [connection X3/s =>[signal: VPWR w=1]]', 'b: [connection X3/b =>[signal: VPB w=1]]']]
X__30__3 _30_:Y _30_:A VPWR no_conn_143 sky130_fd_pr__pfet_01v8_hvt w=1e+06u l=150000u

** replacing hold16 with the contents of sky130_fd_sc_hd__dlygate4sd3_1
** [instance X0 of sky130_fd_pr__nfet_01v8, params={'w': '420000u', 'l': '500000u'} connections=['d: [connection X0/d =>[signal: a_391_47# w=1]]', 'g: [connection X0/g =>[signal: a_285_47# w=1]]', 's: [connection X0/s =>[signal: VGND w=1]]', 'b: [connection X0/b =>[signal: VNB w=1]]']]
X_hold16_0 hold16_a_391_47# hold16_a_285_47# VGND no_conn_144 sky130_fd_pr__nfet_01v8 w=420000u l=500000u
** [instance X1 of sky130_fd_pr__pfet_01v8_hvt, params={'w': '420000u', 'l': '500000u'} connections=['d: [connection X1/d =>[signal: VPWR w=1]]', 'g: [connection X1/g =>[signal: a_49_47# w=1]]', 's: [connection X1/s =>[signal: a_285_47# w=1]]', 'b: [connection X1/b =>[signal: VPB w=1]]']]
X_hold16_1 VPWR hold16_a_49_47# hold16_a_285_47# no_conn_145 sky130_fd_pr__pfet_01v8_hvt w=420000u l=500000u
** [instance X2 of sky130_fd_pr__nfet_01v8, params={'w': '420000u', 'l': '150000u'} connections=['d: [connection X2/d =>[signal: a_49_47# w=1]]', 'g: [connection X2/g =>[signal: A w=1]]', 's: [connection X2/s =>[signal: VGND w=1]]', 'b: [connection X2/b =>[signal: VNB w=1]]']]
X_hold16_2 hold16_a_49_47# hold16:A VGND no_conn_144 sky130_fd_pr__nfet_01v8 w=420000u l=150000u
** [instance X3 of sky130_fd_pr__pfet_01v8_hvt, params={'w': '1e+06u', 'l': '150000u'} connections=['d: [connection X3/d =>[signal: VPWR w=1]]', 'g: [connection X3/g =>[signal: a_391_47# w=1]]', 's: [connection X3/s =>[signal: X w=1]]', 'b: [connection X3/b =>[signal: VPB w=1]]']]
X_hold16_3 VPWR hold16_a_391_47# hold16:X no_conn_145 sky130_fd_pr__pfet_01v8_hvt w=1e+06u l=150000u
** [instance X4 of sky130_fd_pr__nfet_01v8, params={'w': '650000u', 'l': '150000u'} connections=['d: [connection X4/d =>[signal: VGND w=1]]', 'g: [connection X4/g =>[signal: a_391_47# w=1]]', 's: [connection X4/s =>[signal: X w=1]]', 'b: [connection X4/b =>[signal: VNB w=1]]']]
X_hold16_4 VGND hold16_a_391_47# hold16:X no_conn_144 sky130_fd_pr__nfet_01v8 w=650000u l=150000u
** [instance X5 of sky130_fd_pr__nfet_01v8, params={'w': '420000u', 'l': '500000u'} connections=['d: [connection X5/d =>[signal: VGND w=1]]', 'g: [connection X5/g =>[signal: a_49_47# w=1]]', 's: [connection X5/s =>[signal: a_285_47# w=1]]', 'b: [connection X5/b =>[signal: VNB w=1]]']]
X_hold16_5 VGND hold16_a_49_47# hold16_a_285_47# no_conn_144 sky130_fd_pr__nfet_01v8 w=420000u l=500000u
** [instance X6 of sky130_fd_pr__pfet_01v8_hvt, params={'w': '420000u', 'l': '500000u'} connections=['d: [connection X6/d =>[signal: a_391_47# w=1]]', 'g: [connection X6/g =>[signal: a_285_47# w=1]]', 's: [connection X6/s =>[signal: VPWR w=1]]', 'b: [connection X6/b =>[signal: VPB w=1]]']]
X_hold16_6 hold16_a_391_47# hold16_a_285_47# VPWR no_conn_145 sky130_fd_pr__pfet_01v8_hvt w=420000u l=500000u
** [instance X7 of sky130_fd_pr__pfet_01v8_hvt, params={'w': '420000u', 'l': '150000u'} connections=['d: [connection X7/d =>[signal: a_49_47# w=1]]', 'g: [connection X7/g =>[signal: A w=1]]', 's: [connection X7/s =>[signal: VPWR w=1]]', 'b: [connection X7/b =>[signal: VPB w=1]]']]
X_hold16_7 hold16_a_49_47# hold16:A VPWR no_conn_145 sky130_fd_pr__pfet_01v8_hvt w=420000u l=150000u

** replacing hold20 with the contents of sky130_fd_sc_hd__dlygate4sd3_1
** [instance X0 of sky130_fd_pr__nfet_01v8, params={'w': '420000u', 'l': '500000u'} connections=['d: [connection X0/d =>[signal: a_391_47# w=1]]', 'g: [connection X0/g =>[signal: a_285_47# w=1]]', 's: [connection X0/s =>[signal: VGND w=1]]', 'b: [connection X0/b =>[signal: VNB w=1]]']]
X_hold20_0 hold20_a_391_47# hold20_a_285_47# VGND no_conn_146 sky130_fd_pr__nfet_01v8 w=420000u l=500000u
** [instance X1 of sky130_fd_pr__pfet_01v8_hvt, params={'w': '420000u', 'l': '500000u'} connections=['d: [connection X1/d =>[signal: VPWR w=1]]', 'g: [connection X1/g =>[signal: a_49_47# w=1]]', 's: [connection X1/s =>[signal: a_285_47# w=1]]', 'b: [connection X1/b =>[signal: VPB w=1]]']]
X_hold20_1 VPWR hold20_a_49_47# hold20_a_285_47# no_conn_147 sky130_fd_pr__pfet_01v8_hvt w=420000u l=500000u
** [instance X2 of sky130_fd_pr__nfet_01v8, params={'w': '420000u', 'l': '150000u'} connections=['d: [connection X2/d =>[signal: a_49_47# w=1]]', 'g: [connection X2/g =>[signal: A w=1]]', 's: [connection X2/s =>[signal: VGND w=1]]', 'b: [connection X2/b =>[signal: VNB w=1]]']]
X_hold20_2 hold20_a_49_47# hold20:A VGND no_conn_146 sky130_fd_pr__nfet_01v8 w=420000u l=150000u
** [instance X3 of sky130_fd_pr__pfet_01v8_hvt, params={'w': '1e+06u', 'l': '150000u'} connections=['d: [connection X3/d =>[signal: VPWR w=1]]', 'g: [connection X3/g =>[signal: a_391_47# w=1]]', 's: [connection X3/s =>[signal: X w=1]]', 'b: [connection X3/b =>[signal: VPB w=1]]']]
X_hold20_3 VPWR hold20_a_391_47# hold20:X no_conn_147 sky130_fd_pr__pfet_01v8_hvt w=1e+06u l=150000u
** [instance X4 of sky130_fd_pr__nfet_01v8, params={'w': '650000u', 'l': '150000u'} connections=['d: [connection X4/d =>[signal: VGND w=1]]', 'g: [connection X4/g =>[signal: a_391_47# w=1]]', 's: [connection X4/s =>[signal: X w=1]]', 'b: [connection X4/b =>[signal: VNB w=1]]']]
X_hold20_4 VGND hold20_a_391_47# hold20:X no_conn_146 sky130_fd_pr__nfet_01v8 w=650000u l=150000u
** [instance X5 of sky130_fd_pr__nfet_01v8, params={'w': '420000u', 'l': '500000u'} connections=['d: [connection X5/d =>[signal: VGND w=1]]', 'g: [connection X5/g =>[signal: a_49_47# w=1]]', 's: [connection X5/s =>[signal: a_285_47# w=1]]', 'b: [connection X5/b =>[signal: VNB w=1]]']]
X_hold20_5 VGND hold20_a_49_47# hold20_a_285_47# no_conn_146 sky130_fd_pr__nfet_01v8 w=420000u l=500000u
** [instance X6 of sky130_fd_pr__pfet_01v8_hvt, params={'w': '420000u', 'l': '500000u'} connections=['d: [connection X6/d =>[signal: a_391_47# w=1]]', 'g: [connection X6/g =>[signal: a_285_47# w=1]]', 's: [connection X6/s =>[signal: VPWR w=1]]', 'b: [connection X6/b =>[signal: VPB w=1]]']]
X_hold20_6 hold20_a_391_47# hold20_a_285_47# VPWR no_conn_147 sky130_fd_pr__pfet_01v8_hvt w=420000u l=500000u
** [instance X7 of sky130_fd_pr__pfet_01v8_hvt, params={'w': '420000u', 'l': '150000u'} connections=['d: [connection X7/d =>[signal: a_49_47# w=1]]', 'g: [connection X7/g =>[signal: A w=1]]', 's: [connection X7/s =>[signal: VPWR w=1]]', 'b: [connection X7/b =>[signal: VPB w=1]]']]
X_hold20_7 hold20_a_49_47# hold20:A VPWR no_conn_147 sky130_fd_pr__pfet_01v8_hvt w=420000u l=150000u

** replacing _31_ with the contents of sky130_fd_sc_hd__mux4_2
** [instance X0 of sky130_fd_pr__pfet_01v8_hvt, params={'w': '640000u', 'l': '150000u'} connections=['d: [connection X0/d =>[signal: VPWR w=1]]', 'g: [connection X0/g =>[signal: A1 w=1]]', 's: [connection X0/s =>[signal: a_1060_369# w=1]]', 'b: [connection X0/b =>[signal: VPB w=1]]']]
X__31__0 VPWR _31_:A1 _31__a_1060_369# no_conn_149 sky130_fd_pr__pfet_01v8_hvt w=640000u l=150000u
** [instance X1 of sky130_fd_pr__nfet_01v8, params={'w': '360000u', 'l': '150000u'} connections=['d: [connection X1/d =>[signal: a_193_47# w=1]]', 'g: [connection X1/g =>[signal: a_27_47# w=1]]', 's: [connection X1/s =>[signal: a_288_47# w=1]]', 'b: [connection X1/b =>[signal: VNB w=1]]']]
X__31__1 _31__a_193_47# _31__a_27_47# _31__a_288_47# no_conn_148 sky130_fd_pr__nfet_01v8 w=360000u l=150000u
** [instance X2 of sky130_fd_pr__pfet_01v8_hvt, params={'w': '1e+06u', 'l': '150000u'} connections=['d: [connection X2/d =>[signal: VPWR w=1]]', 'g: [connection X2/g =>[signal: a_788_316# w=1]]', 's: [connection X2/s =>[signal: X w=1]]', 'b: [connection X2/b =>[signal: VPB w=1]]']]
X__31__2 VPWR _31__a_788_316# _31_:X no_conn_149 sky130_fd_pr__pfet_01v8_hvt w=1e+06u l=150000u
** [instance X3 of sky130_fd_pr__pfet_01v8_hvt, params={'w': '640000u', 'l': '150000u'} connections=['d: [connection X3/d =>[signal: a_1279_413# w=1]]', 'g: [connection X3/g =>[signal: A0 w=1]]', 's: [connection X3/s =>[signal: VPWR w=1]]', 'b: [connection X3/b =>[signal: VPB w=1]]']]
X__31__3 _31__a_1279_413# _31_:A0 VPWR no_conn_149 sky130_fd_pr__pfet_01v8_hvt w=640000u l=150000u
** [instance X4 of sky130_fd_pr__nfet_01v8, params={'w': '650000u', 'l': '150000u'} connections=['d: [connection X4/d =>[signal: VGND w=1]]', 'g: [connection X4/g =>[signal: a_788_316# w=1]]', 's: [connection X4/s =>[signal: X w=1]]', 'b: [connection X4/b =>[signal: VNB w=1]]']]
X__31__4 VGND _31__a_788_316# _31_:X no_conn_148 sky130_fd_pr__nfet_01v8 w=650000u l=150000u
** [instance X5 of sky130_fd_pr__pfet_01v8_hvt, params={'w': '1e+06u', 'l': '150000u'} connections=['d: [connection X5/d =>[signal: X w=1]]', 'g: [connection X5/g =>[signal: a_788_316# w=1]]', 's: [connection X5/s =>[signal: VPWR w=1]]', 'b: [connection X5/b =>[signal: VPB w=1]]']]
X__31__5 _31_:X _31__a_788_316# VPWR no_conn_149 sky130_fd_pr__pfet_01v8_hvt w=1e+06u l=150000u
** [instance X6 of sky130_fd_pr__nfet_01v8, params={'w': '420000u', 'l': '150000u'} connections=['d: [connection X6/d =>[signal: a_288_47# w=1]]', 'g: [connection X6/g =>[signal: S1 w=1]]', 's: [connection X6/s =>[signal: a_788_316# w=1]]', 'b: [connection X6/b =>[signal: VNB w=1]]']]
X__31__6 _31__a_288_47# _31_:S1 _31__a_788_316# no_conn_148 sky130_fd_pr__nfet_01v8 w=420000u l=150000u
** [instance X7 of sky130_fd_pr__pfet_01v8_hvt, params={'w': '420000u', 'l': '150000u'} connections=['d: [connection X7/d =>[signal: a_193_369# w=1]]', 'g: [connection X7/g =>[signal: S0 w=1]]', 's: [connection X7/s =>[signal: a_288_47# w=1]]', 'b: [connection X7/b =>[signal: VPB w=1]]']]
X__31__7 _31__a_193_369# _31_:S0 _31__a_288_47# no_conn_149 sky130_fd_pr__pfet_01v8_hvt w=420000u l=150000u
** [instance X8 of sky130_fd_pr__pfet_01v8_hvt, params={'w': '640000u', 'l': '150000u'} connections=['d: [connection X8/d =>[signal: a_372_413# w=1]]', 'g: [connection X8/g =>[signal: A3 w=1]]', 's: [connection X8/s =>[signal: VPWR w=1]]', 'b: [connection X8/b =>[signal: VPB w=1]]']]
X__31__8 _31__a_372_413# _31_:A3 VPWR no_conn_149 sky130_fd_pr__pfet_01v8_hvt w=640000u l=150000u
** [instance X9 of sky130_fd_pr__nfet_01v8, params={'w': '360000u', 'l': '150000u'} connections=['d: [connection X9/d =>[signal: a_872_316# w=1]]', 'g: [connection X9/g =>[signal: a_27_47# w=1]]', 's: [connection X9/s =>[signal: a_1281_47# w=1]]', 'b: [connection X9/b =>[signal: VNB w=1]]']]
X__31__9 _31__a_872_316# _31__a_27_47# _31__a_1281_47# no_conn_148 sky130_fd_pr__nfet_01v8 w=360000u l=150000u
** [instance X10 of sky130_fd_pr__pfet_01v8_hvt, params={'w': '420000u', 'l': '150000u'} connections=['d: [connection X10/d =>[signal: a_288_47# w=1]]', 'g: [connection X10/g =>[signal: a_27_47# w=1]]', 's: [connection X10/s =>[signal: a_372_413# w=1]]', 'b: [connection X10/b =>[signal: VPB w=1]]']]
X__31__10 _31__a_288_47# _31__a_27_47# _31__a_372_413# no_conn_149 sky130_fd_pr__pfet_01v8_hvt w=420000u l=150000u
** [instance X11 of sky130_fd_pr__nfet_01v8, params={'w': '420000u', 'l': '150000u'} connections=['d: [connection X11/d =>[signal: VGND w=1]]', 'g: [connection X11/g =>[signal: A1 w=1]]', 's: [connection X11/s =>[signal: a_1064_47# w=1]]', 'b: [connection X11/b =>[signal: VNB w=1]]']]
X__31__11 VGND _31_:A1 _31__a_1064_47# no_conn_148 sky130_fd_pr__nfet_01v8 w=420000u l=150000u
** [instance X12 of sky130_fd_pr__pfet_01v8_hvt, params={'w': '640000u', 'l': '150000u'} connections=['d: [connection X12/d =>[signal: VPWR w=1]]', 'g: [connection X12/g =>[signal: S1 w=1]]', 's: [connection X12/s =>[signal: a_600_345# w=1]]', 'b: [connection X12/b =>[signal: VPB w=1]]']]
X__31__12 VPWR _31_:S1 _31__a_600_345# no_conn_149 sky130_fd_pr__pfet_01v8_hvt w=640000u l=150000u
** [instance X13 of sky130_fd_pr__pfet_01v8_hvt, params={'w': '420000u', 'l': '150000u'} connections=['d: [connection X13/d =>[signal: a_872_316# w=1]]', 'g: [connection X13/g =>[signal: S0 w=1]]', 's: [connection X13/s =>[signal: a_1279_413# w=1]]', 'b: [connection X13/b =>[signal: VPB w=1]]']]
X__31__13 _31__a_872_316# _31_:S0 _31__a_1279_413# no_conn_149 sky130_fd_pr__pfet_01v8_hvt w=420000u l=150000u
** [instance X14 of sky130_fd_pr__pfet_01v8_hvt, params={'w': '640000u', 'l': '150000u'} connections=['d: [connection X14/d =>[signal: a_27_47# w=1]]', 'g: [connection X14/g =>[signal: S0 w=1]]', 's: [connection X14/s =>[signal: VPWR w=1]]', 'b: [connection X14/b =>[signal: VPB w=1]]']]
X__31__14 _31__a_27_47# _31_:S0 VPWR no_conn_149 sky130_fd_pr__pfet_01v8_hvt w=640000u l=150000u
** [instance X15 of sky130_fd_pr__pfet_01v8_hvt, params={'w': '640000u', 'l': '150000u'} connections=['d: [connection X15/d =>[signal: VPWR w=1]]', 'g: [connection X15/g =>[signal: A2 w=1]]', 's: [connection X15/s =>[signal: a_193_369# w=1]]', 'b: [connection X15/b =>[signal: VPB w=1]]']]
X__31__15 VPWR _31_:A2 _31__a_193_369# no_conn_149 sky130_fd_pr__pfet_01v8_hvt w=640000u l=150000u
** [instance X16 of sky130_fd_pr__nfet_01v8, params={'w': '420000u', 'l': '150000u'} connections=['d: [connection X16/d =>[signal: VGND w=1]]', 'g: [connection X16/g =>[signal: A2 w=1]]', 's: [connection X16/s =>[signal: a_193_47# w=1]]', 'b: [connection X16/b =>[signal: VNB w=1]]']]
X__31__16 VGND _31_:A2 _31__a_193_47# no_conn_148 sky130_fd_pr__nfet_01v8 w=420000u l=150000u
** [instance X17 of sky130_fd_pr__pfet_01v8_hvt, params={'w': '540000u', 'l': '150000u'} connections=['d: [connection X17/d =>[signal: a_288_47# w=1]]', 'g: [connection X17/g =>[signal: a_600_345# w=1]]', 's: [connection X17/s =>[signal: a_788_316# w=1]]', 'b: [connection X17/b =>[signal: VPB w=1]]']]
X__31__17 _31__a_288_47# _31__a_600_345# _31__a_788_316# no_conn_149 sky130_fd_pr__pfet_01v8_hvt w=540000u l=150000u
** [instance X18 of sky130_fd_pr__nfet_01v8, params={'w': '420000u', 'l': '150000u'} connections=['d: [connection X18/d =>[signal: a_397_47# w=1]]', 'g: [connection X18/g =>[signal: A3 w=1]]', 's: [connection X18/s =>[signal: VGND w=1]]', 'b: [connection X18/b =>[signal: VNB w=1]]']]
X__31__18 _31__a_397_47# _31_:A3 VGND no_conn_148 sky130_fd_pr__nfet_01v8 w=420000u l=150000u
** [instance X19 of sky130_fd_pr__nfet_01v8, params={'w': '420000u', 'l': '150000u'} connections=['d: [connection X19/d =>[signal: a_27_47# w=1]]', 'g: [connection X19/g =>[signal: S0 w=1]]', 's: [connection X19/s =>[signal: VGND w=1]]', 'b: [connection X19/b =>[signal: VNB w=1]]']]
X__31__19 _31__a_27_47# _31_:S0 VGND no_conn_148 sky130_fd_pr__nfet_01v8 w=420000u l=150000u
** [instance X20 of sky130_fd_pr__pfet_01v8_hvt, params={'w': '420000u', 'l': '150000u'} connections=['d: [connection X20/d =>[signal: a_1060_369# w=1]]', 'g: [connection X20/g =>[signal: a_27_47# w=1]]', 's: [connection X20/s =>[signal: a_872_316# w=1]]', 'b: [connection X20/b =>[signal: VPB w=1]]']]
X__31__20 _31__a_1060_369# _31__a_27_47# _31__a_872_316# no_conn_149 sky130_fd_pr__pfet_01v8_hvt w=420000u l=150000u
** [instance X21 of sky130_fd_pr__nfet_01v8, params={'w': '420000u', 'l': '150000u'} connections=['d: [connection X21/d =>[signal: VGND w=1]]', 'g: [connection X21/g =>[signal: S1 w=1]]', 's: [connection X21/s =>[signal: a_600_345# w=1]]', 'b: [connection X21/b =>[signal: VNB w=1]]']]
X__31__21 VGND _31_:S1 _31__a_600_345# no_conn_148 sky130_fd_pr__nfet_01v8 w=420000u l=150000u
** [instance X22 of sky130_fd_pr__nfet_01v8, params={'w': '420000u', 'l': '150000u'} connections=['d: [connection X22/d =>[signal: a_1281_47# w=1]]', 'g: [connection X22/g =>[signal: A0 w=1]]', 's: [connection X22/s =>[signal: VGND w=1]]', 'b: [connection X22/b =>[signal: VNB w=1]]']]
X__31__22 _31__a_1281_47# _31_:A0 VGND no_conn_148 sky130_fd_pr__nfet_01v8 w=420000u l=150000u
** [instance X23 of sky130_fd_pr__nfet_01v8, params={'w': '650000u', 'l': '150000u'} connections=['d: [connection X23/d =>[signal: X w=1]]', 'g: [connection X23/g =>[signal: a_788_316# w=1]]', 's: [connection X23/s =>[signal: VGND w=1]]', 'b: [connection X23/b =>[signal: VNB w=1]]']]
X__31__23 _31_:X _31__a_788_316# VGND no_conn_148 sky130_fd_pr__nfet_01v8 w=650000u l=150000u
** [instance X24 of sky130_fd_pr__nfet_01v8, params={'w': '360000u', 'l': '150000u'} connections=['d: [connection X24/d =>[signal: a_288_47# w=1]]', 'g: [connection X24/g =>[signal: S0 w=1]]', 's: [connection X24/s =>[signal: a_397_47# w=1]]', 'b: [connection X24/b =>[signal: VNB w=1]]']]
X__31__24 _31__a_288_47# _31_:S0 _31__a_397_47# no_conn_148 sky130_fd_pr__nfet_01v8 w=360000u l=150000u
** [instance X25 of sky130_fd_pr__pfet_01v8_hvt, params={'w': '540000u', 'l': '150000u'} connections=['d: [connection X25/d =>[signal: a_788_316# w=1]]', 'g: [connection X25/g =>[signal: S1 w=1]]', 's: [connection X25/s =>[signal: a_872_316# w=1]]', 'b: [connection X25/b =>[signal: VPB w=1]]']]
X__31__25 _31__a_788_316# _31_:S1 _31__a_872_316# no_conn_149 sky130_fd_pr__pfet_01v8_hvt w=540000u l=150000u
** [instance X26 of sky130_fd_pr__nfet_01v8, params={'w': '420000u', 'l': '150000u'} connections=['d: [connection X26/d =>[signal: a_788_316# w=1]]', 'g: [connection X26/g =>[signal: a_600_345# w=1]]', 's: [connection X26/s =>[signal: a_872_316# w=1]]', 'b: [connection X26/b =>[signal: VNB w=1]]']]
X__31__26 _31__a_788_316# _31__a_600_345# _31__a_872_316# no_conn_148 sky130_fd_pr__nfet_01v8 w=420000u l=150000u
** [instance X27 of sky130_fd_pr__nfet_01v8, params={'w': '360000u', 'l': '150000u'} connections=['d: [connection X27/d =>[signal: a_1064_47# w=1]]', 'g: [connection X27/g =>[signal: S0 w=1]]', 's: [connection X27/s =>[signal: a_872_316# w=1]]', 'b: [connection X27/b =>[signal: VNB w=1]]']]
X__31__27 _31__a_1064_47# _31_:S0 _31__a_872_316# no_conn_148 sky130_fd_pr__nfet_01v8 w=360000u l=150000u

** replacing _35_ with the contents of sky130_fd_sc_hd__mux4_2
** [instance X0 of sky130_fd_pr__pfet_01v8_hvt, params={'w': '640000u', 'l': '150000u'} connections=['d: [connection X0/d =>[signal: VPWR w=1]]', 'g: [connection X0/g =>[signal: A1 w=1]]', 's: [connection X0/s =>[signal: a_1060_369# w=1]]', 'b: [connection X0/b =>[signal: VPB w=1]]']]
X__35__0 VPWR _35_:A1 _35__a_1060_369# no_conn_151 sky130_fd_pr__pfet_01v8_hvt w=640000u l=150000u
** [instance X1 of sky130_fd_pr__nfet_01v8, params={'w': '360000u', 'l': '150000u'} connections=['d: [connection X1/d =>[signal: a_193_47# w=1]]', 'g: [connection X1/g =>[signal: a_27_47# w=1]]', 's: [connection X1/s =>[signal: a_288_47# w=1]]', 'b: [connection X1/b =>[signal: VNB w=1]]']]
X__35__1 _35__a_193_47# _35__a_27_47# _35__a_288_47# no_conn_150 sky130_fd_pr__nfet_01v8 w=360000u l=150000u
** [instance X2 of sky130_fd_pr__pfet_01v8_hvt, params={'w': '1e+06u', 'l': '150000u'} connections=['d: [connection X2/d =>[signal: VPWR w=1]]', 'g: [connection X2/g =>[signal: a_788_316# w=1]]', 's: [connection X2/s =>[signal: X w=1]]', 'b: [connection X2/b =>[signal: VPB w=1]]']]
X__35__2 VPWR _35__a_788_316# _35_:X no_conn_151 sky130_fd_pr__pfet_01v8_hvt w=1e+06u l=150000u
** [instance X3 of sky130_fd_pr__pfet_01v8_hvt, params={'w': '640000u', 'l': '150000u'} connections=['d: [connection X3/d =>[signal: a_1279_413# w=1]]', 'g: [connection X3/g =>[signal: A0 w=1]]', 's: [connection X3/s =>[signal: VPWR w=1]]', 'b: [connection X3/b =>[signal: VPB w=1]]']]
X__35__3 _35__a_1279_413# _35_:A0 VPWR no_conn_151 sky130_fd_pr__pfet_01v8_hvt w=640000u l=150000u
** [instance X4 of sky130_fd_pr__nfet_01v8, params={'w': '650000u', 'l': '150000u'} connections=['d: [connection X4/d =>[signal: VGND w=1]]', 'g: [connection X4/g =>[signal: a_788_316# w=1]]', 's: [connection X4/s =>[signal: X w=1]]', 'b: [connection X4/b =>[signal: VNB w=1]]']]
X__35__4 VGND _35__a_788_316# _35_:X no_conn_150 sky130_fd_pr__nfet_01v8 w=650000u l=150000u
** [instance X5 of sky130_fd_pr__pfet_01v8_hvt, params={'w': '1e+06u', 'l': '150000u'} connections=['d: [connection X5/d =>[signal: X w=1]]', 'g: [connection X5/g =>[signal: a_788_316# w=1]]', 's: [connection X5/s =>[signal: VPWR w=1]]', 'b: [connection X5/b =>[signal: VPB w=1]]']]
X__35__5 _35_:X _35__a_788_316# VPWR no_conn_151 sky130_fd_pr__pfet_01v8_hvt w=1e+06u l=150000u
** [instance X6 of sky130_fd_pr__nfet_01v8, params={'w': '420000u', 'l': '150000u'} connections=['d: [connection X6/d =>[signal: a_288_47# w=1]]', 'g: [connection X6/g =>[signal: S1 w=1]]', 's: [connection X6/s =>[signal: a_788_316# w=1]]', 'b: [connection X6/b =>[signal: VNB w=1]]']]
X__35__6 _35__a_288_47# _35_:S1 _35__a_788_316# no_conn_150 sky130_fd_pr__nfet_01v8 w=420000u l=150000u
** [instance X7 of sky130_fd_pr__pfet_01v8_hvt, params={'w': '420000u', 'l': '150000u'} connections=['d: [connection X7/d =>[signal: a_193_369# w=1]]', 'g: [connection X7/g =>[signal: S0 w=1]]', 's: [connection X7/s =>[signal: a_288_47# w=1]]', 'b: [connection X7/b =>[signal: VPB w=1]]']]
X__35__7 _35__a_193_369# _35_:S0 _35__a_288_47# no_conn_151 sky130_fd_pr__pfet_01v8_hvt w=420000u l=150000u
** [instance X8 of sky130_fd_pr__pfet_01v8_hvt, params={'w': '640000u', 'l': '150000u'} connections=['d: [connection X8/d =>[signal: a_372_413# w=1]]', 'g: [connection X8/g =>[signal: A3 w=1]]', 's: [connection X8/s =>[signal: VPWR w=1]]', 'b: [connection X8/b =>[signal: VPB w=1]]']]
X__35__8 _35__a_372_413# _35_:A3 VPWR no_conn_151 sky130_fd_pr__pfet_01v8_hvt w=640000u l=150000u
** [instance X9 of sky130_fd_pr__nfet_01v8, params={'w': '360000u', 'l': '150000u'} connections=['d: [connection X9/d =>[signal: a_872_316# w=1]]', 'g: [connection X9/g =>[signal: a_27_47# w=1]]', 's: [connection X9/s =>[signal: a_1281_47# w=1]]', 'b: [connection X9/b =>[signal: VNB w=1]]']]
X__35__9 _35__a_872_316# _35__a_27_47# _35__a_1281_47# no_conn_150 sky130_fd_pr__nfet_01v8 w=360000u l=150000u
** [instance X10 of sky130_fd_pr__pfet_01v8_hvt, params={'w': '420000u', 'l': '150000u'} connections=['d: [connection X10/d =>[signal: a_288_47# w=1]]', 'g: [connection X10/g =>[signal: a_27_47# w=1]]', 's: [connection X10/s =>[signal: a_372_413# w=1]]', 'b: [connection X10/b =>[signal: VPB w=1]]']]
X__35__10 _35__a_288_47# _35__a_27_47# _35__a_372_413# no_conn_151 sky130_fd_pr__pfet_01v8_hvt w=420000u l=150000u
** [instance X11 of sky130_fd_pr__nfet_01v8, params={'w': '420000u', 'l': '150000u'} connections=['d: [connection X11/d =>[signal: VGND w=1]]', 'g: [connection X11/g =>[signal: A1 w=1]]', 's: [connection X11/s =>[signal: a_1064_47# w=1]]', 'b: [connection X11/b =>[signal: VNB w=1]]']]
X__35__11 VGND _35_:A1 _35__a_1064_47# no_conn_150 sky130_fd_pr__nfet_01v8 w=420000u l=150000u
** [instance X12 of sky130_fd_pr__pfet_01v8_hvt, params={'w': '640000u', 'l': '150000u'} connections=['d: [connection X12/d =>[signal: VPWR w=1]]', 'g: [connection X12/g =>[signal: S1 w=1]]', 's: [connection X12/s =>[signal: a_600_345# w=1]]', 'b: [connection X12/b =>[signal: VPB w=1]]']]
X__35__12 VPWR _35_:S1 _35__a_600_345# no_conn_151 sky130_fd_pr__pfet_01v8_hvt w=640000u l=150000u
** [instance X13 of sky130_fd_pr__pfet_01v8_hvt, params={'w': '420000u', 'l': '150000u'} connections=['d: [connection X13/d =>[signal: a_872_316# w=1]]', 'g: [connection X13/g =>[signal: S0 w=1]]', 's: [connection X13/s =>[signal: a_1279_413# w=1]]', 'b: [connection X13/b =>[signal: VPB w=1]]']]
X__35__13 _35__a_872_316# _35_:S0 _35__a_1279_413# no_conn_151 sky130_fd_pr__pfet_01v8_hvt w=420000u l=150000u
** [instance X14 of sky130_fd_pr__pfet_01v8_hvt, params={'w': '640000u', 'l': '150000u'} connections=['d: [connection X14/d =>[signal: a_27_47# w=1]]', 'g: [connection X14/g =>[signal: S0 w=1]]', 's: [connection X14/s =>[signal: VPWR w=1]]', 'b: [connection X14/b =>[signal: VPB w=1]]']]
X__35__14 _35__a_27_47# _35_:S0 VPWR no_conn_151 sky130_fd_pr__pfet_01v8_hvt w=640000u l=150000u
** [instance X15 of sky130_fd_pr__pfet_01v8_hvt, params={'w': '640000u', 'l': '150000u'} connections=['d: [connection X15/d =>[signal: VPWR w=1]]', 'g: [connection X15/g =>[signal: A2 w=1]]', 's: [connection X15/s =>[signal: a_193_369# w=1]]', 'b: [connection X15/b =>[signal: VPB w=1]]']]
X__35__15 VPWR _35_:A2 _35__a_193_369# no_conn_151 sky130_fd_pr__pfet_01v8_hvt w=640000u l=150000u
** [instance X16 of sky130_fd_pr__nfet_01v8, params={'w': '420000u', 'l': '150000u'} connections=['d: [connection X16/d =>[signal: VGND w=1]]', 'g: [connection X16/g =>[signal: A2 w=1]]', 's: [connection X16/s =>[signal: a_193_47# w=1]]', 'b: [connection X16/b =>[signal: VNB w=1]]']]
X__35__16 VGND _35_:A2 _35__a_193_47# no_conn_150 sky130_fd_pr__nfet_01v8 w=420000u l=150000u
** [instance X17 of sky130_fd_pr__pfet_01v8_hvt, params={'w': '540000u', 'l': '150000u'} connections=['d: [connection X17/d =>[signal: a_288_47# w=1]]', 'g: [connection X17/g =>[signal: a_600_345# w=1]]', 's: [connection X17/s =>[signal: a_788_316# w=1]]', 'b: [connection X17/b =>[signal: VPB w=1]]']]
X__35__17 _35__a_288_47# _35__a_600_345# _35__a_788_316# no_conn_151 sky130_fd_pr__pfet_01v8_hvt w=540000u l=150000u
** [instance X18 of sky130_fd_pr__nfet_01v8, params={'w': '420000u', 'l': '150000u'} connections=['d: [connection X18/d =>[signal: a_397_47# w=1]]', 'g: [connection X18/g =>[signal: A3 w=1]]', 's: [connection X18/s =>[signal: VGND w=1]]', 'b: [connection X18/b =>[signal: VNB w=1]]']]
X__35__18 _35__a_397_47# _35_:A3 VGND no_conn_150 sky130_fd_pr__nfet_01v8 w=420000u l=150000u
** [instance X19 of sky130_fd_pr__nfet_01v8, params={'w': '420000u', 'l': '150000u'} connections=['d: [connection X19/d =>[signal: a_27_47# w=1]]', 'g: [connection X19/g =>[signal: S0 w=1]]', 's: [connection X19/s =>[signal: VGND w=1]]', 'b: [connection X19/b =>[signal: VNB w=1]]']]
X__35__19 _35__a_27_47# _35_:S0 VGND no_conn_150 sky130_fd_pr__nfet_01v8 w=420000u l=150000u
** [instance X20 of sky130_fd_pr__pfet_01v8_hvt, params={'w': '420000u', 'l': '150000u'} connections=['d: [connection X20/d =>[signal: a_1060_369# w=1]]', 'g: [connection X20/g =>[signal: a_27_47# w=1]]', 's: [connection X20/s =>[signal: a_872_316# w=1]]', 'b: [connection X20/b =>[signal: VPB w=1]]']]
X__35__20 _35__a_1060_369# _35__a_27_47# _35__a_872_316# no_conn_151 sky130_fd_pr__pfet_01v8_hvt w=420000u l=150000u
** [instance X21 of sky130_fd_pr__nfet_01v8, params={'w': '420000u', 'l': '150000u'} connections=['d: [connection X21/d =>[signal: VGND w=1]]', 'g: [connection X21/g =>[signal: S1 w=1]]', 's: [connection X21/s =>[signal: a_600_345# w=1]]', 'b: [connection X21/b =>[signal: VNB w=1]]']]
X__35__21 VGND _35_:S1 _35__a_600_345# no_conn_150 sky130_fd_pr__nfet_01v8 w=420000u l=150000u
** [instance X22 of sky130_fd_pr__nfet_01v8, params={'w': '420000u', 'l': '150000u'} connections=['d: [connection X22/d =>[signal: a_1281_47# w=1]]', 'g: [connection X22/g =>[signal: A0 w=1]]', 's: [connection X22/s =>[signal: VGND w=1]]', 'b: [connection X22/b =>[signal: VNB w=1]]']]
X__35__22 _35__a_1281_47# _35_:A0 VGND no_conn_150 sky130_fd_pr__nfet_01v8 w=420000u l=150000u
** [instance X23 of sky130_fd_pr__nfet_01v8, params={'w': '650000u', 'l': '150000u'} connections=['d: [connection X23/d =>[signal: X w=1]]', 'g: [connection X23/g =>[signal: a_788_316# w=1]]', 's: [connection X23/s =>[signal: VGND w=1]]', 'b: [connection X23/b =>[signal: VNB w=1]]']]
X__35__23 _35_:X _35__a_788_316# VGND no_conn_150 sky130_fd_pr__nfet_01v8 w=650000u l=150000u
** [instance X24 of sky130_fd_pr__nfet_01v8, params={'w': '360000u', 'l': '150000u'} connections=['d: [connection X24/d =>[signal: a_288_47# w=1]]', 'g: [connection X24/g =>[signal: S0 w=1]]', 's: [connection X24/s =>[signal: a_397_47# w=1]]', 'b: [connection X24/b =>[signal: VNB w=1]]']]
X__35__24 _35__a_288_47# _35_:S0 _35__a_397_47# no_conn_150 sky130_fd_pr__nfet_01v8 w=360000u l=150000u
** [instance X25 of sky130_fd_pr__pfet_01v8_hvt, params={'w': '540000u', 'l': '150000u'} connections=['d: [connection X25/d =>[signal: a_788_316# w=1]]', 'g: [connection X25/g =>[signal: S1 w=1]]', 's: [connection X25/s =>[signal: a_872_316# w=1]]', 'b: [connection X25/b =>[signal: VPB w=1]]']]
X__35__25 _35__a_788_316# _35_:S1 _35__a_872_316# no_conn_151 sky130_fd_pr__pfet_01v8_hvt w=540000u l=150000u
** [instance X26 of sky130_fd_pr__nfet_01v8, params={'w': '420000u', 'l': '150000u'} connections=['d: [connection X26/d =>[signal: a_788_316# w=1]]', 'g: [connection X26/g =>[signal: a_600_345# w=1]]', 's: [connection X26/s =>[signal: a_872_316# w=1]]', 'b: [connection X26/b =>[signal: VNB w=1]]']]
X__35__26 _35__a_788_316# _35__a_600_345# _35__a_872_316# no_conn_150 sky130_fd_pr__nfet_01v8 w=420000u l=150000u
** [instance X27 of sky130_fd_pr__nfet_01v8, params={'w': '360000u', 'l': '150000u'} connections=['d: [connection X27/d =>[signal: a_1064_47# w=1]]', 'g: [connection X27/g =>[signal: S0 w=1]]', 's: [connection X27/s =>[signal: a_872_316# w=1]]', 'b: [connection X27/b =>[signal: VNB w=1]]']]
X__35__27 _35__a_1064_47# _35_:S0 _35__a_872_316# no_conn_150 sky130_fd_pr__nfet_01v8 w=360000u l=150000u

** replacing hold33 with the contents of sky130_fd_sc_hd__dlygate4sd3_1
** [instance X0 of sky130_fd_pr__nfet_01v8, params={'w': '420000u', 'l': '500000u'} connections=['d: [connection X0/d =>[signal: a_391_47# w=1]]', 'g: [connection X0/g =>[signal: a_285_47# w=1]]', 's: [connection X0/s =>[signal: VGND w=1]]', 'b: [connection X0/b =>[signal: VNB w=1]]']]
X_hold33_0 hold33_a_391_47# hold33_a_285_47# VGND no_conn_152 sky130_fd_pr__nfet_01v8 w=420000u l=500000u
** [instance X1 of sky130_fd_pr__pfet_01v8_hvt, params={'w': '420000u', 'l': '500000u'} connections=['d: [connection X1/d =>[signal: VPWR w=1]]', 'g: [connection X1/g =>[signal: a_49_47# w=1]]', 's: [connection X1/s =>[signal: a_285_47# w=1]]', 'b: [connection X1/b =>[signal: VPB w=1]]']]
X_hold33_1 VPWR hold33_a_49_47# hold33_a_285_47# no_conn_153 sky130_fd_pr__pfet_01v8_hvt w=420000u l=500000u
** [instance X2 of sky130_fd_pr__nfet_01v8, params={'w': '420000u', 'l': '150000u'} connections=['d: [connection X2/d =>[signal: a_49_47# w=1]]', 'g: [connection X2/g =>[signal: A w=1]]', 's: [connection X2/s =>[signal: VGND w=1]]', 'b: [connection X2/b =>[signal: VNB w=1]]']]
X_hold33_2 hold33_a_49_47# hold33:A VGND no_conn_152 sky130_fd_pr__nfet_01v8 w=420000u l=150000u
** [instance X3 of sky130_fd_pr__pfet_01v8_hvt, params={'w': '1e+06u', 'l': '150000u'} connections=['d: [connection X3/d =>[signal: VPWR w=1]]', 'g: [connection X3/g =>[signal: a_391_47# w=1]]', 's: [connection X3/s =>[signal: X w=1]]', 'b: [connection X3/b =>[signal: VPB w=1]]']]
X_hold33_3 VPWR hold33_a_391_47# hold33:X no_conn_153 sky130_fd_pr__pfet_01v8_hvt w=1e+06u l=150000u
** [instance X4 of sky130_fd_pr__nfet_01v8, params={'w': '650000u', 'l': '150000u'} connections=['d: [connection X4/d =>[signal: VGND w=1]]', 'g: [connection X4/g =>[signal: a_391_47# w=1]]', 's: [connection X4/s =>[signal: X w=1]]', 'b: [connection X4/b =>[signal: VNB w=1]]']]
X_hold33_4 VGND hold33_a_391_47# hold33:X no_conn_152 sky130_fd_pr__nfet_01v8 w=650000u l=150000u
** [instance X5 of sky130_fd_pr__nfet_01v8, params={'w': '420000u', 'l': '500000u'} connections=['d: [connection X5/d =>[signal: VGND w=1]]', 'g: [connection X5/g =>[signal: a_49_47# w=1]]', 's: [connection X5/s =>[signal: a_285_47# w=1]]', 'b: [connection X5/b =>[signal: VNB w=1]]']]
X_hold33_5 VGND hold33_a_49_47# hold33_a_285_47# no_conn_152 sky130_fd_pr__nfet_01v8 w=420000u l=500000u
** [instance X6 of sky130_fd_pr__pfet_01v8_hvt, params={'w': '420000u', 'l': '500000u'} connections=['d: [connection X6/d =>[signal: a_391_47# w=1]]', 'g: [connection X6/g =>[signal: a_285_47# w=1]]', 's: [connection X6/s =>[signal: VPWR w=1]]', 'b: [connection X6/b =>[signal: VPB w=1]]']]
X_hold33_6 hold33_a_391_47# hold33_a_285_47# VPWR no_conn_153 sky130_fd_pr__pfet_01v8_hvt w=420000u l=500000u
** [instance X7 of sky130_fd_pr__pfet_01v8_hvt, params={'w': '420000u', 'l': '150000u'} connections=['d: [connection X7/d =>[signal: a_49_47# w=1]]', 'g: [connection X7/g =>[signal: A w=1]]', 's: [connection X7/s =>[signal: VPWR w=1]]', 'b: [connection X7/b =>[signal: VPB w=1]]']]
X_hold33_7 hold33_a_49_47# hold33:A VPWR no_conn_153 sky130_fd_pr__pfet_01v8_hvt w=420000u l=150000u

** replacing _40_ with the contents of sky130_fd_sc_hd__mux2_1
** [instance X0 of sky130_fd_pr__pfet_01v8_hvt, params={'w': '420000u', 'l': '150000u'} connections=['d: [connection X0/d =>[signal: VPWR w=1]]', 'g: [connection X0/g =>[signal: S w=1]]', 's: [connection X0/s =>[signal: a_218_374# w=1]]', 'b: [connection X0/b =>[signal: VPB w=1]]']]
X__40__0 VPWR _40_:S _40__a_218_374# no_conn_155 sky130_fd_pr__pfet_01v8_hvt w=420000u l=150000u
** [instance X1 of sky130_fd_pr__nfet_01v8, params={'w': '420000u', 'l': '150000u'} connections=['d: [connection X1/d =>[signal: a_76_199# w=1]]', 'g: [connection X1/g =>[signal: A0 w=1]]', 's: [connection X1/s =>[signal: a_439_47# w=1]]', 'b: [connection X1/b =>[signal: VNB w=1]]']]
X__40__1 _40__a_76_199# _40_:A0 _40__a_439_47# no_conn_154 sky130_fd_pr__nfet_01v8 w=420000u l=150000u
** [instance X2 of sky130_fd_pr__pfet_01v8_hvt, params={'w': '420000u', 'l': '150000u'} connections=['d: [connection X2/d =>[signal: a_535_374# w=1]]', 'g: [connection X2/g =>[signal: a_505_21# w=1]]', 's: [connection X2/s =>[signal: VPWR w=1]]', 'b: [connection X2/b =>[signal: VPB w=1]]']]
X__40__2 _40__a_535_374# _40__a_505_21# VPWR no_conn_155 sky130_fd_pr__pfet_01v8_hvt w=420000u l=150000u
** [instance X3 of sky130_fd_pr__pfet_01v8_hvt, params={'w': '420000u', 'l': '150000u'} connections=['d: [connection X3/d =>[signal: VPWR w=1]]', 'g: [connection X3/g =>[signal: S w=1]]', 's: [connection X3/s =>[signal: a_505_21# w=1]]', 'b: [connection X3/b =>[signal: VPB w=1]]']]
X__40__3 VPWR _40_:S _40__a_505_21# no_conn_155 sky130_fd_pr__pfet_01v8_hvt w=420000u l=150000u
** [instance X4 of sky130_fd_pr__pfet_01v8_hvt, params={'w': '420000u', 'l': '150000u'} connections=['d: [connection X4/d =>[signal: a_76_199# w=1]]', 'g: [connection X4/g =>[signal: A1 w=1]]', 's: [connection X4/s =>[signal: a_535_374# w=1]]', 'b: [connection X4/b =>[signal: VPB w=1]]']]
X__40__4 _40__a_76_199# _40_:A1 _40__a_535_374# no_conn_155 sky130_fd_pr__pfet_01v8_hvt w=420000u l=150000u
** [instance X5 of sky130_fd_pr__nfet_01v8, params={'w': '420000u', 'l': '150000u'} connections=['d: [connection X5/d =>[signal: a_218_47# w=1]]', 'g: [connection X5/g =>[signal: A1 w=1]]', 's: [connection X5/s =>[signal: a_76_199# w=1]]', 'b: [connection X5/b =>[signal: VNB w=1]]']]
X__40__5 _40__a_218_47# _40_:A1 _40__a_76_199# no_conn_154 sky130_fd_pr__nfet_01v8 w=420000u l=150000u
** [instance X6 of sky130_fd_pr__pfet_01v8_hvt, params={'w': '420000u', 'l': '150000u'} connections=['d: [connection X6/d =>[signal: a_218_374# w=1]]', 'g: [connection X6/g =>[signal: A0 w=1]]', 's: [connection X6/s =>[signal: a_76_199# w=1]]', 'b: [connection X6/b =>[signal: VPB w=1]]']]
X__40__6 _40__a_218_374# _40_:A0 _40__a_76_199# no_conn_155 sky130_fd_pr__pfet_01v8_hvt w=420000u l=150000u
** [instance X7 of sky130_fd_pr__nfet_01v8, params={'w': '650000u', 'l': '150000u'} connections=['d: [connection X7/d =>[signal: X w=1]]', 'g: [connection X7/g =>[signal: a_76_199# w=1]]', 's: [connection X7/s =>[signal: VGND w=1]]', 'b: [connection X7/b =>[signal: VNB w=1]]']]
X__40__7 _40_:X _40__a_76_199# VGND no_conn_154 sky130_fd_pr__nfet_01v8 w=650000u l=150000u
** [instance X8 of sky130_fd_pr__pfet_01v8_hvt, params={'w': '1e+06u', 'l': '150000u'} connections=['d: [connection X8/d =>[signal: X w=1]]', 'g: [connection X8/g =>[signal: a_76_199# w=1]]', 's: [connection X8/s =>[signal: VPWR w=1]]', 'b: [connection X8/b =>[signal: VPB w=1]]']]
X__40__8 _40_:X _40__a_76_199# VPWR no_conn_155 sky130_fd_pr__pfet_01v8_hvt w=1e+06u l=150000u
** [instance X9 of sky130_fd_pr__nfet_01v8, params={'w': '420000u', 'l': '150000u'} connections=['d: [connection X9/d =>[signal: VGND w=1]]', 'g: [connection X9/g =>[signal: S w=1]]', 's: [connection X9/s =>[signal: a_218_47# w=1]]', 'b: [connection X9/b =>[signal: VNB w=1]]']]
X__40__9 VGND _40_:S _40__a_218_47# no_conn_154 sky130_fd_pr__nfet_01v8 w=420000u l=150000u
** [instance X10 of sky130_fd_pr__nfet_01v8, params={'w': '420000u', 'l': '150000u'} connections=['d: [connection X10/d =>[signal: VGND w=1]]', 'g: [connection X10/g =>[signal: S w=1]]', 's: [connection X10/s =>[signal: a_505_21# w=1]]', 'b: [connection X10/b =>[signal: VNB w=1]]']]
X__40__10 VGND _40_:S _40__a_505_21# no_conn_154 sky130_fd_pr__nfet_01v8 w=420000u l=150000u
** [instance X11 of sky130_fd_pr__nfet_01v8, params={'w': '420000u', 'l': '150000u'} connections=['d: [connection X11/d =>[signal: a_439_47# w=1]]', 'g: [connection X11/g =>[signal: a_505_21# w=1]]', 's: [connection X11/s =>[signal: VGND w=1]]', 'b: [connection X11/b =>[signal: VNB w=1]]']]
X__40__11 _40__a_439_47# _40__a_505_21# VGND no_conn_154 sky130_fd_pr__nfet_01v8 w=420000u l=150000u

** replacing clkbuf_1_1__f_scan_clk with the contents of sky130_fd_sc_hd__clkbuf_16
** [instance X0 of sky130_fd_pr__pfet_01v8_hvt, params={'w': '1e+06u', 'l': '150000u'} connections=['d: [connection X0/d =>[signal: VPWR w=1]]', 'g: [connection X0/g =>[signal: a_110_47# w=1]]', 's: [connection X0/s =>[signal: X w=1]]', 'b: [connection X0/b =>[signal: VPB w=1]]']]
X_clkbuf_1_1__f_scan_clk_0 VPWR clkbuf_1_1__f_scan_clk_a_110_47# clkbuf_1_1__f_scan_clk:X no_conn_157 sky130_fd_pr__pfet_01v8_hvt w=1e+06u l=150000u
** [instance X1 of sky130_fd_pr__nfet_01v8, params={'w': '420000u', 'l': '150000u'} connections=['d: [connection X1/d =>[signal: X w=1]]', 'g: [connection X1/g =>[signal: a_110_47# w=1]]', 's: [connection X1/s =>[signal: VGND w=1]]', 'b: [connection X1/b =>[signal: VNB w=1]]']]
X_clkbuf_1_1__f_scan_clk_1 clkbuf_1_1__f_scan_clk:X clkbuf_1_1__f_scan_clk_a_110_47# VGND no_conn_156 sky130_fd_pr__nfet_01v8 w=420000u l=150000u
** [instance X2 of sky130_fd_pr__nfet_01v8, params={'w': '420000u', 'l': '150000u'} connections=['d: [connection X2/d =>[signal: X w=1]]', 'g: [connection X2/g =>[signal: a_110_47# w=1]]', 's: [connection X2/s =>[signal: VGND w=1]]', 'b: [connection X2/b =>[signal: VNB w=1]]']]
X_clkbuf_1_1__f_scan_clk_2 clkbuf_1_1__f_scan_clk:X clkbuf_1_1__f_scan_clk_a_110_47# VGND no_conn_156 sky130_fd_pr__nfet_01v8 w=420000u l=150000u
** [instance X3 of sky130_fd_pr__pfet_01v8_hvt, params={'w': '1e+06u', 'l': '150000u'} connections=['d: [connection X3/d =>[signal: a_110_47# w=1]]', 'g: [connection X3/g =>[signal: A w=1]]', 's: [connection X3/s =>[signal: VPWR w=1]]', 'b: [connection X3/b =>[signal: VPB w=1]]']]
X_clkbuf_1_1__f_scan_clk_3 clkbuf_1_1__f_scan_clk_a_110_47# clkbuf_1_1__f_scan_clk:A VPWR no_conn_157 sky130_fd_pr__pfet_01v8_hvt w=1e+06u l=150000u
** [instance X4 of sky130_fd_pr__pfet_01v8_hvt, params={'w': '1e+06u', 'l': '150000u'} connections=['d: [connection X4/d =>[signal: VPWR w=1]]', 'g: [connection X4/g =>[signal: a_110_47# w=1]]', 's: [connection X4/s =>[signal: X w=1]]', 'b: [connection X4/b =>[signal: VPB w=1]]']]
X_clkbuf_1_1__f_scan_clk_4 VPWR clkbuf_1_1__f_scan_clk_a_110_47# clkbuf_1_1__f_scan_clk:X no_conn_157 sky130_fd_pr__pfet_01v8_hvt w=1e+06u l=150000u
** [instance X5 of sky130_fd_pr__pfet_01v8_hvt, params={'w': '1e+06u', 'l': '150000u'} connections=['d: [connection X5/d =>[signal: X w=1]]', 'g: [connection X5/g =>[signal: a_110_47# w=1]]', 's: [connection X5/s =>[signal: VPWR w=1]]', 'b: [connection X5/b =>[signal: VPB w=1]]']]
X_clkbuf_1_1__f_scan_clk_5 clkbuf_1_1__f_scan_clk:X clkbuf_1_1__f_scan_clk_a_110_47# VPWR no_conn_157 sky130_fd_pr__pfet_01v8_hvt w=1e+06u l=150000u
** [instance X6 of sky130_fd_pr__nfet_01v8, params={'w': '420000u', 'l': '150000u'} connections=['d: [connection X6/d =>[signal: a_110_47# w=1]]', 'g: [connection X6/g =>[signal: A w=1]]', 's: [connection X6/s =>[signal: VGND w=1]]', 'b: [connection X6/b =>[signal: VNB w=1]]']]
X_clkbuf_1_1__f_scan_clk_6 clkbuf_1_1__f_scan_clk_a_110_47# clkbuf_1_1__f_scan_clk:A VGND no_conn_156 sky130_fd_pr__nfet_01v8 w=420000u l=150000u
** [instance X7 of sky130_fd_pr__pfet_01v8_hvt, params={'w': '1e+06u', 'l': '150000u'} connections=['d: [connection X7/d =>[signal: VPWR w=1]]', 'g: [connection X7/g =>[signal: A w=1]]', 's: [connection X7/s =>[signal: a_110_47# w=1]]', 'b: [connection X7/b =>[signal: VPB w=1]]']]
X_clkbuf_1_1__f_scan_clk_7 VPWR clkbuf_1_1__f_scan_clk:A clkbuf_1_1__f_scan_clk_a_110_47# no_conn_157 sky130_fd_pr__pfet_01v8_hvt w=1e+06u l=150000u
** [instance X8 of sky130_fd_pr__nfet_01v8, params={'w': '420000u', 'l': '150000u'} connections=['d: [connection X8/d =>[signal: VGND w=1]]', 'g: [connection X8/g =>[signal: a_110_47# w=1]]', 's: [connection X8/s =>[signal: X w=1]]', 'b: [connection X8/b =>[signal: VNB w=1]]']]
X_clkbuf_1_1__f_scan_clk_8 VGND clkbuf_1_1__f_scan_clk_a_110_47# clkbuf_1_1__f_scan_clk:X no_conn_156 sky130_fd_pr__nfet_01v8 w=420000u l=150000u
** [instance X9 of sky130_fd_pr__nfet_01v8, params={'w': '420000u', 'l': '150000u'} connections=['d: [connection X9/d =>[signal: VGND w=1]]', 'g: [connection X9/g =>[signal: A w=1]]', 's: [connection X9/s =>[signal: a_110_47# w=1]]', 'b: [connection X9/b =>[signal: VNB w=1]]']]
X_clkbuf_1_1__f_scan_clk_9 VGND clkbuf_1_1__f_scan_clk:A clkbuf_1_1__f_scan_clk_a_110_47# no_conn_156 sky130_fd_pr__nfet_01v8 w=420000u l=150000u
** [instance X10 of sky130_fd_pr__nfet_01v8, params={'w': '420000u', 'l': '150000u'} connections=['d: [connection X10/d =>[signal: X w=1]]', 'g: [connection X10/g =>[signal: a_110_47# w=1]]', 's: [connection X10/s =>[signal: VGND w=1]]', 'b: [connection X10/b =>[signal: VNB w=1]]']]
X_clkbuf_1_1__f_scan_clk_10 clkbuf_1_1__f_scan_clk:X clkbuf_1_1__f_scan_clk_a_110_47# VGND no_conn_156 sky130_fd_pr__nfet_01v8 w=420000u l=150000u
** [instance X11 of sky130_fd_pr__nfet_01v8, params={'w': '420000u', 'l': '150000u'} connections=['d: [connection X11/d =>[signal: X w=1]]', 'g: [connection X11/g =>[signal: a_110_47# w=1]]', 's: [connection X11/s =>[signal: VGND w=1]]', 'b: [connection X11/b =>[signal: VNB w=1]]']]
X_clkbuf_1_1__f_scan_clk_11 clkbuf_1_1__f_scan_clk:X clkbuf_1_1__f_scan_clk_a_110_47# VGND no_conn_156 sky130_fd_pr__nfet_01v8 w=420000u l=150000u
** [instance X12 of sky130_fd_pr__pfet_01v8_hvt, params={'w': '1e+06u', 'l': '150000u'} connections=['d: [connection X12/d =>[signal: a_110_47# w=1]]', 'g: [connection X12/g =>[signal: A w=1]]', 's: [connection X12/s =>[signal: VPWR w=1]]', 'b: [connection X12/b =>[signal: VPB w=1]]']]
X_clkbuf_1_1__f_scan_clk_12 clkbuf_1_1__f_scan_clk_a_110_47# clkbuf_1_1__f_scan_clk:A VPWR no_conn_157 sky130_fd_pr__pfet_01v8_hvt w=1e+06u l=150000u
** [instance X13 of sky130_fd_pr__pfet_01v8_hvt, params={'w': '1e+06u', 'l': '150000u'} connections=['d: [connection X13/d =>[signal: VPWR w=1]]', 'g: [connection X13/g =>[signal: a_110_47# w=1]]', 's: [connection X13/s =>[signal: X w=1]]', 'b: [connection X13/b =>[signal: VPB w=1]]']]
X_clkbuf_1_1__f_scan_clk_13 VPWR clkbuf_1_1__f_scan_clk_a_110_47# clkbuf_1_1__f_scan_clk:X no_conn_157 sky130_fd_pr__pfet_01v8_hvt w=1e+06u l=150000u
** [instance X14 of sky130_fd_pr__nfet_01v8, params={'w': '420000u', 'l': '150000u'} connections=['d: [connection X14/d =>[signal: X w=1]]', 'g: [connection X14/g =>[signal: a_110_47# w=1]]', 's: [connection X14/s =>[signal: VGND w=1]]', 'b: [connection X14/b =>[signal: VNB w=1]]']]
X_clkbuf_1_1__f_scan_clk_14 clkbuf_1_1__f_scan_clk:X clkbuf_1_1__f_scan_clk_a_110_47# VGND no_conn_156 sky130_fd_pr__nfet_01v8 w=420000u l=150000u
** [instance X15 of sky130_fd_pr__pfet_01v8_hvt, params={'w': '1e+06u', 'l': '150000u'} connections=['d: [connection X15/d =>[signal: VPWR w=1]]', 'g: [connection X15/g =>[signal: A w=1]]', 's: [connection X15/s =>[signal: a_110_47# w=1]]', 'b: [connection X15/b =>[signal: VPB w=1]]']]
X_clkbuf_1_1__f_scan_clk_15 VPWR clkbuf_1_1__f_scan_clk:A clkbuf_1_1__f_scan_clk_a_110_47# no_conn_157 sky130_fd_pr__pfet_01v8_hvt w=1e+06u l=150000u
** [instance X16 of sky130_fd_pr__nfet_01v8, params={'w': '420000u', 'l': '150000u'} connections=['d: [connection X16/d =>[signal: VGND w=1]]', 'g: [connection X16/g =>[signal: a_110_47# w=1]]', 's: [connection X16/s =>[signal: X w=1]]', 'b: [connection X16/b =>[signal: VNB w=1]]']]
X_clkbuf_1_1__f_scan_clk_16 VGND clkbuf_1_1__f_scan_clk_a_110_47# clkbuf_1_1__f_scan_clk:X no_conn_156 sky130_fd_pr__nfet_01v8 w=420000u l=150000u
** [instance X17 of sky130_fd_pr__nfet_01v8, params={'w': '420000u', 'l': '150000u'} connections=['d: [connection X17/d =>[signal: X w=1]]', 'g: [connection X17/g =>[signal: a_110_47# w=1]]', 's: [connection X17/s =>[signal: VGND w=1]]', 'b: [connection X17/b =>[signal: VNB w=1]]']]
X_clkbuf_1_1__f_scan_clk_17 clkbuf_1_1__f_scan_clk:X clkbuf_1_1__f_scan_clk_a_110_47# VGND no_conn_156 sky130_fd_pr__nfet_01v8 w=420000u l=150000u
** [instance X18 of sky130_fd_pr__nfet_01v8, params={'w': '420000u', 'l': '150000u'} connections=['d: [connection X18/d =>[signal: VGND w=1]]', 'g: [connection X18/g =>[signal: a_110_47# w=1]]', 's: [connection X18/s =>[signal: X w=1]]', 'b: [connection X18/b =>[signal: VNB w=1]]']]
X_clkbuf_1_1__f_scan_clk_18 VGND clkbuf_1_1__f_scan_clk_a_110_47# clkbuf_1_1__f_scan_clk:X no_conn_156 sky130_fd_pr__nfet_01v8 w=420000u l=150000u
** [instance X19 of sky130_fd_pr__nfet_01v8, params={'w': '420000u', 'l': '150000u'} connections=['d: [connection X19/d =>[signal: VGND w=1]]', 'g: [connection X19/g =>[signal: a_110_47# w=1]]', 's: [connection X19/s =>[signal: X w=1]]', 'b: [connection X19/b =>[signal: VNB w=1]]']]
X_clkbuf_1_1__f_scan_clk_19 VGND clkbuf_1_1__f_scan_clk_a_110_47# clkbuf_1_1__f_scan_clk:X no_conn_156 sky130_fd_pr__nfet_01v8 w=420000u l=150000u
** [instance X20 of sky130_fd_pr__pfet_01v8_hvt, params={'w': '1e+06u', 'l': '150000u'} connections=['d: [connection X20/d =>[signal: X w=1]]', 'g: [connection X20/g =>[signal: a_110_47# w=1]]', 's: [connection X20/s =>[signal: VPWR w=1]]', 'b: [connection X20/b =>[signal: VPB w=1]]']]
X_clkbuf_1_1__f_scan_clk_20 clkbuf_1_1__f_scan_clk:X clkbuf_1_1__f_scan_clk_a_110_47# VPWR no_conn_157 sky130_fd_pr__pfet_01v8_hvt w=1e+06u l=150000u
** [instance X21 of sky130_fd_pr__pfet_01v8_hvt, params={'w': '1e+06u', 'l': '150000u'} connections=['d: [connection X21/d =>[signal: X w=1]]', 'g: [connection X21/g =>[signal: a_110_47# w=1]]', 's: [connection X21/s =>[signal: VPWR w=1]]', 'b: [connection X21/b =>[signal: VPB w=1]]']]
X_clkbuf_1_1__f_scan_clk_21 clkbuf_1_1__f_scan_clk:X clkbuf_1_1__f_scan_clk_a_110_47# VPWR no_conn_157 sky130_fd_pr__pfet_01v8_hvt w=1e+06u l=150000u
** [instance X22 of sky130_fd_pr__pfet_01v8_hvt, params={'w': '1e+06u', 'l': '150000u'} connections=['d: [connection X22/d =>[signal: X w=1]]', 'g: [connection X22/g =>[signal: a_110_47# w=1]]', 's: [connection X22/s =>[signal: VPWR w=1]]', 'b: [connection X22/b =>[signal: VPB w=1]]']]
X_clkbuf_1_1__f_scan_clk_22 clkbuf_1_1__f_scan_clk:X clkbuf_1_1__f_scan_clk_a_110_47# VPWR no_conn_157 sky130_fd_pr__pfet_01v8_hvt w=1e+06u l=150000u
** [instance X23 of sky130_fd_pr__pfet_01v8_hvt, params={'w': '1e+06u', 'l': '150000u'} connections=['d: [connection X23/d =>[signal: VPWR w=1]]', 'g: [connection X23/g =>[signal: a_110_47# w=1]]', 's: [connection X23/s =>[signal: X w=1]]', 'b: [connection X23/b =>[signal: VPB w=1]]']]
X_clkbuf_1_1__f_scan_clk_23 VPWR clkbuf_1_1__f_scan_clk_a_110_47# clkbuf_1_1__f_scan_clk:X no_conn_157 sky130_fd_pr__pfet_01v8_hvt w=1e+06u l=150000u
** [instance X24 of sky130_fd_pr__pfet_01v8_hvt, params={'w': '1e+06u', 'l': '150000u'} connections=['d: [connection X24/d =>[signal: VPWR w=1]]', 'g: [connection X24/g =>[signal: a_110_47# w=1]]', 's: [connection X24/s =>[signal: X w=1]]', 'b: [connection X24/b =>[signal: VPB w=1]]']]
X_clkbuf_1_1__f_scan_clk_24 VPWR clkbuf_1_1__f_scan_clk_a_110_47# clkbuf_1_1__f_scan_clk:X no_conn_157 sky130_fd_pr__pfet_01v8_hvt w=1e+06u l=150000u
** [instance X25 of sky130_fd_pr__nfet_01v8, params={'w': '420000u', 'l': '150000u'} connections=['d: [connection X25/d =>[signal: VGND w=1]]', 'g: [connection X25/g =>[signal: a_110_47# w=1]]', 's: [connection X25/s =>[signal: X w=1]]', 'b: [connection X25/b =>[signal: VNB w=1]]']]
X_clkbuf_1_1__f_scan_clk_25 VGND clkbuf_1_1__f_scan_clk_a_110_47# clkbuf_1_1__f_scan_clk:X no_conn_156 sky130_fd_pr__nfet_01v8 w=420000u l=150000u
** [instance X26 of sky130_fd_pr__pfet_01v8_hvt, params={'w': '1e+06u', 'l': '150000u'} connections=['d: [connection X26/d =>[signal: X w=1]]', 'g: [connection X26/g =>[signal: a_110_47# w=1]]', 's: [connection X26/s =>[signal: VPWR w=1]]', 'b: [connection X26/b =>[signal: VPB w=1]]']]
X_clkbuf_1_1__f_scan_clk_26 clkbuf_1_1__f_scan_clk:X clkbuf_1_1__f_scan_clk_a_110_47# VPWR no_conn_157 sky130_fd_pr__pfet_01v8_hvt w=1e+06u l=150000u
** [instance X27 of sky130_fd_pr__nfet_01v8, params={'w': '420000u', 'l': '150000u'} connections=['d: [connection X27/d =>[signal: X w=1]]', 'g: [connection X27/g =>[signal: a_110_47# w=1]]', 's: [connection X27/s =>[signal: VGND w=1]]', 'b: [connection X27/b =>[signal: VNB w=1]]']]
X_clkbuf_1_1__f_scan_clk_27 clkbuf_1_1__f_scan_clk:X clkbuf_1_1__f_scan_clk_a_110_47# VGND no_conn_156 sky130_fd_pr__nfet_01v8 w=420000u l=150000u
** [instance X28 of sky130_fd_pr__pfet_01v8_hvt, params={'w': '1e+06u', 'l': '150000u'} connections=['d: [connection X28/d =>[signal: VPWR w=1]]', 'g: [connection X28/g =>[signal: a_110_47# w=1]]', 's: [connection X28/s =>[signal: X w=1]]', 'b: [connection X28/b =>[signal: VPB w=1]]']]
X_clkbuf_1_1__f_scan_clk_28 VPWR clkbuf_1_1__f_scan_clk_a_110_47# clkbuf_1_1__f_scan_clk:X no_conn_157 sky130_fd_pr__pfet_01v8_hvt w=1e+06u l=150000u
** [instance X29 of sky130_fd_pr__nfet_01v8, params={'w': '420000u', 'l': '150000u'} connections=['d: [connection X29/d =>[signal: VGND w=1]]', 'g: [connection X29/g =>[signal: a_110_47# w=1]]', 's: [connection X29/s =>[signal: X w=1]]', 'b: [connection X29/b =>[signal: VNB w=1]]']]
X_clkbuf_1_1__f_scan_clk_29 VGND clkbuf_1_1__f_scan_clk_a_110_47# clkbuf_1_1__f_scan_clk:X no_conn_156 sky130_fd_pr__nfet_01v8 w=420000u l=150000u
** [instance X30 of sky130_fd_pr__nfet_01v8, params={'w': '420000u', 'l': '150000u'} connections=['d: [connection X30/d =>[signal: X w=1]]', 'g: [connection X30/g =>[signal: a_110_47# w=1]]', 's: [connection X30/s =>[signal: VGND w=1]]', 'b: [connection X30/b =>[signal: VNB w=1]]']]
X_clkbuf_1_1__f_scan_clk_30 clkbuf_1_1__f_scan_clk:X clkbuf_1_1__f_scan_clk_a_110_47# VGND no_conn_156 sky130_fd_pr__nfet_01v8 w=420000u l=150000u
** [instance X31 of sky130_fd_pr__pfet_01v8_hvt, params={'w': '1e+06u', 'l': '150000u'} connections=['d: [connection X31/d =>[signal: X w=1]]', 'g: [connection X31/g =>[signal: a_110_47# w=1]]', 's: [connection X31/s =>[signal: VPWR w=1]]', 'b: [connection X31/b =>[signal: VPB w=1]]']]
X_clkbuf_1_1__f_scan_clk_31 clkbuf_1_1__f_scan_clk:X clkbuf_1_1__f_scan_clk_a_110_47# VPWR no_conn_157 sky130_fd_pr__pfet_01v8_hvt w=1e+06u l=150000u
** [instance X32 of sky130_fd_pr__pfet_01v8_hvt, params={'w': '1e+06u', 'l': '150000u'} connections=['d: [connection X32/d =>[signal: X w=1]]', 'g: [connection X32/g =>[signal: a_110_47# w=1]]', 's: [connection X32/s =>[signal: VPWR w=1]]', 'b: [connection X32/b =>[signal: VPB w=1]]']]
X_clkbuf_1_1__f_scan_clk_32 clkbuf_1_1__f_scan_clk:X clkbuf_1_1__f_scan_clk_a_110_47# VPWR no_conn_157 sky130_fd_pr__pfet_01v8_hvt w=1e+06u l=150000u
** [instance X33 of sky130_fd_pr__pfet_01v8_hvt, params={'w': '1e+06u', 'l': '150000u'} connections=['d: [connection X33/d =>[signal: X w=1]]', 'g: [connection X33/g =>[signal: a_110_47# w=1]]', 's: [connection X33/s =>[signal: VPWR w=1]]', 'b: [connection X33/b =>[signal: VPB w=1]]']]
X_clkbuf_1_1__f_scan_clk_33 clkbuf_1_1__f_scan_clk:X clkbuf_1_1__f_scan_clk_a_110_47# VPWR no_conn_157 sky130_fd_pr__pfet_01v8_hvt w=1e+06u l=150000u
** [instance X34 of sky130_fd_pr__nfet_01v8, params={'w': '420000u', 'l': '150000u'} connections=['d: [connection X34/d =>[signal: a_110_47# w=1]]', 'g: [connection X34/g =>[signal: A w=1]]', 's: [connection X34/s =>[signal: VGND w=1]]', 'b: [connection X34/b =>[signal: VNB w=1]]']]
X_clkbuf_1_1__f_scan_clk_34 clkbuf_1_1__f_scan_clk_a_110_47# clkbuf_1_1__f_scan_clk:A VGND no_conn_156 sky130_fd_pr__nfet_01v8 w=420000u l=150000u
** [instance X35 of sky130_fd_pr__pfet_01v8_hvt, params={'w': '1e+06u', 'l': '150000u'} connections=['d: [connection X35/d =>[signal: VPWR w=1]]', 'g: [connection X35/g =>[signal: a_110_47# w=1]]', 's: [connection X35/s =>[signal: X w=1]]', 'b: [connection X35/b =>[signal: VPB w=1]]']]
X_clkbuf_1_1__f_scan_clk_35 VPWR clkbuf_1_1__f_scan_clk_a_110_47# clkbuf_1_1__f_scan_clk:X no_conn_157 sky130_fd_pr__pfet_01v8_hvt w=1e+06u l=150000u
** [instance X36 of sky130_fd_pr__nfet_01v8, params={'w': '420000u', 'l': '150000u'} connections=['d: [connection X36/d =>[signal: VGND w=1]]', 'g: [connection X36/g =>[signal: A w=1]]', 's: [connection X36/s =>[signal: a_110_47# w=1]]', 'b: [connection X36/b =>[signal: VNB w=1]]']]
X_clkbuf_1_1__f_scan_clk_36 VGND clkbuf_1_1__f_scan_clk:A clkbuf_1_1__f_scan_clk_a_110_47# no_conn_156 sky130_fd_pr__nfet_01v8 w=420000u l=150000u
** [instance X37 of sky130_fd_pr__pfet_01v8_hvt, params={'w': '1e+06u', 'l': '150000u'} connections=['d: [connection X37/d =>[signal: VPWR w=1]]', 'g: [connection X37/g =>[signal: a_110_47# w=1]]', 's: [connection X37/s =>[signal: X w=1]]', 'b: [connection X37/b =>[signal: VPB w=1]]']]
X_clkbuf_1_1__f_scan_clk_37 VPWR clkbuf_1_1__f_scan_clk_a_110_47# clkbuf_1_1__f_scan_clk:X no_conn_157 sky130_fd_pr__pfet_01v8_hvt w=1e+06u l=150000u
** [instance X38 of sky130_fd_pr__nfet_01v8, params={'w': '420000u', 'l': '150000u'} connections=['d: [connection X38/d =>[signal: VGND w=1]]', 'g: [connection X38/g =>[signal: a_110_47# w=1]]', 's: [connection X38/s =>[signal: X w=1]]', 'b: [connection X38/b =>[signal: VNB w=1]]']]
X_clkbuf_1_1__f_scan_clk_38 VGND clkbuf_1_1__f_scan_clk_a_110_47# clkbuf_1_1__f_scan_clk:X no_conn_156 sky130_fd_pr__nfet_01v8 w=420000u l=150000u
** [instance X39 of sky130_fd_pr__nfet_01v8, params={'w': '420000u', 'l': '150000u'} connections=['d: [connection X39/d =>[signal: VGND w=1]]', 'g: [connection X39/g =>[signal: a_110_47# w=1]]', 's: [connection X39/s =>[signal: X w=1]]', 'b: [connection X39/b =>[signal: VNB w=1]]']]
X_clkbuf_1_1__f_scan_clk_39 VGND clkbuf_1_1__f_scan_clk_a_110_47# clkbuf_1_1__f_scan_clk:X no_conn_156 sky130_fd_pr__nfet_01v8 w=420000u l=150000u

** replacing clkbuf_1_0__f_scan_clk with the contents of sky130_fd_sc_hd__clkbuf_16
** [instance X0 of sky130_fd_pr__pfet_01v8_hvt, params={'w': '1e+06u', 'l': '150000u'} connections=['d: [connection X0/d =>[signal: VPWR w=1]]', 'g: [connection X0/g =>[signal: a_110_47# w=1]]', 's: [connection X0/s =>[signal: X w=1]]', 'b: [connection X0/b =>[signal: VPB w=1]]']]
X_clkbuf_1_0__f_scan_clk_0 VPWR clkbuf_1_0__f_scan_clk_a_110_47# clkbuf_1_0__f_scan_clk:X no_conn_159 sky130_fd_pr__pfet_01v8_hvt w=1e+06u l=150000u
** [instance X1 of sky130_fd_pr__nfet_01v8, params={'w': '420000u', 'l': '150000u'} connections=['d: [connection X1/d =>[signal: X w=1]]', 'g: [connection X1/g =>[signal: a_110_47# w=1]]', 's: [connection X1/s =>[signal: VGND w=1]]', 'b: [connection X1/b =>[signal: VNB w=1]]']]
X_clkbuf_1_0__f_scan_clk_1 clkbuf_1_0__f_scan_clk:X clkbuf_1_0__f_scan_clk_a_110_47# VGND no_conn_158 sky130_fd_pr__nfet_01v8 w=420000u l=150000u
** [instance X2 of sky130_fd_pr__nfet_01v8, params={'w': '420000u', 'l': '150000u'} connections=['d: [connection X2/d =>[signal: X w=1]]', 'g: [connection X2/g =>[signal: a_110_47# w=1]]', 's: [connection X2/s =>[signal: VGND w=1]]', 'b: [connection X2/b =>[signal: VNB w=1]]']]
X_clkbuf_1_0__f_scan_clk_2 clkbuf_1_0__f_scan_clk:X clkbuf_1_0__f_scan_clk_a_110_47# VGND no_conn_158 sky130_fd_pr__nfet_01v8 w=420000u l=150000u
** [instance X3 of sky130_fd_pr__pfet_01v8_hvt, params={'w': '1e+06u', 'l': '150000u'} connections=['d: [connection X3/d =>[signal: a_110_47# w=1]]', 'g: [connection X3/g =>[signal: A w=1]]', 's: [connection X3/s =>[signal: VPWR w=1]]', 'b: [connection X3/b =>[signal: VPB w=1]]']]
X_clkbuf_1_0__f_scan_clk_3 clkbuf_1_0__f_scan_clk_a_110_47# clkbuf_1_0__f_scan_clk:A VPWR no_conn_159 sky130_fd_pr__pfet_01v8_hvt w=1e+06u l=150000u
** [instance X4 of sky130_fd_pr__pfet_01v8_hvt, params={'w': '1e+06u', 'l': '150000u'} connections=['d: [connection X4/d =>[signal: VPWR w=1]]', 'g: [connection X4/g =>[signal: a_110_47# w=1]]', 's: [connection X4/s =>[signal: X w=1]]', 'b: [connection X4/b =>[signal: VPB w=1]]']]
X_clkbuf_1_0__f_scan_clk_4 VPWR clkbuf_1_0__f_scan_clk_a_110_47# clkbuf_1_0__f_scan_clk:X no_conn_159 sky130_fd_pr__pfet_01v8_hvt w=1e+06u l=150000u
** [instance X5 of sky130_fd_pr__pfet_01v8_hvt, params={'w': '1e+06u', 'l': '150000u'} connections=['d: [connection X5/d =>[signal: X w=1]]', 'g: [connection X5/g =>[signal: a_110_47# w=1]]', 's: [connection X5/s =>[signal: VPWR w=1]]', 'b: [connection X5/b =>[signal: VPB w=1]]']]
X_clkbuf_1_0__f_scan_clk_5 clkbuf_1_0__f_scan_clk:X clkbuf_1_0__f_scan_clk_a_110_47# VPWR no_conn_159 sky130_fd_pr__pfet_01v8_hvt w=1e+06u l=150000u
** [instance X6 of sky130_fd_pr__nfet_01v8, params={'w': '420000u', 'l': '150000u'} connections=['d: [connection X6/d =>[signal: a_110_47# w=1]]', 'g: [connection X6/g =>[signal: A w=1]]', 's: [connection X6/s =>[signal: VGND w=1]]', 'b: [connection X6/b =>[signal: VNB w=1]]']]
X_clkbuf_1_0__f_scan_clk_6 clkbuf_1_0__f_scan_clk_a_110_47# clkbuf_1_0__f_scan_clk:A VGND no_conn_158 sky130_fd_pr__nfet_01v8 w=420000u l=150000u
** [instance X7 of sky130_fd_pr__pfet_01v8_hvt, params={'w': '1e+06u', 'l': '150000u'} connections=['d: [connection X7/d =>[signal: VPWR w=1]]', 'g: [connection X7/g =>[signal: A w=1]]', 's: [connection X7/s =>[signal: a_110_47# w=1]]', 'b: [connection X7/b =>[signal: VPB w=1]]']]
X_clkbuf_1_0__f_scan_clk_7 VPWR clkbuf_1_0__f_scan_clk:A clkbuf_1_0__f_scan_clk_a_110_47# no_conn_159 sky130_fd_pr__pfet_01v8_hvt w=1e+06u l=150000u
** [instance X8 of sky130_fd_pr__nfet_01v8, params={'w': '420000u', 'l': '150000u'} connections=['d: [connection X8/d =>[signal: VGND w=1]]', 'g: [connection X8/g =>[signal: a_110_47# w=1]]', 's: [connection X8/s =>[signal: X w=1]]', 'b: [connection X8/b =>[signal: VNB w=1]]']]
X_clkbuf_1_0__f_scan_clk_8 VGND clkbuf_1_0__f_scan_clk_a_110_47# clkbuf_1_0__f_scan_clk:X no_conn_158 sky130_fd_pr__nfet_01v8 w=420000u l=150000u
** [instance X9 of sky130_fd_pr__nfet_01v8, params={'w': '420000u', 'l': '150000u'} connections=['d: [connection X9/d =>[signal: VGND w=1]]', 'g: [connection X9/g =>[signal: A w=1]]', 's: [connection X9/s =>[signal: a_110_47# w=1]]', 'b: [connection X9/b =>[signal: VNB w=1]]']]
X_clkbuf_1_0__f_scan_clk_9 VGND clkbuf_1_0__f_scan_clk:A clkbuf_1_0__f_scan_clk_a_110_47# no_conn_158 sky130_fd_pr__nfet_01v8 w=420000u l=150000u
** [instance X10 of sky130_fd_pr__nfet_01v8, params={'w': '420000u', 'l': '150000u'} connections=['d: [connection X10/d =>[signal: X w=1]]', 'g: [connection X10/g =>[signal: a_110_47# w=1]]', 's: [connection X10/s =>[signal: VGND w=1]]', 'b: [connection X10/b =>[signal: VNB w=1]]']]
X_clkbuf_1_0__f_scan_clk_10 clkbuf_1_0__f_scan_clk:X clkbuf_1_0__f_scan_clk_a_110_47# VGND no_conn_158 sky130_fd_pr__nfet_01v8 w=420000u l=150000u
** [instance X11 of sky130_fd_pr__nfet_01v8, params={'w': '420000u', 'l': '150000u'} connections=['d: [connection X11/d =>[signal: X w=1]]', 'g: [connection X11/g =>[signal: a_110_47# w=1]]', 's: [connection X11/s =>[signal: VGND w=1]]', 'b: [connection X11/b =>[signal: VNB w=1]]']]
X_clkbuf_1_0__f_scan_clk_11 clkbuf_1_0__f_scan_clk:X clkbuf_1_0__f_scan_clk_a_110_47# VGND no_conn_158 sky130_fd_pr__nfet_01v8 w=420000u l=150000u
** [instance X12 of sky130_fd_pr__pfet_01v8_hvt, params={'w': '1e+06u', 'l': '150000u'} connections=['d: [connection X12/d =>[signal: a_110_47# w=1]]', 'g: [connection X12/g =>[signal: A w=1]]', 's: [connection X12/s =>[signal: VPWR w=1]]', 'b: [connection X12/b =>[signal: VPB w=1]]']]
X_clkbuf_1_0__f_scan_clk_12 clkbuf_1_0__f_scan_clk_a_110_47# clkbuf_1_0__f_scan_clk:A VPWR no_conn_159 sky130_fd_pr__pfet_01v8_hvt w=1e+06u l=150000u
** [instance X13 of sky130_fd_pr__pfet_01v8_hvt, params={'w': '1e+06u', 'l': '150000u'} connections=['d: [connection X13/d =>[signal: VPWR w=1]]', 'g: [connection X13/g =>[signal: a_110_47# w=1]]', 's: [connection X13/s =>[signal: X w=1]]', 'b: [connection X13/b =>[signal: VPB w=1]]']]
X_clkbuf_1_0__f_scan_clk_13 VPWR clkbuf_1_0__f_scan_clk_a_110_47# clkbuf_1_0__f_scan_clk:X no_conn_159 sky130_fd_pr__pfet_01v8_hvt w=1e+06u l=150000u
** [instance X14 of sky130_fd_pr__nfet_01v8, params={'w': '420000u', 'l': '150000u'} connections=['d: [connection X14/d =>[signal: X w=1]]', 'g: [connection X14/g =>[signal: a_110_47# w=1]]', 's: [connection X14/s =>[signal: VGND w=1]]', 'b: [connection X14/b =>[signal: VNB w=1]]']]
X_clkbuf_1_0__f_scan_clk_14 clkbuf_1_0__f_scan_clk:X clkbuf_1_0__f_scan_clk_a_110_47# VGND no_conn_158 sky130_fd_pr__nfet_01v8 w=420000u l=150000u
** [instance X15 of sky130_fd_pr__pfet_01v8_hvt, params={'w': '1e+06u', 'l': '150000u'} connections=['d: [connection X15/d =>[signal: VPWR w=1]]', 'g: [connection X15/g =>[signal: A w=1]]', 's: [connection X15/s =>[signal: a_110_47# w=1]]', 'b: [connection X15/b =>[signal: VPB w=1]]']]
X_clkbuf_1_0__f_scan_clk_15 VPWR clkbuf_1_0__f_scan_clk:A clkbuf_1_0__f_scan_clk_a_110_47# no_conn_159 sky130_fd_pr__pfet_01v8_hvt w=1e+06u l=150000u
** [instance X16 of sky130_fd_pr__nfet_01v8, params={'w': '420000u', 'l': '150000u'} connections=['d: [connection X16/d =>[signal: VGND w=1]]', 'g: [connection X16/g =>[signal: a_110_47# w=1]]', 's: [connection X16/s =>[signal: X w=1]]', 'b: [connection X16/b =>[signal: VNB w=1]]']]
X_clkbuf_1_0__f_scan_clk_16 VGND clkbuf_1_0__f_scan_clk_a_110_47# clkbuf_1_0__f_scan_clk:X no_conn_158 sky130_fd_pr__nfet_01v8 w=420000u l=150000u
** [instance X17 of sky130_fd_pr__nfet_01v8, params={'w': '420000u', 'l': '150000u'} connections=['d: [connection X17/d =>[signal: X w=1]]', 'g: [connection X17/g =>[signal: a_110_47# w=1]]', 's: [connection X17/s =>[signal: VGND w=1]]', 'b: [connection X17/b =>[signal: VNB w=1]]']]
X_clkbuf_1_0__f_scan_clk_17 clkbuf_1_0__f_scan_clk:X clkbuf_1_0__f_scan_clk_a_110_47# VGND no_conn_158 sky130_fd_pr__nfet_01v8 w=420000u l=150000u
** [instance X18 of sky130_fd_pr__nfet_01v8, params={'w': '420000u', 'l': '150000u'} connections=['d: [connection X18/d =>[signal: VGND w=1]]', 'g: [connection X18/g =>[signal: a_110_47# w=1]]', 's: [connection X18/s =>[signal: X w=1]]', 'b: [connection X18/b =>[signal: VNB w=1]]']]
X_clkbuf_1_0__f_scan_clk_18 VGND clkbuf_1_0__f_scan_clk_a_110_47# clkbuf_1_0__f_scan_clk:X no_conn_158 sky130_fd_pr__nfet_01v8 w=420000u l=150000u
** [instance X19 of sky130_fd_pr__nfet_01v8, params={'w': '420000u', 'l': '150000u'} connections=['d: [connection X19/d =>[signal: VGND w=1]]', 'g: [connection X19/g =>[signal: a_110_47# w=1]]', 's: [connection X19/s =>[signal: X w=1]]', 'b: [connection X19/b =>[signal: VNB w=1]]']]
X_clkbuf_1_0__f_scan_clk_19 VGND clkbuf_1_0__f_scan_clk_a_110_47# clkbuf_1_0__f_scan_clk:X no_conn_158 sky130_fd_pr__nfet_01v8 w=420000u l=150000u
** [instance X20 of sky130_fd_pr__pfet_01v8_hvt, params={'w': '1e+06u', 'l': '150000u'} connections=['d: [connection X20/d =>[signal: X w=1]]', 'g: [connection X20/g =>[signal: a_110_47# w=1]]', 's: [connection X20/s =>[signal: VPWR w=1]]', 'b: [connection X20/b =>[signal: VPB w=1]]']]
X_clkbuf_1_0__f_scan_clk_20 clkbuf_1_0__f_scan_clk:X clkbuf_1_0__f_scan_clk_a_110_47# VPWR no_conn_159 sky130_fd_pr__pfet_01v8_hvt w=1e+06u l=150000u
** [instance X21 of sky130_fd_pr__pfet_01v8_hvt, params={'w': '1e+06u', 'l': '150000u'} connections=['d: [connection X21/d =>[signal: X w=1]]', 'g: [connection X21/g =>[signal: a_110_47# w=1]]', 's: [connection X21/s =>[signal: VPWR w=1]]', 'b: [connection X21/b =>[signal: VPB w=1]]']]
X_clkbuf_1_0__f_scan_clk_21 clkbuf_1_0__f_scan_clk:X clkbuf_1_0__f_scan_clk_a_110_47# VPWR no_conn_159 sky130_fd_pr__pfet_01v8_hvt w=1e+06u l=150000u
** [instance X22 of sky130_fd_pr__pfet_01v8_hvt, params={'w': '1e+06u', 'l': '150000u'} connections=['d: [connection X22/d =>[signal: X w=1]]', 'g: [connection X22/g =>[signal: a_110_47# w=1]]', 's: [connection X22/s =>[signal: VPWR w=1]]', 'b: [connection X22/b =>[signal: VPB w=1]]']]
X_clkbuf_1_0__f_scan_clk_22 clkbuf_1_0__f_scan_clk:X clkbuf_1_0__f_scan_clk_a_110_47# VPWR no_conn_159 sky130_fd_pr__pfet_01v8_hvt w=1e+06u l=150000u
** [instance X23 of sky130_fd_pr__pfet_01v8_hvt, params={'w': '1e+06u', 'l': '150000u'} connections=['d: [connection X23/d =>[signal: VPWR w=1]]', 'g: [connection X23/g =>[signal: a_110_47# w=1]]', 's: [connection X23/s =>[signal: X w=1]]', 'b: [connection X23/b =>[signal: VPB w=1]]']]
X_clkbuf_1_0__f_scan_clk_23 VPWR clkbuf_1_0__f_scan_clk_a_110_47# clkbuf_1_0__f_scan_clk:X no_conn_159 sky130_fd_pr__pfet_01v8_hvt w=1e+06u l=150000u
** [instance X24 of sky130_fd_pr__pfet_01v8_hvt, params={'w': '1e+06u', 'l': '150000u'} connections=['d: [connection X24/d =>[signal: VPWR w=1]]', 'g: [connection X24/g =>[signal: a_110_47# w=1]]', 's: [connection X24/s =>[signal: X w=1]]', 'b: [connection X24/b =>[signal: VPB w=1]]']]
X_clkbuf_1_0__f_scan_clk_24 VPWR clkbuf_1_0__f_scan_clk_a_110_47# clkbuf_1_0__f_scan_clk:X no_conn_159 sky130_fd_pr__pfet_01v8_hvt w=1e+06u l=150000u
** [instance X25 of sky130_fd_pr__nfet_01v8, params={'w': '420000u', 'l': '150000u'} connections=['d: [connection X25/d =>[signal: VGND w=1]]', 'g: [connection X25/g =>[signal: a_110_47# w=1]]', 's: [connection X25/s =>[signal: X w=1]]', 'b: [connection X25/b =>[signal: VNB w=1]]']]
X_clkbuf_1_0__f_scan_clk_25 VGND clkbuf_1_0__f_scan_clk_a_110_47# clkbuf_1_0__f_scan_clk:X no_conn_158 sky130_fd_pr__nfet_01v8 w=420000u l=150000u
** [instance X26 of sky130_fd_pr__pfet_01v8_hvt, params={'w': '1e+06u', 'l': '150000u'} connections=['d: [connection X26/d =>[signal: X w=1]]', 'g: [connection X26/g =>[signal: a_110_47# w=1]]', 's: [connection X26/s =>[signal: VPWR w=1]]', 'b: [connection X26/b =>[signal: VPB w=1]]']]
X_clkbuf_1_0__f_scan_clk_26 clkbuf_1_0__f_scan_clk:X clkbuf_1_0__f_scan_clk_a_110_47# VPWR no_conn_159 sky130_fd_pr__pfet_01v8_hvt w=1e+06u l=150000u
** [instance X27 of sky130_fd_pr__nfet_01v8, params={'w': '420000u', 'l': '150000u'} connections=['d: [connection X27/d =>[signal: X w=1]]', 'g: [connection X27/g =>[signal: a_110_47# w=1]]', 's: [connection X27/s =>[signal: VGND w=1]]', 'b: [connection X27/b =>[signal: VNB w=1]]']]
X_clkbuf_1_0__f_scan_clk_27 clkbuf_1_0__f_scan_clk:X clkbuf_1_0__f_scan_clk_a_110_47# VGND no_conn_158 sky130_fd_pr__nfet_01v8 w=420000u l=150000u
** [instance X28 of sky130_fd_pr__pfet_01v8_hvt, params={'w': '1e+06u', 'l': '150000u'} connections=['d: [connection X28/d =>[signal: VPWR w=1]]', 'g: [connection X28/g =>[signal: a_110_47# w=1]]', 's: [connection X28/s =>[signal: X w=1]]', 'b: [connection X28/b =>[signal: VPB w=1]]']]
X_clkbuf_1_0__f_scan_clk_28 VPWR clkbuf_1_0__f_scan_clk_a_110_47# clkbuf_1_0__f_scan_clk:X no_conn_159 sky130_fd_pr__pfet_01v8_hvt w=1e+06u l=150000u
** [instance X29 of sky130_fd_pr__nfet_01v8, params={'w': '420000u', 'l': '150000u'} connections=['d: [connection X29/d =>[signal: VGND w=1]]', 'g: [connection X29/g =>[signal: a_110_47# w=1]]', 's: [connection X29/s =>[signal: X w=1]]', 'b: [connection X29/b =>[signal: VNB w=1]]']]
X_clkbuf_1_0__f_scan_clk_29 VGND clkbuf_1_0__f_scan_clk_a_110_47# clkbuf_1_0__f_scan_clk:X no_conn_158 sky130_fd_pr__nfet_01v8 w=420000u l=150000u
** [instance X30 of sky130_fd_pr__nfet_01v8, params={'w': '420000u', 'l': '150000u'} connections=['d: [connection X30/d =>[signal: X w=1]]', 'g: [connection X30/g =>[signal: a_110_47# w=1]]', 's: [connection X30/s =>[signal: VGND w=1]]', 'b: [connection X30/b =>[signal: VNB w=1]]']]
X_clkbuf_1_0__f_scan_clk_30 clkbuf_1_0__f_scan_clk:X clkbuf_1_0__f_scan_clk_a_110_47# VGND no_conn_158 sky130_fd_pr__nfet_01v8 w=420000u l=150000u
** [instance X31 of sky130_fd_pr__pfet_01v8_hvt, params={'w': '1e+06u', 'l': '150000u'} connections=['d: [connection X31/d =>[signal: X w=1]]', 'g: [connection X31/g =>[signal: a_110_47# w=1]]', 's: [connection X31/s =>[signal: VPWR w=1]]', 'b: [connection X31/b =>[signal: VPB w=1]]']]
X_clkbuf_1_0__f_scan_clk_31 clkbuf_1_0__f_scan_clk:X clkbuf_1_0__f_scan_clk_a_110_47# VPWR no_conn_159 sky130_fd_pr__pfet_01v8_hvt w=1e+06u l=150000u
** [instance X32 of sky130_fd_pr__pfet_01v8_hvt, params={'w': '1e+06u', 'l': '150000u'} connections=['d: [connection X32/d =>[signal: X w=1]]', 'g: [connection X32/g =>[signal: a_110_47# w=1]]', 's: [connection X32/s =>[signal: VPWR w=1]]', 'b: [connection X32/b =>[signal: VPB w=1]]']]
X_clkbuf_1_0__f_scan_clk_32 clkbuf_1_0__f_scan_clk:X clkbuf_1_0__f_scan_clk_a_110_47# VPWR no_conn_159 sky130_fd_pr__pfet_01v8_hvt w=1e+06u l=150000u
** [instance X33 of sky130_fd_pr__pfet_01v8_hvt, params={'w': '1e+06u', 'l': '150000u'} connections=['d: [connection X33/d =>[signal: X w=1]]', 'g: [connection X33/g =>[signal: a_110_47# w=1]]', 's: [connection X33/s =>[signal: VPWR w=1]]', 'b: [connection X33/b =>[signal: VPB w=1]]']]
X_clkbuf_1_0__f_scan_clk_33 clkbuf_1_0__f_scan_clk:X clkbuf_1_0__f_scan_clk_a_110_47# VPWR no_conn_159 sky130_fd_pr__pfet_01v8_hvt w=1e+06u l=150000u
** [instance X34 of sky130_fd_pr__nfet_01v8, params={'w': '420000u', 'l': '150000u'} connections=['d: [connection X34/d =>[signal: a_110_47# w=1]]', 'g: [connection X34/g =>[signal: A w=1]]', 's: [connection X34/s =>[signal: VGND w=1]]', 'b: [connection X34/b =>[signal: VNB w=1]]']]
X_clkbuf_1_0__f_scan_clk_34 clkbuf_1_0__f_scan_clk_a_110_47# clkbuf_1_0__f_scan_clk:A VGND no_conn_158 sky130_fd_pr__nfet_01v8 w=420000u l=150000u
** [instance X35 of sky130_fd_pr__pfet_01v8_hvt, params={'w': '1e+06u', 'l': '150000u'} connections=['d: [connection X35/d =>[signal: VPWR w=1]]', 'g: [connection X35/g =>[signal: a_110_47# w=1]]', 's: [connection X35/s =>[signal: X w=1]]', 'b: [connection X35/b =>[signal: VPB w=1]]']]
X_clkbuf_1_0__f_scan_clk_35 VPWR clkbuf_1_0__f_scan_clk_a_110_47# clkbuf_1_0__f_scan_clk:X no_conn_159 sky130_fd_pr__pfet_01v8_hvt w=1e+06u l=150000u
** [instance X36 of sky130_fd_pr__nfet_01v8, params={'w': '420000u', 'l': '150000u'} connections=['d: [connection X36/d =>[signal: VGND w=1]]', 'g: [connection X36/g =>[signal: A w=1]]', 's: [connection X36/s =>[signal: a_110_47# w=1]]', 'b: [connection X36/b =>[signal: VNB w=1]]']]
X_clkbuf_1_0__f_scan_clk_36 VGND clkbuf_1_0__f_scan_clk:A clkbuf_1_0__f_scan_clk_a_110_47# no_conn_158 sky130_fd_pr__nfet_01v8 w=420000u l=150000u
** [instance X37 of sky130_fd_pr__pfet_01v8_hvt, params={'w': '1e+06u', 'l': '150000u'} connections=['d: [connection X37/d =>[signal: VPWR w=1]]', 'g: [connection X37/g =>[signal: a_110_47# w=1]]', 's: [connection X37/s =>[signal: X w=1]]', 'b: [connection X37/b =>[signal: VPB w=1]]']]
X_clkbuf_1_0__f_scan_clk_37 VPWR clkbuf_1_0__f_scan_clk_a_110_47# clkbuf_1_0__f_scan_clk:X no_conn_159 sky130_fd_pr__pfet_01v8_hvt w=1e+06u l=150000u
** [instance X38 of sky130_fd_pr__nfet_01v8, params={'w': '420000u', 'l': '150000u'} connections=['d: [connection X38/d =>[signal: VGND w=1]]', 'g: [connection X38/g =>[signal: a_110_47# w=1]]', 's: [connection X38/s =>[signal: X w=1]]', 'b: [connection X38/b =>[signal: VNB w=1]]']]
X_clkbuf_1_0__f_scan_clk_38 VGND clkbuf_1_0__f_scan_clk_a_110_47# clkbuf_1_0__f_scan_clk:X no_conn_158 sky130_fd_pr__nfet_01v8 w=420000u l=150000u
** [instance X39 of sky130_fd_pr__nfet_01v8, params={'w': '420000u', 'l': '150000u'} connections=['d: [connection X39/d =>[signal: VGND w=1]]', 'g: [connection X39/g =>[signal: a_110_47# w=1]]', 's: [connection X39/s =>[signal: X w=1]]', 'b: [connection X39/b =>[signal: VNB w=1]]']]
X_clkbuf_1_0__f_scan_clk_39 VGND clkbuf_1_0__f_scan_clk_a_110_47# clkbuf_1_0__f_scan_clk:X no_conn_158 sky130_fd_pr__nfet_01v8 w=420000u l=150000u

** replacing _75_ with the contents of sky130_fd_sc_hd__dfxtp_2
** [instance X0 of sky130_fd_pr__pfet_01v8_hvt, params={'w': '420000u', 'l': '150000u'} connections=['d: [connection X0/d =>[signal: a_891_413# w=1]]', 'g: [connection X0/g =>[signal: a_193_47# w=1]]', 's: [connection X0/s =>[signal: a_975_413# w=1]]', 'b: [connection X0/b =>[signal: VPB w=1]]']]
X__75__0 _75__a_891_413# _75__a_193_47# _75__a_975_413# no_conn_161 sky130_fd_pr__pfet_01v8_hvt w=420000u l=150000u
** [instance X1 of sky130_fd_pr__nfet_01v8, params={'w': '650000u', 'l': '150000u'} connections=['d: [connection X1/d =>[signal: a_1059_315# w=1]]', 'g: [connection X1/g =>[signal: a_891_413# w=1]]', 's: [connection X1/s =>[signal: VGND w=1]]', 'b: [connection X1/b =>[signal: VNB w=1]]']]
X__75__1 _75__a_1059_315# _75__a_891_413# VGND no_conn_160 sky130_fd_pr__nfet_01v8 w=650000u l=150000u
** [instance X2 of sky130_fd_pr__pfet_01v8_hvt, params={'w': '420000u', 'l': '150000u'} connections=['d: [connection X2/d =>[signal: a_466_413# w=1]]', 'g: [connection X2/g =>[signal: a_27_47# w=1]]', 's: [connection X2/s =>[signal: a_561_413# w=1]]', 'b: [connection X2/b =>[signal: VPB w=1]]']]
X__75__2 _75__a_466_413# _75__a_27_47# _75__a_561_413# no_conn_161 sky130_fd_pr__pfet_01v8_hvt w=420000u l=150000u
** [instance X3 of sky130_fd_pr__pfet_01v8_hvt, params={'w': '420000u', 'l': '150000u'} connections=['d: [connection X3/d =>[signal: a_634_159# w=1]]', 'g: [connection X3/g =>[signal: a_27_47# w=1]]', 's: [connection X3/s =>[signal: a_891_413# w=1]]', 'b: [connection X3/b =>[signal: VPB w=1]]']]
X__75__3 _75__a_634_159# _75__a_27_47# _75__a_891_413# no_conn_161 sky130_fd_pr__pfet_01v8_hvt w=420000u l=150000u
** [instance X4 of sky130_fd_pr__pfet_01v8_hvt, params={'w': '420000u', 'l': '150000u'} connections=['d: [connection X4/d =>[signal: a_381_47# w=1]]', 'g: [connection X4/g =>[signal: a_193_47# w=1]]', 's: [connection X4/s =>[signal: a_466_413# w=1]]', 'b: [connection X4/b =>[signal: VPB w=1]]']]
X__75__4 _75__a_381_47# _75__a_193_47# _75__a_466_413# no_conn_161 sky130_fd_pr__pfet_01v8_hvt w=420000u l=150000u
** [instance X5 of sky130_fd_pr__pfet_01v8_hvt, params={'w': '420000u', 'l': '150000u'} connections=['d: [connection X5/d =>[signal: VPWR w=1]]', 'g: [connection X5/g =>[signal: D w=1]]', 's: [connection X5/s =>[signal: a_381_47# w=1]]', 'b: [connection X5/b =>[signal: VPB w=1]]']]
X__75__5 VPWR _75_:D _75__a_381_47# no_conn_161 sky130_fd_pr__pfet_01v8_hvt w=420000u l=150000u
** [instance X6 of sky130_fd_pr__pfet_01v8_hvt, params={'w': '750000u', 'l': '150000u'} connections=['d: [connection X6/d =>[signal: VPWR w=1]]', 'g: [connection X6/g =>[signal: a_466_413# w=1]]', 's: [connection X6/s =>[signal: a_634_159# w=1]]', 'b: [connection X6/b =>[signal: VPB w=1]]']]
X__75__6 VPWR _75__a_466_413# _75__a_634_159# no_conn_161 sky130_fd_pr__pfet_01v8_hvt w=750000u l=150000u
** [instance X7 of sky130_fd_pr__nfet_01v8, params={'w': '640000u', 'l': '150000u'} connections=['d: [connection X7/d =>[signal: VGND w=1]]', 'g: [connection X7/g =>[signal: a_466_413# w=1]]', 's: [connection X7/s =>[signal: a_634_159# w=1]]', 'b: [connection X7/b =>[signal: VNB w=1]]']]
X__75__7 VGND _75__a_466_413# _75__a_634_159# no_conn_160 sky130_fd_pr__nfet_01v8 w=640000u l=150000u
** [instance X8 of sky130_fd_pr__nfet_01v8, params={'w': '420000u', 'l': '150000u'} connections=['d: [connection X8/d =>[signal: a_1017_47# w=1]]', 'g: [connection X8/g =>[signal: a_1059_315# w=1]]', 's: [connection X8/s =>[signal: VGND w=1]]', 'b: [connection X8/b =>[signal: VNB w=1]]']]
X__75__8 _75__a_1017_47# _75__a_1059_315# VGND no_conn_160 sky130_fd_pr__nfet_01v8 w=420000u l=150000u
** [instance X9 of sky130_fd_pr__pfet_01v8_hvt, params={'w': '1e+06u', 'l': '150000u'} connections=['d: [connection X9/d =>[signal: a_1059_315# w=1]]', 'g: [connection X9/g =>[signal: a_891_413# w=1]]', 's: [connection X9/s =>[signal: VPWR w=1]]', 'b: [connection X9/b =>[signal: VPB w=1]]']]
X__75__9 _75__a_1059_315# _75__a_891_413# VPWR no_conn_161 sky130_fd_pr__pfet_01v8_hvt w=1e+06u l=150000u
** [instance X10 of sky130_fd_pr__pfet_01v8_hvt, params={'w': '1e+06u', 'l': '150000u'} connections=['d: [connection X10/d =>[signal: Q w=1]]', 'g: [connection X10/g =>[signal: a_1059_315# w=1]]', 's: [connection X10/s =>[signal: VPWR w=1]]', 'b: [connection X10/b =>[signal: VPB w=1]]']]
X__75__10 _75_:Q _75__a_1059_315# VPWR no_conn_161 sky130_fd_pr__pfet_01v8_hvt w=1e+06u l=150000u
** [instance X11 of sky130_fd_pr__pfet_01v8_hvt, params={'w': '420000u', 'l': '150000u'} connections=['d: [connection X11/d =>[signal: a_561_413# w=1]]', 'g: [connection X11/g =>[signal: a_634_159# w=1]]', 's: [connection X11/s =>[signal: VPWR w=1]]', 'b: [connection X11/b =>[signal: VPB w=1]]']]
X__75__11 _75__a_561_413# _75__a_634_159# VPWR no_conn_161 sky130_fd_pr__pfet_01v8_hvt w=420000u l=150000u
** [instance X12 of sky130_fd_pr__pfet_01v8_hvt, params={'w': '1e+06u', 'l': '150000u'} connections=['d: [connection X12/d =>[signal: VPWR w=1]]', 'g: [connection X12/g =>[signal: a_1059_315# w=1]]', 's: [connection X12/s =>[signal: Q w=1]]', 'b: [connection X12/b =>[signal: VPB w=1]]']]
X__75__12 VPWR _75__a_1059_315# _75_:Q no_conn_161 sky130_fd_pr__pfet_01v8_hvt w=1e+06u l=150000u
** [instance X13 of sky130_fd_pr__nfet_01v8, params={'w': '360000u', 'l': '150000u'} connections=['d: [connection X13/d =>[signal: a_891_413# w=1]]', 'g: [connection X13/g =>[signal: a_27_47# w=1]]', 's: [connection X13/s =>[signal: a_1017_47# w=1]]', 'b: [connection X13/b =>[signal: VNB w=1]]']]
X__75__13 _75__a_891_413# _75__a_27_47# _75__a_1017_47# no_conn_160 sky130_fd_pr__nfet_01v8 w=360000u l=150000u
** [instance X14 of sky130_fd_pr__nfet_01v8, params={'w': '360000u', 'l': '150000u'} connections=['d: [connection X14/d =>[signal: a_634_159# w=1]]', 'g: [connection X14/g =>[signal: a_193_47# w=1]]', 's: [connection X14/s =>[signal: a_891_413# w=1]]', 'b: [connection X14/b =>[signal: VNB w=1]]']]
X__75__14 _75__a_634_159# _75__a_193_47# _75__a_891_413# no_conn_160 sky130_fd_pr__nfet_01v8 w=360000u l=150000u
** [instance X15 of sky130_fd_pr__nfet_01v8, params={'w': '420000u', 'l': '150000u'} connections=['d: [connection X15/d =>[signal: a_592_47# w=1]]', 'g: [connection X15/g =>[signal: a_634_159# w=1]]', 's: [connection X15/s =>[signal: VGND w=1]]', 'b: [connection X15/b =>[signal: VNB w=1]]']]
X__75__15 _75__a_592_47# _75__a_634_159# VGND no_conn_160 sky130_fd_pr__nfet_01v8 w=420000u l=150000u
** [instance X16 of sky130_fd_pr__nfet_01v8, params={'w': '360000u', 'l': '150000u'} connections=['d: [connection X16/d =>[signal: a_466_413# w=1]]', 'g: [connection X16/g =>[signal: a_193_47# w=1]]', 's: [connection X16/s =>[signal: a_592_47# w=1]]', 'b: [connection X16/b =>[signal: VNB w=1]]']]
X__75__16 _75__a_466_413# _75__a_193_47# _75__a_592_47# no_conn_160 sky130_fd_pr__nfet_01v8 w=360000u l=150000u
** [instance X17 of sky130_fd_pr__nfet_01v8, params={'w': '420000u', 'l': '150000u'} connections=['d: [connection X17/d =>[signal: VGND w=1]]', 'g: [connection X17/g =>[signal: a_27_47# w=1]]', 's: [connection X17/s =>[signal: a_193_47# w=1]]', 'b: [connection X17/b =>[signal: VNB w=1]]']]
X__75__17 VGND _75__a_27_47# _75__a_193_47# no_conn_160 sky130_fd_pr__nfet_01v8 w=420000u l=150000u
** [instance X18 of sky130_fd_pr__nfet_01v8, params={'w': '360000u', 'l': '150000u'} connections=['d: [connection X18/d =>[signal: a_381_47# w=1]]', 'g: [connection X18/g =>[signal: a_27_47# w=1]]', 's: [connection X18/s =>[signal: a_466_413# w=1]]', 'b: [connection X18/b =>[signal: VNB w=1]]']]
X__75__18 _75__a_381_47# _75__a_27_47# _75__a_466_413# no_conn_160 sky130_fd_pr__nfet_01v8 w=360000u l=150000u
** [instance X19 of sky130_fd_pr__nfet_01v8, params={'w': '420000u', 'l': '150000u'} connections=['d: [connection X19/d =>[signal: a_27_47# w=1]]', 'g: [connection X19/g =>[signal: CLK w=1]]', 's: [connection X19/s =>[signal: VGND w=1]]', 'b: [connection X19/b =>[signal: VNB w=1]]']]
X__75__19 _75__a_27_47# _75_:CLK VGND no_conn_160 sky130_fd_pr__nfet_01v8 w=420000u l=150000u
** [instance X20 of sky130_fd_pr__pfet_01v8_hvt, params={'w': '640000u', 'l': '150000u'} connections=['d: [connection X20/d =>[signal: a_27_47# w=1]]', 'g: [connection X20/g =>[signal: CLK w=1]]', 's: [connection X20/s =>[signal: VPWR w=1]]', 'b: [connection X20/b =>[signal: VPB w=1]]']]
X__75__20 _75__a_27_47# _75_:CLK VPWR no_conn_161 sky130_fd_pr__pfet_01v8_hvt w=640000u l=150000u
** [instance X21 of sky130_fd_pr__nfet_01v8, params={'w': '650000u', 'l': '150000u'} connections=['d: [connection X21/d =>[signal: Q w=1]]', 'g: [connection X21/g =>[signal: a_1059_315# w=1]]', 's: [connection X21/s =>[signal: VGND w=1]]', 'b: [connection X21/b =>[signal: VNB w=1]]']]
X__75__21 _75_:Q _75__a_1059_315# VGND no_conn_160 sky130_fd_pr__nfet_01v8 w=650000u l=150000u
** [instance X22 of sky130_fd_pr__pfet_01v8_hvt, params={'w': '640000u', 'l': '150000u'} connections=['d: [connection X22/d =>[signal: VPWR w=1]]', 'g: [connection X22/g =>[signal: a_27_47# w=1]]', 's: [connection X22/s =>[signal: a_193_47# w=1]]', 'b: [connection X22/b =>[signal: VPB w=1]]']]
X__75__22 VPWR _75__a_27_47# _75__a_193_47# no_conn_161 sky130_fd_pr__pfet_01v8_hvt w=640000u l=150000u
** [instance X23 of sky130_fd_pr__nfet_01v8, params={'w': '420000u', 'l': '150000u'} connections=['d: [connection X23/d =>[signal: VGND w=1]]', 'g: [connection X23/g =>[signal: D w=1]]', 's: [connection X23/s =>[signal: a_381_47# w=1]]', 'b: [connection X23/b =>[signal: VNB w=1]]']]
X__75__23 VGND _75_:D _75__a_381_47# no_conn_160 sky130_fd_pr__nfet_01v8 w=420000u l=150000u
** [instance X24 of sky130_fd_pr__pfet_01v8_hvt, params={'w': '420000u', 'l': '150000u'} connections=['d: [connection X24/d =>[signal: a_975_413# w=1]]', 'g: [connection X24/g =>[signal: a_1059_315# w=1]]', 's: [connection X24/s =>[signal: VPWR w=1]]', 'b: [connection X24/b =>[signal: VPB w=1]]']]
X__75__24 _75__a_975_413# _75__a_1059_315# VPWR no_conn_161 sky130_fd_pr__pfet_01v8_hvt w=420000u l=150000u
** [instance X25 of sky130_fd_pr__nfet_01v8, params={'w': '650000u', 'l': '150000u'} connections=['d: [connection X25/d =>[signal: VGND w=1]]', 'g: [connection X25/g =>[signal: a_1059_315# w=1]]', 's: [connection X25/s =>[signal: Q w=1]]', 'b: [connection X25/b =>[signal: VNB w=1]]']]
X__75__25 VGND _75__a_1059_315# _75_:Q no_conn_160 sky130_fd_pr__nfet_01v8 w=650000u l=150000u

** replacing hold14 with the contents of sky130_fd_sc_hd__dlygate4sd3_1
** [instance X0 of sky130_fd_pr__nfet_01v8, params={'w': '420000u', 'l': '500000u'} connections=['d: [connection X0/d =>[signal: a_391_47# w=1]]', 'g: [connection X0/g =>[signal: a_285_47# w=1]]', 's: [connection X0/s =>[signal: VGND w=1]]', 'b: [connection X0/b =>[signal: VNB w=1]]']]
X_hold14_0 hold14_a_391_47# hold14_a_285_47# VGND no_conn_162 sky130_fd_pr__nfet_01v8 w=420000u l=500000u
** [instance X1 of sky130_fd_pr__pfet_01v8_hvt, params={'w': '420000u', 'l': '500000u'} connections=['d: [connection X1/d =>[signal: VPWR w=1]]', 'g: [connection X1/g =>[signal: a_49_47# w=1]]', 's: [connection X1/s =>[signal: a_285_47# w=1]]', 'b: [connection X1/b =>[signal: VPB w=1]]']]
X_hold14_1 VPWR hold14_a_49_47# hold14_a_285_47# no_conn_163 sky130_fd_pr__pfet_01v8_hvt w=420000u l=500000u
** [instance X2 of sky130_fd_pr__nfet_01v8, params={'w': '420000u', 'l': '150000u'} connections=['d: [connection X2/d =>[signal: a_49_47# w=1]]', 'g: [connection X2/g =>[signal: A w=1]]', 's: [connection X2/s =>[signal: VGND w=1]]', 'b: [connection X2/b =>[signal: VNB w=1]]']]
X_hold14_2 hold14_a_49_47# hold14:A VGND no_conn_162 sky130_fd_pr__nfet_01v8 w=420000u l=150000u
** [instance X3 of sky130_fd_pr__pfet_01v8_hvt, params={'w': '1e+06u', 'l': '150000u'} connections=['d: [connection X3/d =>[signal: VPWR w=1]]', 'g: [connection X3/g =>[signal: a_391_47# w=1]]', 's: [connection X3/s =>[signal: X w=1]]', 'b: [connection X3/b =>[signal: VPB w=1]]']]
X_hold14_3 VPWR hold14_a_391_47# hold14:X no_conn_163 sky130_fd_pr__pfet_01v8_hvt w=1e+06u l=150000u
** [instance X4 of sky130_fd_pr__nfet_01v8, params={'w': '650000u', 'l': '150000u'} connections=['d: [connection X4/d =>[signal: VGND w=1]]', 'g: [connection X4/g =>[signal: a_391_47# w=1]]', 's: [connection X4/s =>[signal: X w=1]]', 'b: [connection X4/b =>[signal: VNB w=1]]']]
X_hold14_4 VGND hold14_a_391_47# hold14:X no_conn_162 sky130_fd_pr__nfet_01v8 w=650000u l=150000u
** [instance X5 of sky130_fd_pr__nfet_01v8, params={'w': '420000u', 'l': '500000u'} connections=['d: [connection X5/d =>[signal: VGND w=1]]', 'g: [connection X5/g =>[signal: a_49_47# w=1]]', 's: [connection X5/s =>[signal: a_285_47# w=1]]', 'b: [connection X5/b =>[signal: VNB w=1]]']]
X_hold14_5 VGND hold14_a_49_47# hold14_a_285_47# no_conn_162 sky130_fd_pr__nfet_01v8 w=420000u l=500000u
** [instance X6 of sky130_fd_pr__pfet_01v8_hvt, params={'w': '420000u', 'l': '500000u'} connections=['d: [connection X6/d =>[signal: a_391_47# w=1]]', 'g: [connection X6/g =>[signal: a_285_47# w=1]]', 's: [connection X6/s =>[signal: VPWR w=1]]', 'b: [connection X6/b =>[signal: VPB w=1]]']]
X_hold14_6 hold14_a_391_47# hold14_a_285_47# VPWR no_conn_163 sky130_fd_pr__pfet_01v8_hvt w=420000u l=500000u
** [instance X7 of sky130_fd_pr__pfet_01v8_hvt, params={'w': '420000u', 'l': '150000u'} connections=['d: [connection X7/d =>[signal: a_49_47# w=1]]', 'g: [connection X7/g =>[signal: A w=1]]', 's: [connection X7/s =>[signal: VPWR w=1]]', 'b: [connection X7/b =>[signal: VPB w=1]]']]
X_hold14_7 hold14_a_49_47# hold14:A VPWR no_conn_163 sky130_fd_pr__pfet_01v8_hvt w=420000u l=150000u

** replacing hold26 with the contents of sky130_fd_sc_hd__dlygate4sd3_1
** [instance X0 of sky130_fd_pr__nfet_01v8, params={'w': '420000u', 'l': '500000u'} connections=['d: [connection X0/d =>[signal: a_391_47# w=1]]', 'g: [connection X0/g =>[signal: a_285_47# w=1]]', 's: [connection X0/s =>[signal: VGND w=1]]', 'b: [connection X0/b =>[signal: VNB w=1]]']]
X_hold26_0 hold26_a_391_47# hold26_a_285_47# VGND no_conn_164 sky130_fd_pr__nfet_01v8 w=420000u l=500000u
** [instance X1 of sky130_fd_pr__pfet_01v8_hvt, params={'w': '420000u', 'l': '500000u'} connections=['d: [connection X1/d =>[signal: VPWR w=1]]', 'g: [connection X1/g =>[signal: a_49_47# w=1]]', 's: [connection X1/s =>[signal: a_285_47# w=1]]', 'b: [connection X1/b =>[signal: VPB w=1]]']]
X_hold26_1 VPWR hold26_a_49_47# hold26_a_285_47# no_conn_165 sky130_fd_pr__pfet_01v8_hvt w=420000u l=500000u
** [instance X2 of sky130_fd_pr__nfet_01v8, params={'w': '420000u', 'l': '150000u'} connections=['d: [connection X2/d =>[signal: a_49_47# w=1]]', 'g: [connection X2/g =>[signal: A w=1]]', 's: [connection X2/s =>[signal: VGND w=1]]', 'b: [connection X2/b =>[signal: VNB w=1]]']]
X_hold26_2 hold26_a_49_47# hold26:A VGND no_conn_164 sky130_fd_pr__nfet_01v8 w=420000u l=150000u
** [instance X3 of sky130_fd_pr__pfet_01v8_hvt, params={'w': '1e+06u', 'l': '150000u'} connections=['d: [connection X3/d =>[signal: VPWR w=1]]', 'g: [connection X3/g =>[signal: a_391_47# w=1]]', 's: [connection X3/s =>[signal: X w=1]]', 'b: [connection X3/b =>[signal: VPB w=1]]']]
X_hold26_3 VPWR hold26_a_391_47# hold26:X no_conn_165 sky130_fd_pr__pfet_01v8_hvt w=1e+06u l=150000u
** [instance X4 of sky130_fd_pr__nfet_01v8, params={'w': '650000u', 'l': '150000u'} connections=['d: [connection X4/d =>[signal: VGND w=1]]', 'g: [connection X4/g =>[signal: a_391_47# w=1]]', 's: [connection X4/s =>[signal: X w=1]]', 'b: [connection X4/b =>[signal: VNB w=1]]']]
X_hold26_4 VGND hold26_a_391_47# hold26:X no_conn_164 sky130_fd_pr__nfet_01v8 w=650000u l=150000u
** [instance X5 of sky130_fd_pr__nfet_01v8, params={'w': '420000u', 'l': '500000u'} connections=['d: [connection X5/d =>[signal: VGND w=1]]', 'g: [connection X5/g =>[signal: a_49_47# w=1]]', 's: [connection X5/s =>[signal: a_285_47# w=1]]', 'b: [connection X5/b =>[signal: VNB w=1]]']]
X_hold26_5 VGND hold26_a_49_47# hold26_a_285_47# no_conn_164 sky130_fd_pr__nfet_01v8 w=420000u l=500000u
** [instance X6 of sky130_fd_pr__pfet_01v8_hvt, params={'w': '420000u', 'l': '500000u'} connections=['d: [connection X6/d =>[signal: a_391_47# w=1]]', 'g: [connection X6/g =>[signal: a_285_47# w=1]]', 's: [connection X6/s =>[signal: VPWR w=1]]', 'b: [connection X6/b =>[signal: VPB w=1]]']]
X_hold26_6 hold26_a_391_47# hold26_a_285_47# VPWR no_conn_165 sky130_fd_pr__pfet_01v8_hvt w=420000u l=500000u
** [instance X7 of sky130_fd_pr__pfet_01v8_hvt, params={'w': '420000u', 'l': '150000u'} connections=['d: [connection X7/d =>[signal: a_49_47# w=1]]', 'g: [connection X7/g =>[signal: A w=1]]', 's: [connection X7/s =>[signal: VPWR w=1]]', 'b: [connection X7/b =>[signal: VPB w=1]]']]
X_hold26_7 hold26_a_49_47# hold26:A VPWR no_conn_165 sky130_fd_pr__pfet_01v8_hvt w=420000u l=150000u

** replacing hold30 with the contents of sky130_fd_sc_hd__dlygate4sd3_1
** [instance X0 of sky130_fd_pr__nfet_01v8, params={'w': '420000u', 'l': '500000u'} connections=['d: [connection X0/d =>[signal: a_391_47# w=1]]', 'g: [connection X0/g =>[signal: a_285_47# w=1]]', 's: [connection X0/s =>[signal: VGND w=1]]', 'b: [connection X0/b =>[signal: VNB w=1]]']]
X_hold30_0 hold30_a_391_47# hold30_a_285_47# VGND no_conn_166 sky130_fd_pr__nfet_01v8 w=420000u l=500000u
** [instance X1 of sky130_fd_pr__pfet_01v8_hvt, params={'w': '420000u', 'l': '500000u'} connections=['d: [connection X1/d =>[signal: VPWR w=1]]', 'g: [connection X1/g =>[signal: a_49_47# w=1]]', 's: [connection X1/s =>[signal: a_285_47# w=1]]', 'b: [connection X1/b =>[signal: VPB w=1]]']]
X_hold30_1 VPWR hold30_a_49_47# hold30_a_285_47# no_conn_167 sky130_fd_pr__pfet_01v8_hvt w=420000u l=500000u
** [instance X2 of sky130_fd_pr__nfet_01v8, params={'w': '420000u', 'l': '150000u'} connections=['d: [connection X2/d =>[signal: a_49_47# w=1]]', 'g: [connection X2/g =>[signal: A w=1]]', 's: [connection X2/s =>[signal: VGND w=1]]', 'b: [connection X2/b =>[signal: VNB w=1]]']]
X_hold30_2 hold30_a_49_47# hold30:A VGND no_conn_166 sky130_fd_pr__nfet_01v8 w=420000u l=150000u
** [instance X3 of sky130_fd_pr__pfet_01v8_hvt, params={'w': '1e+06u', 'l': '150000u'} connections=['d: [connection X3/d =>[signal: VPWR w=1]]', 'g: [connection X3/g =>[signal: a_391_47# w=1]]', 's: [connection X3/s =>[signal: X w=1]]', 'b: [connection X3/b =>[signal: VPB w=1]]']]
X_hold30_3 VPWR hold30_a_391_47# hold30:X no_conn_167 sky130_fd_pr__pfet_01v8_hvt w=1e+06u l=150000u
** [instance X4 of sky130_fd_pr__nfet_01v8, params={'w': '650000u', 'l': '150000u'} connections=['d: [connection X4/d =>[signal: VGND w=1]]', 'g: [connection X4/g =>[signal: a_391_47# w=1]]', 's: [connection X4/s =>[signal: X w=1]]', 'b: [connection X4/b =>[signal: VNB w=1]]']]
X_hold30_4 VGND hold30_a_391_47# hold30:X no_conn_166 sky130_fd_pr__nfet_01v8 w=650000u l=150000u
** [instance X5 of sky130_fd_pr__nfet_01v8, params={'w': '420000u', 'l': '500000u'} connections=['d: [connection X5/d =>[signal: VGND w=1]]', 'g: [connection X5/g =>[signal: a_49_47# w=1]]', 's: [connection X5/s =>[signal: a_285_47# w=1]]', 'b: [connection X5/b =>[signal: VNB w=1]]']]
X_hold30_5 VGND hold30_a_49_47# hold30_a_285_47# no_conn_166 sky130_fd_pr__nfet_01v8 w=420000u l=500000u
** [instance X6 of sky130_fd_pr__pfet_01v8_hvt, params={'w': '420000u', 'l': '500000u'} connections=['d: [connection X6/d =>[signal: a_391_47# w=1]]', 'g: [connection X6/g =>[signal: a_285_47# w=1]]', 's: [connection X6/s =>[signal: VPWR w=1]]', 'b: [connection X6/b =>[signal: VPB w=1]]']]
X_hold30_6 hold30_a_391_47# hold30_a_285_47# VPWR no_conn_167 sky130_fd_pr__pfet_01v8_hvt w=420000u l=500000u
** [instance X7 of sky130_fd_pr__pfet_01v8_hvt, params={'w': '420000u', 'l': '150000u'} connections=['d: [connection X7/d =>[signal: a_49_47# w=1]]', 'g: [connection X7/g =>[signal: A w=1]]', 's: [connection X7/s =>[signal: VPWR w=1]]', 'b: [connection X7/b =>[signal: VPB w=1]]']]
X_hold30_7 hold30_a_49_47# hold30:A VPWR no_conn_167 sky130_fd_pr__pfet_01v8_hvt w=420000u l=150000u

** replacing hold36 with the contents of sky130_fd_sc_hd__dlygate4sd3_1
** [instance X0 of sky130_fd_pr__nfet_01v8, params={'w': '420000u', 'l': '500000u'} connections=['d: [connection X0/d =>[signal: a_391_47# w=1]]', 'g: [connection X0/g =>[signal: a_285_47# w=1]]', 's: [connection X0/s =>[signal: VGND w=1]]', 'b: [connection X0/b =>[signal: VNB w=1]]']]
X_hold36_0 hold36_a_391_47# hold36_a_285_47# VGND no_conn_168 sky130_fd_pr__nfet_01v8 w=420000u l=500000u
** [instance X1 of sky130_fd_pr__pfet_01v8_hvt, params={'w': '420000u', 'l': '500000u'} connections=['d: [connection X1/d =>[signal: VPWR w=1]]', 'g: [connection X1/g =>[signal: a_49_47# w=1]]', 's: [connection X1/s =>[signal: a_285_47# w=1]]', 'b: [connection X1/b =>[signal: VPB w=1]]']]
X_hold36_1 VPWR hold36_a_49_47# hold36_a_285_47# no_conn_169 sky130_fd_pr__pfet_01v8_hvt w=420000u l=500000u
** [instance X2 of sky130_fd_pr__nfet_01v8, params={'w': '420000u', 'l': '150000u'} connections=['d: [connection X2/d =>[signal: a_49_47# w=1]]', 'g: [connection X2/g =>[signal: A w=1]]', 's: [connection X2/s =>[signal: VGND w=1]]', 'b: [connection X2/b =>[signal: VNB w=1]]']]
X_hold36_2 hold36_a_49_47# hold36:A VGND no_conn_168 sky130_fd_pr__nfet_01v8 w=420000u l=150000u
** [instance X3 of sky130_fd_pr__pfet_01v8_hvt, params={'w': '1e+06u', 'l': '150000u'} connections=['d: [connection X3/d =>[signal: VPWR w=1]]', 'g: [connection X3/g =>[signal: a_391_47# w=1]]', 's: [connection X3/s =>[signal: X w=1]]', 'b: [connection X3/b =>[signal: VPB w=1]]']]
X_hold36_3 VPWR hold36_a_391_47# hold36:X no_conn_169 sky130_fd_pr__pfet_01v8_hvt w=1e+06u l=150000u
** [instance X4 of sky130_fd_pr__nfet_01v8, params={'w': '650000u', 'l': '150000u'} connections=['d: [connection X4/d =>[signal: VGND w=1]]', 'g: [connection X4/g =>[signal: a_391_47# w=1]]', 's: [connection X4/s =>[signal: X w=1]]', 'b: [connection X4/b =>[signal: VNB w=1]]']]
X_hold36_4 VGND hold36_a_391_47# hold36:X no_conn_168 sky130_fd_pr__nfet_01v8 w=650000u l=150000u
** [instance X5 of sky130_fd_pr__nfet_01v8, params={'w': '420000u', 'l': '500000u'} connections=['d: [connection X5/d =>[signal: VGND w=1]]', 'g: [connection X5/g =>[signal: a_49_47# w=1]]', 's: [connection X5/s =>[signal: a_285_47# w=1]]', 'b: [connection X5/b =>[signal: VNB w=1]]']]
X_hold36_5 VGND hold36_a_49_47# hold36_a_285_47# no_conn_168 sky130_fd_pr__nfet_01v8 w=420000u l=500000u
** [instance X6 of sky130_fd_pr__pfet_01v8_hvt, params={'w': '420000u', 'l': '500000u'} connections=['d: [connection X6/d =>[signal: a_391_47# w=1]]', 'g: [connection X6/g =>[signal: a_285_47# w=1]]', 's: [connection X6/s =>[signal: VPWR w=1]]', 'b: [connection X6/b =>[signal: VPB w=1]]']]
X_hold36_6 hold36_a_391_47# hold36_a_285_47# VPWR no_conn_169 sky130_fd_pr__pfet_01v8_hvt w=420000u l=500000u
** [instance X7 of sky130_fd_pr__pfet_01v8_hvt, params={'w': '420000u', 'l': '150000u'} connections=['d: [connection X7/d =>[signal: a_49_47# w=1]]', 'g: [connection X7/g =>[signal: A w=1]]', 's: [connection X7/s =>[signal: VPWR w=1]]', 'b: [connection X7/b =>[signal: VPB w=1]]']]
X_hold36_7 hold36_a_49_47# hold36:A VPWR no_conn_169 sky130_fd_pr__pfet_01v8_hvt w=420000u l=150000u

** replacing hold35 with the contents of sky130_fd_sc_hd__dlygate4sd3_1
** [instance X0 of sky130_fd_pr__nfet_01v8, params={'w': '420000u', 'l': '500000u'} connections=['d: [connection X0/d =>[signal: a_391_47# w=1]]', 'g: [connection X0/g =>[signal: a_285_47# w=1]]', 's: [connection X0/s =>[signal: VGND w=1]]', 'b: [connection X0/b =>[signal: VNB w=1]]']]
X_hold35_0 hold35_a_391_47# hold35_a_285_47# VGND no_conn_170 sky130_fd_pr__nfet_01v8 w=420000u l=500000u
** [instance X1 of sky130_fd_pr__pfet_01v8_hvt, params={'w': '420000u', 'l': '500000u'} connections=['d: [connection X1/d =>[signal: VPWR w=1]]', 'g: [connection X1/g =>[signal: a_49_47# w=1]]', 's: [connection X1/s =>[signal: a_285_47# w=1]]', 'b: [connection X1/b =>[signal: VPB w=1]]']]
X_hold35_1 VPWR hold35_a_49_47# hold35_a_285_47# no_conn_171 sky130_fd_pr__pfet_01v8_hvt w=420000u l=500000u
** [instance X2 of sky130_fd_pr__nfet_01v8, params={'w': '420000u', 'l': '150000u'} connections=['d: [connection X2/d =>[signal: a_49_47# w=1]]', 'g: [connection X2/g =>[signal: A w=1]]', 's: [connection X2/s =>[signal: VGND w=1]]', 'b: [connection X2/b =>[signal: VNB w=1]]']]
X_hold35_2 hold35_a_49_47# hold35:A VGND no_conn_170 sky130_fd_pr__nfet_01v8 w=420000u l=150000u
** [instance X3 of sky130_fd_pr__pfet_01v8_hvt, params={'w': '1e+06u', 'l': '150000u'} connections=['d: [connection X3/d =>[signal: VPWR w=1]]', 'g: [connection X3/g =>[signal: a_391_47# w=1]]', 's: [connection X3/s =>[signal: X w=1]]', 'b: [connection X3/b =>[signal: VPB w=1]]']]
X_hold35_3 VPWR hold35_a_391_47# hold35:X no_conn_171 sky130_fd_pr__pfet_01v8_hvt w=1e+06u l=150000u
** [instance X4 of sky130_fd_pr__nfet_01v8, params={'w': '650000u', 'l': '150000u'} connections=['d: [connection X4/d =>[signal: VGND w=1]]', 'g: [connection X4/g =>[signal: a_391_47# w=1]]', 's: [connection X4/s =>[signal: X w=1]]', 'b: [connection X4/b =>[signal: VNB w=1]]']]
X_hold35_4 VGND hold35_a_391_47# hold35:X no_conn_170 sky130_fd_pr__nfet_01v8 w=650000u l=150000u
** [instance X5 of sky130_fd_pr__nfet_01v8, params={'w': '420000u', 'l': '500000u'} connections=['d: [connection X5/d =>[signal: VGND w=1]]', 'g: [connection X5/g =>[signal: a_49_47# w=1]]', 's: [connection X5/s =>[signal: a_285_47# w=1]]', 'b: [connection X5/b =>[signal: VNB w=1]]']]
X_hold35_5 VGND hold35_a_49_47# hold35_a_285_47# no_conn_170 sky130_fd_pr__nfet_01v8 w=420000u l=500000u
** [instance X6 of sky130_fd_pr__pfet_01v8_hvt, params={'w': '420000u', 'l': '500000u'} connections=['d: [connection X6/d =>[signal: a_391_47# w=1]]', 'g: [connection X6/g =>[signal: a_285_47# w=1]]', 's: [connection X6/s =>[signal: VPWR w=1]]', 'b: [connection X6/b =>[signal: VPB w=1]]']]
X_hold35_6 hold35_a_391_47# hold35_a_285_47# VPWR no_conn_171 sky130_fd_pr__pfet_01v8_hvt w=420000u l=500000u
** [instance X7 of sky130_fd_pr__pfet_01v8_hvt, params={'w': '420000u', 'l': '150000u'} connections=['d: [connection X7/d =>[signal: a_49_47# w=1]]', 'g: [connection X7/g =>[signal: A w=1]]', 's: [connection X7/s =>[signal: VPWR w=1]]', 'b: [connection X7/b =>[signal: VPB w=1]]']]
X_hold35_7 hold35_a_49_47# hold35:A VPWR no_conn_171 sky130_fd_pr__pfet_01v8_hvt w=420000u l=150000u

** replacing fanout12 with the contents of sky130_fd_sc_hd__clkdlybuf4s25_1
** [instance X0 of sky130_fd_pr__pfet_01v8_hvt, params={'w': '820000u', 'l': '250000u'} connections=['d: [connection X0/d =>[signal: a_355_47# w=1]]', 'g: [connection X0/g =>[signal: a_244_47# w=1]]', 's: [connection X0/s =>[signal: VPWR w=1]]', 'b: [connection X0/b =>[signal: VPB w=1]]']]
X_fanout12_0 fanout12_a_355_47# fanout12_a_244_47# VPWR no_conn_173 sky130_fd_pr__pfet_01v8_hvt w=820000u l=250000u
** [instance X1 of sky130_fd_pr__pfet_01v8_hvt, params={'w': '820000u', 'l': '250000u'} connections=['d: [connection X1/d =>[signal: VPWR w=1]]', 'g: [connection X1/g =>[signal: a_27_47# w=1]]', 's: [connection X1/s =>[signal: a_244_47# w=1]]', 'b: [connection X1/b =>[signal: VPB w=1]]']]
X_fanout12_1 VPWR fanout12_a_27_47# fanout12_a_244_47# no_conn_173 sky130_fd_pr__pfet_01v8_hvt w=820000u l=250000u
** [instance X2 of sky130_fd_pr__pfet_01v8_hvt, params={'w': '1e+06u', 'l': '150000u'} connections=['d: [connection X2/d =>[signal: VPWR w=1]]', 'g: [connection X2/g =>[signal: a_355_47# w=1]]', 's: [connection X2/s =>[signal: X w=1]]', 'b: [connection X2/b =>[signal: VPB w=1]]']]
X_fanout12_2 VPWR fanout12_a_355_47# fanout12:X no_conn_173 sky130_fd_pr__pfet_01v8_hvt w=1e+06u l=150000u
** [instance X3 of sky130_fd_pr__pfet_01v8_hvt, params={'w': '1e+06u', 'l': '150000u'} connections=['d: [connection X3/d =>[signal: a_27_47# w=1]]', 'g: [connection X3/g =>[signal: A w=1]]', 's: [connection X3/s =>[signal: VPWR w=1]]', 'b: [connection X3/b =>[signal: VPB w=1]]']]
X_fanout12_3 fanout12_a_27_47# fanout12:A VPWR no_conn_173 sky130_fd_pr__pfet_01v8_hvt w=1e+06u l=150000u
** [instance X4 of sky130_fd_pr__nfet_01v8, params={'w': '650000u', 'l': '250000u'} connections=['d: [connection X4/d =>[signal: a_355_47# w=1]]', 'g: [connection X4/g =>[signal: a_244_47# w=1]]', 's: [connection X4/s =>[signal: VGND w=1]]', 'b: [connection X4/b =>[signal: VNB w=1]]']]
X_fanout12_4 fanout12_a_355_47# fanout12_a_244_47# VGND no_conn_172 sky130_fd_pr__nfet_01v8 w=650000u l=250000u
** [instance X5 of sky130_fd_pr__nfet_01v8, params={'w': '650000u', 'l': '250000u'} connections=['d: [connection X5/d =>[signal: VGND w=1]]', 'g: [connection X5/g =>[signal: a_27_47# w=1]]', 's: [connection X5/s =>[signal: a_244_47# w=1]]', 'b: [connection X5/b =>[signal: VNB w=1]]']]
X_fanout12_5 VGND fanout12_a_27_47# fanout12_a_244_47# no_conn_172 sky130_fd_pr__nfet_01v8 w=650000u l=250000u
** [instance X6 of sky130_fd_pr__nfet_01v8, params={'w': '420000u', 'l': '150000u'} connections=['d: [connection X6/d =>[signal: VGND w=1]]', 'g: [connection X6/g =>[signal: a_355_47# w=1]]', 's: [connection X6/s =>[signal: X w=1]]', 'b: [connection X6/b =>[signal: VNB w=1]]']]
X_fanout12_6 VGND fanout12_a_355_47# fanout12:X no_conn_172 sky130_fd_pr__nfet_01v8 w=420000u l=150000u
** [instance X7 of sky130_fd_pr__nfet_01v8, params={'w': '420000u', 'l': '150000u'} connections=['d: [connection X7/d =>[signal: a_27_47# w=1]]', 'g: [connection X7/g =>[signal: A w=1]]', 's: [connection X7/s =>[signal: VGND w=1]]', 'b: [connection X7/b =>[signal: VNB w=1]]']]
X_fanout12_7 fanout12_a_27_47# fanout12:A VGND no_conn_172 sky130_fd_pr__nfet_01v8 w=420000u l=150000u

** replacing hold31 with the contents of sky130_fd_sc_hd__dlygate4sd3_1
** [instance X0 of sky130_fd_pr__nfet_01v8, params={'w': '420000u', 'l': '500000u'} connections=['d: [connection X0/d =>[signal: a_391_47# w=1]]', 'g: [connection X0/g =>[signal: a_285_47# w=1]]', 's: [connection X0/s =>[signal: VGND w=1]]', 'b: [connection X0/b =>[signal: VNB w=1]]']]
X_hold31_0 hold31_a_391_47# hold31_a_285_47# VGND no_conn_174 sky130_fd_pr__nfet_01v8 w=420000u l=500000u
** [instance X1 of sky130_fd_pr__pfet_01v8_hvt, params={'w': '420000u', 'l': '500000u'} connections=['d: [connection X1/d =>[signal: VPWR w=1]]', 'g: [connection X1/g =>[signal: a_49_47# w=1]]', 's: [connection X1/s =>[signal: a_285_47# w=1]]', 'b: [connection X1/b =>[signal: VPB w=1]]']]
X_hold31_1 VPWR hold31_a_49_47# hold31_a_285_47# no_conn_175 sky130_fd_pr__pfet_01v8_hvt w=420000u l=500000u
** [instance X2 of sky130_fd_pr__nfet_01v8, params={'w': '420000u', 'l': '150000u'} connections=['d: [connection X2/d =>[signal: a_49_47# w=1]]', 'g: [connection X2/g =>[signal: A w=1]]', 's: [connection X2/s =>[signal: VGND w=1]]', 'b: [connection X2/b =>[signal: VNB w=1]]']]
X_hold31_2 hold31_a_49_47# hold31:A VGND no_conn_174 sky130_fd_pr__nfet_01v8 w=420000u l=150000u
** [instance X3 of sky130_fd_pr__pfet_01v8_hvt, params={'w': '1e+06u', 'l': '150000u'} connections=['d: [connection X3/d =>[signal: VPWR w=1]]', 'g: [connection X3/g =>[signal: a_391_47# w=1]]', 's: [connection X3/s =>[signal: X w=1]]', 'b: [connection X3/b =>[signal: VPB w=1]]']]
X_hold31_3 VPWR hold31_a_391_47# hold31:X no_conn_175 sky130_fd_pr__pfet_01v8_hvt w=1e+06u l=150000u
** [instance X4 of sky130_fd_pr__nfet_01v8, params={'w': '650000u', 'l': '150000u'} connections=['d: [connection X4/d =>[signal: VGND w=1]]', 'g: [connection X4/g =>[signal: a_391_47# w=1]]', 's: [connection X4/s =>[signal: X w=1]]', 'b: [connection X4/b =>[signal: VNB w=1]]']]
X_hold31_4 VGND hold31_a_391_47# hold31:X no_conn_174 sky130_fd_pr__nfet_01v8 w=650000u l=150000u
** [instance X5 of sky130_fd_pr__nfet_01v8, params={'w': '420000u', 'l': '500000u'} connections=['d: [connection X5/d =>[signal: VGND w=1]]', 'g: [connection X5/g =>[signal: a_49_47# w=1]]', 's: [connection X5/s =>[signal: a_285_47# w=1]]', 'b: [connection X5/b =>[signal: VNB w=1]]']]
X_hold31_5 VGND hold31_a_49_47# hold31_a_285_47# no_conn_174 sky130_fd_pr__nfet_01v8 w=420000u l=500000u
** [instance X6 of sky130_fd_pr__pfet_01v8_hvt, params={'w': '420000u', 'l': '500000u'} connections=['d: [connection X6/d =>[signal: a_391_47# w=1]]', 'g: [connection X6/g =>[signal: a_285_47# w=1]]', 's: [connection X6/s =>[signal: VPWR w=1]]', 'b: [connection X6/b =>[signal: VPB w=1]]']]
X_hold31_6 hold31_a_391_47# hold31_a_285_47# VPWR no_conn_175 sky130_fd_pr__pfet_01v8_hvt w=420000u l=500000u
** [instance X7 of sky130_fd_pr__pfet_01v8_hvt, params={'w': '420000u', 'l': '150000u'} connections=['d: [connection X7/d =>[signal: a_49_47# w=1]]', 'g: [connection X7/g =>[signal: A w=1]]', 's: [connection X7/s =>[signal: VPWR w=1]]', 'b: [connection X7/b =>[signal: VPB w=1]]']]
X_hold31_7 hold31_a_49_47# hold31:A VPWR no_conn_175 sky130_fd_pr__pfet_01v8_hvt w=420000u l=150000u

** replacing hold32 with the contents of sky130_fd_sc_hd__dlygate4sd3_1
** [instance X0 of sky130_fd_pr__nfet_01v8, params={'w': '420000u', 'l': '500000u'} connections=['d: [connection X0/d =>[signal: a_391_47# w=1]]', 'g: [connection X0/g =>[signal: a_285_47# w=1]]', 's: [connection X0/s =>[signal: VGND w=1]]', 'b: [connection X0/b =>[signal: VNB w=1]]']]
X_hold32_0 hold32_a_391_47# hold32_a_285_47# VGND no_conn_176 sky130_fd_pr__nfet_01v8 w=420000u l=500000u
** [instance X1 of sky130_fd_pr__pfet_01v8_hvt, params={'w': '420000u', 'l': '500000u'} connections=['d: [connection X1/d =>[signal: VPWR w=1]]', 'g: [connection X1/g =>[signal: a_49_47# w=1]]', 's: [connection X1/s =>[signal: a_285_47# w=1]]', 'b: [connection X1/b =>[signal: VPB w=1]]']]
X_hold32_1 VPWR hold32_a_49_47# hold32_a_285_47# no_conn_177 sky130_fd_pr__pfet_01v8_hvt w=420000u l=500000u
** [instance X2 of sky130_fd_pr__nfet_01v8, params={'w': '420000u', 'l': '150000u'} connections=['d: [connection X2/d =>[signal: a_49_47# w=1]]', 'g: [connection X2/g =>[signal: A w=1]]', 's: [connection X2/s =>[signal: VGND w=1]]', 'b: [connection X2/b =>[signal: VNB w=1]]']]
X_hold32_2 hold32_a_49_47# hold32:A VGND no_conn_176 sky130_fd_pr__nfet_01v8 w=420000u l=150000u
** [instance X3 of sky130_fd_pr__pfet_01v8_hvt, params={'w': '1e+06u', 'l': '150000u'} connections=['d: [connection X3/d =>[signal: VPWR w=1]]', 'g: [connection X3/g =>[signal: a_391_47# w=1]]', 's: [connection X3/s =>[signal: X w=1]]', 'b: [connection X3/b =>[signal: VPB w=1]]']]
X_hold32_3 VPWR hold32_a_391_47# hold32:X no_conn_177 sky130_fd_pr__pfet_01v8_hvt w=1e+06u l=150000u
** [instance X4 of sky130_fd_pr__nfet_01v8, params={'w': '650000u', 'l': '150000u'} connections=['d: [connection X4/d =>[signal: VGND w=1]]', 'g: [connection X4/g =>[signal: a_391_47# w=1]]', 's: [connection X4/s =>[signal: X w=1]]', 'b: [connection X4/b =>[signal: VNB w=1]]']]
X_hold32_4 VGND hold32_a_391_47# hold32:X no_conn_176 sky130_fd_pr__nfet_01v8 w=650000u l=150000u
** [instance X5 of sky130_fd_pr__nfet_01v8, params={'w': '420000u', 'l': '500000u'} connections=['d: [connection X5/d =>[signal: VGND w=1]]', 'g: [connection X5/g =>[signal: a_49_47# w=1]]', 's: [connection X5/s =>[signal: a_285_47# w=1]]', 'b: [connection X5/b =>[signal: VNB w=1]]']]
X_hold32_5 VGND hold32_a_49_47# hold32_a_285_47# no_conn_176 sky130_fd_pr__nfet_01v8 w=420000u l=500000u
** [instance X6 of sky130_fd_pr__pfet_01v8_hvt, params={'w': '420000u', 'l': '500000u'} connections=['d: [connection X6/d =>[signal: a_391_47# w=1]]', 'g: [connection X6/g =>[signal: a_285_47# w=1]]', 's: [connection X6/s =>[signal: VPWR w=1]]', 'b: [connection X6/b =>[signal: VPB w=1]]']]
X_hold32_6 hold32_a_391_47# hold32_a_285_47# VPWR no_conn_177 sky130_fd_pr__pfet_01v8_hvt w=420000u l=500000u
** [instance X7 of sky130_fd_pr__pfet_01v8_hvt, params={'w': '420000u', 'l': '150000u'} connections=['d: [connection X7/d =>[signal: a_49_47# w=1]]', 'g: [connection X7/g =>[signal: A w=1]]', 's: [connection X7/s =>[signal: VPWR w=1]]', 'b: [connection X7/b =>[signal: VPB w=1]]']]
X_hold32_7 hold32_a_49_47# hold32:A VPWR no_conn_177 sky130_fd_pr__pfet_01v8_hvt w=420000u l=150000u

.ENDS
