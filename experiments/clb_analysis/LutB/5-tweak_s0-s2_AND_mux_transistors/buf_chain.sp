xnfet_0
+ 1 A VGND VNB
+ sky130_fd_pr__nfet_01v8
+ PARAMS: l={150m} w={520m}

xpfet_0
+ 1 A VPWR VPB
+ sky130_fd_pr__pfet_01v8_hvt
+ PARAMS: l={150m} w={790m}

xnfet_1
+ 2 1 VGND VNB
+ sky130_fd_pr__nfet_01v8
+ PARAMS: l={150m} w={520m}

xpfet_1
+ 2 1 VPWR VPB
+ sky130_fd_pr__pfet_01v8_hvt
+ PARAMS: l={150m} w={790m}

xnfet_2
+ P 2 VGND VNB
+ sky130_fd_pr__nfet_01v8
+ PARAMS: l={150m} w={640m}

xpfet_2
+ P 2 VPWR VPB
+ sky130_fd_pr__pfet_01v8_hvt
+ PARAMS: l={150m} w={1000m}

xnfet_3
+ X P VGND VNB
+ sky130_fd_pr__nfet_01v8
+ PARAMS: l={150m} w={640m}

xpfet_3
+ X P VPWR VPB
+ sky130_fd_pr__pfet_01v8_hvt
+ PARAMS: l={150m} w={1000m}
