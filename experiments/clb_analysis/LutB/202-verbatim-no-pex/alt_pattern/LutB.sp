* Anonymous `circuit.Package`
* Generated by `vlsirtools.SpiceNetlister`
*

.SUBCKT LutB_register_select_hd_mux2_1
+ S A0 A1 X VPWR VGND VPB VNB
* No parameters

xn0
+ S_B S VGND VNB
+ sky130_fd_pr__nfet_01v8
+ l='150m' w='420m'

xn1
+ I1 S VGND VNB
+ sky130_fd_pr__nfet_01v8
+ l='150m' w='420m'

xn2
+ X_B A1 I1 VNB
+ sky130_fd_pr__nfet_01v8
+ l='150m' w='420m'

xn3
+ I3 S_B VGND VNB
+ sky130_fd_pr__nfet_01v8
+ l='150m' w='420m'

xn4
+ X_B A0 I3 VNB
+ sky130_fd_pr__nfet_01v8
+ l='150m' w='420m'

xn5
+ X X_B VGND VNB
+ sky130_fd_pr__nfet_01v8
+ l='150m' w='650m'

xp0
+ S_B S VPWR VPB
+ sky130_fd_pr__pfet_01v8_hvt
+ l='150m' w='420m'

xp1
+ I0 S VPWR VPB
+ sky130_fd_pr__pfet_01v8_hvt
+ l='150m' w='420m'

xp2
+ X_B A0 I0 VPB
+ sky130_fd_pr__pfet_01v8_hvt
+ l='150m' w='420m'

xp3
+ I2 S_B VPWR VPB
+ sky130_fd_pr__pfet_01v8_hvt
+ l='150m' w='420m'

xp4
+ X_B A1 I2 VPB
+ sky130_fd_pr__pfet_01v8_hvt
+ l='150m' w='420m'

xp5
+ X X_B VPWR VPB
+ sky130_fd_pr__pfet_01v8_hvt
+ l='150m' w='1000m'

.ENDS

.SUBCKT LutB_buf_2
+ A P X VPWR VGND VPB VNB
* No parameters

xpfet_1
+ Xb A VPWR VPB
+ sky130_fd_pr__pfet_01v8_hvt
+ l='150m' w='1000m'

xnfet_1
+ Xb A VGND VNB
+ sky130_fd_pr__nfet_01v8
+ l='150m' w='600m'

xpfet_2a
+ X Xb VPWR VPB
+ sky130_fd_pr__pfet_01v8_hvt
+ l='150m' w='1000m'

xnfet_2a
+ X Xb VGND VNB
+ sky130_fd_pr__nfet_01v8
+ l='150m' w='600m'

xpfet_2b
+ X Xb VPWR VPB
+ sky130_fd_pr__pfet_01v8_hvt
+ l='150m' w='1000m'

xnfet_2b
+ X Xb VGND VNB
+ sky130_fd_pr__nfet_01v8
+ l='150m' w='600m'

xpfet_0a
+ P A VPWR VPB
+ sky130_fd_pr__pfet_01v8_hvt
+ l='150m' w='1000m'

xnfet_0a
+ P A VGND VNB
+ sky130_fd_pr__nfet_01v8
+ l='150m' w='600m'

xpfet_0b
+ P A VPWR VPB
+ sky130_fd_pr__pfet_01v8_hvt
+ l='150m' w='1000m'

xnfet_0b
+ P A VGND VNB
+ sky130_fd_pr__nfet_01v8
+ l='150m' w='600m'

.ENDS

.SUBCKT LutB_alt_sky130_mux
+ S0 S0_B S1 S1_B S2 S2_B input_0 input_1 input_2 input_3 input_4 input_5 input_6 input_7 Z VPB VNB
* No parameters

xupper_left__fet0
+ upper_left__A0 S0_B input_2 VNB
+ sky130_fd_pr__nfet_01v8
+ w='480m' l='170m'

xupper_left__fet1
+ upper_left__A1 S0_B input_0 VNB
+ sky130_fd_pr__nfet_01v8
+ w='480m' l='170m'

xupper_left__fet2
+ input_3 S0 upper_left__A0 VNB
+ sky130_fd_pr__nfet_01v8
+ w='480m' l='170m'

xupper_left__fet3
+ input_1 S0 upper_left__A1 VNB
+ sky130_fd_pr__nfet_01v8
+ w='480m' l='170m'

xupper_left__fet4
+ A0 S1_B upper_left__A1 VNB
+ sky130_fd_pr__nfet_01v8
+ w='480m' l='170m'

xupper_left__fet5
+ upper_left__A0 S1 A0 VNB
+ sky130_fd_pr__nfet_01v8
+ w='480m' l='170m'

xlower_left__fet0
+ lower_left__A0 S0_B input_6 VNB
+ sky130_fd_pr__nfet_01v8
+ w='480m' l='170m'

xlower_left__fet1
+ lower_left__A1 S0_B input_4 VNB
+ sky130_fd_pr__nfet_01v8
+ w='480m' l='170m'

xlower_left__fet2
+ input_7 S0 lower_left__A0 VNB
+ sky130_fd_pr__nfet_01v8
+ w='480m' l='170m'

xlower_left__fet3
+ input_5 S0 lower_left__A1 VNB
+ sky130_fd_pr__nfet_01v8
+ w='480m' l='170m'

xlower_left__fet4
+ A1 S1_B lower_left__A1 VNB
+ sky130_fd_pr__nfet_01v8
+ w='480m' l='170m'

xlower_left__fet5
+ lower_left__A0 S1 A1 VNB
+ sky130_fd_pr__nfet_01v8
+ w='480m' l='170m'

xupper_right__fet0
+ upper_right__A0 S0 input_2 VPB
+ sky130_fd_pr__pfet_01v8
+ w='640m' l='170m'

xupper_right__fet1
+ upper_right__A1 S0 input_0 VPB
+ sky130_fd_pr__pfet_01v8
+ w='640m' l='170m'

xupper_right__fet2
+ input_3 S0_B upper_right__A0 VPB
+ sky130_fd_pr__pfet_01v8
+ w='640m' l='170m'

xupper_right__fet3
+ input_1 S0_B upper_right__A1 VPB
+ sky130_fd_pr__pfet_01v8
+ w='640m' l='170m'

xupper_right__fet4
+ A2 S1 upper_right__A1 VPB
+ sky130_fd_pr__pfet_01v8
+ w='640m' l='170m'

xupper_right__fet5
+ upper_right__A0 S1_B A2 VPB
+ sky130_fd_pr__pfet_01v8
+ w='640m' l='170m'

xlower_right__fet0
+ lower_right__A0 S0 input_6 VPB
+ sky130_fd_pr__pfet_01v8
+ w='640m' l='170m'

xlower_right__fet1
+ lower_right__A1 S0 input_4 VPB
+ sky130_fd_pr__pfet_01v8
+ w='640m' l='170m'

xlower_right__fet2
+ input_7 S0_B lower_right__A0 VPB
+ sky130_fd_pr__pfet_01v8
+ w='640m' l='170m'

xlower_right__fet3
+ input_5 S0_B lower_right__A1 VPB
+ sky130_fd_pr__pfet_01v8
+ w='640m' l='170m'

xlower_right__fet4
+ A3 S1 lower_right__A1 VPB
+ sky130_fd_pr__pfet_01v8
+ w='640m' l='170m'

xlower_right__fet5
+ lower_right__A0 S1_B A3 VPB
+ sky130_fd_pr__pfet_01v8
+ w='640m' l='170m'

xoutput_mux2__nfet0
+ Z S2_B A0 VNB
+ sky130_fd_pr__nfet_01v8
+ w='480m' l='170m'

xoutput_mux2__nfet1
+ A1 S2 Z VNB
+ sky130_fd_pr__nfet_01v8
+ w='480m' l='170m'

xoutput_mux2__pfet0
+ Z S2 A2 VPB
+ sky130_fd_pr__pfet_01v8
+ w='640m' l='170m'

xoutput_mux2__pfet1
+ A3 S2_B Z VPB
+ sky130_fd_pr__pfet_01v8
+ w='640m' l='170m'

.ENDS

.SUBCKT LutB_lut_tap_template
+ VPWR VGND VPB VNB
* No parameters

.ENDS

.SUBCKT LutB_lut_dfxtp_0_0
+ D CLK CLKI Q VPWR VGND VPB VNB
* No parameters

xnfet_0
+ a D VGND VNB
+ sky130_fd_pr__nfet_01v8
+ l='150m' w='420m'

xnfet_1
+ b CLKI a VNB
+ sky130_fd_pr__nfet_01v8
+ l='150m' w='360m'

xnfet_2
+ e c VGND VNB
+ sky130_fd_pr__nfet_01v8
+ l='150m' w='420m'

xnfet_3
+ b CLK e VNB
+ sky130_fd_pr__nfet_01v8
+ l='150m' w='360m'

xnfet_4
+ c b VGND VNB
+ sky130_fd_pr__nfet_01v8
+ l='150m' w='640m'

xnfet_5
+ f CLK c VNB
+ sky130_fd_pr__nfet_01v8
+ l='150m' w='360m'

xnfet_6
+ i Q_B VGND VNB
+ sky130_fd_pr__nfet_01v8
+ l='150m' w='420m'

xnfet_7
+ f CLKI i VNB
+ sky130_fd_pr__nfet_01v8
+ l='150m' w='360m'

xnfet_8
+ Q_B f VGND VNB
+ sky130_fd_pr__nfet_01v8
+ l='150m' w='650m'

xnfet_9
+ Q Q_B VGND VNB
+ sky130_fd_pr__nfet_01v8
+ l='150m' w='650m'

xpfet_0
+ a D VPWR VPB
+ sky130_fd_pr__pfet_01v8_hvt
+ l='150m' w='420m'

xpfet_1
+ b CLK a VPB
+ sky130_fd_pr__pfet_01v8_hvt
+ l='150m' w='420m'

xpfet_2
+ j c VPWR VPB
+ sky130_fd_pr__pfet_01v8_hvt
+ l='150m' w='420m'

xpfet_3
+ b CLKI j VPB
+ sky130_fd_pr__pfet_01v8_hvt
+ l='150m' w='420m'

xpfet_4
+ c b VPWR VPB
+ sky130_fd_pr__pfet_01v8_hvt
+ l='150m' w='750m'

xpfet_5
+ f CLKI c VPB
+ sky130_fd_pr__pfet_01v8_hvt
+ l='150m' w='420m'

xpfet_6
+ h Q_B VPWR VPB
+ sky130_fd_pr__pfet_01v8_hvt
+ l='150m' w='420m'

xpfet_7
+ f CLK h VPB
+ sky130_fd_pr__pfet_01v8_hvt
+ l='150m' w='420m'

xpfet_8
+ Q_B f VPWR VPB
+ sky130_fd_pr__pfet_01v8_hvt
+ l='150m' w='1000m'

xpfet_9
+ Q Q_B VPWR VPB
+ sky130_fd_pr__pfet_01v8_hvt
+ l='150m' w='1000m'

.ENDS

.SUBCKT LutB_lut_dfxtp_0_1
+ D CLK CLKI Q VPWR VGND VPB VNB
* No parameters

xnfet_0
+ a D VGND VNB
+ sky130_fd_pr__nfet_01v8
+ l='150m' w='420m'

xnfet_1
+ b CLKI a VNB
+ sky130_fd_pr__nfet_01v8
+ l='150m' w='360m'

xnfet_2
+ e c VGND VNB
+ sky130_fd_pr__nfet_01v8
+ l='150m' w='420m'

xnfet_3
+ b CLK e VNB
+ sky130_fd_pr__nfet_01v8
+ l='150m' w='360m'

xnfet_4
+ c b VGND VNB
+ sky130_fd_pr__nfet_01v8
+ l='150m' w='640m'

xnfet_5
+ f CLK c VNB
+ sky130_fd_pr__nfet_01v8
+ l='150m' w='360m'

xnfet_6
+ i Q_B VGND VNB
+ sky130_fd_pr__nfet_01v8
+ l='150m' w='420m'

xnfet_7
+ f CLKI i VNB
+ sky130_fd_pr__nfet_01v8
+ l='150m' w='360m'

xnfet_8
+ Q_B f VGND VNB
+ sky130_fd_pr__nfet_01v8
+ l='150m' w='650m'

xnfet_9
+ Q Q_B VGND VNB
+ sky130_fd_pr__nfet_01v8
+ l='150m' w='650m'

xpfet_0
+ a D VPWR VPB
+ sky130_fd_pr__pfet_01v8_hvt
+ l='150m' w='420m'

xpfet_1
+ b CLK a VPB
+ sky130_fd_pr__pfet_01v8_hvt
+ l='150m' w='420m'

xpfet_2
+ j c VPWR VPB
+ sky130_fd_pr__pfet_01v8_hvt
+ l='150m' w='420m'

xpfet_3
+ b CLKI j VPB
+ sky130_fd_pr__pfet_01v8_hvt
+ l='150m' w='420m'

xpfet_4
+ c b VPWR VPB
+ sky130_fd_pr__pfet_01v8_hvt
+ l='150m' w='750m'

xpfet_5
+ f CLKI c VPB
+ sky130_fd_pr__pfet_01v8_hvt
+ l='150m' w='420m'

xpfet_6
+ h Q_B VPWR VPB
+ sky130_fd_pr__pfet_01v8_hvt
+ l='150m' w='420m'

xpfet_7
+ f CLK h VPB
+ sky130_fd_pr__pfet_01v8_hvt
+ l='150m' w='420m'

xpfet_8
+ Q_B f VPWR VPB
+ sky130_fd_pr__pfet_01v8_hvt
+ l='150m' w='1000m'

xpfet_9
+ Q Q_B VPWR VPB
+ sky130_fd_pr__pfet_01v8_hvt
+ l='150m' w='1000m'

.ENDS

.SUBCKT LutB_lut_dfxtp_0_2
+ D CLK CLKI Q VPWR VGND VPB VNB
* No parameters

xnfet_0
+ a D VGND VNB
+ sky130_fd_pr__nfet_01v8
+ l='150m' w='420m'

xnfet_1
+ b CLKI a VNB
+ sky130_fd_pr__nfet_01v8
+ l='150m' w='360m'

xnfet_2
+ e c VGND VNB
+ sky130_fd_pr__nfet_01v8
+ l='150m' w='420m'

xnfet_3
+ b CLK e VNB
+ sky130_fd_pr__nfet_01v8
+ l='150m' w='360m'

xnfet_4
+ c b VGND VNB
+ sky130_fd_pr__nfet_01v8
+ l='150m' w='640m'

xnfet_5
+ f CLK c VNB
+ sky130_fd_pr__nfet_01v8
+ l='150m' w='360m'

xnfet_6
+ i Q_B VGND VNB
+ sky130_fd_pr__nfet_01v8
+ l='150m' w='420m'

xnfet_7
+ f CLKI i VNB
+ sky130_fd_pr__nfet_01v8
+ l='150m' w='360m'

xnfet_8
+ Q_B f VGND VNB
+ sky130_fd_pr__nfet_01v8
+ l='150m' w='650m'

xnfet_9
+ Q Q_B VGND VNB
+ sky130_fd_pr__nfet_01v8
+ l='150m' w='650m'

xpfet_0
+ a D VPWR VPB
+ sky130_fd_pr__pfet_01v8_hvt
+ l='150m' w='420m'

xpfet_1
+ b CLK a VPB
+ sky130_fd_pr__pfet_01v8_hvt
+ l='150m' w='420m'

xpfet_2
+ j c VPWR VPB
+ sky130_fd_pr__pfet_01v8_hvt
+ l='150m' w='420m'

xpfet_3
+ b CLKI j VPB
+ sky130_fd_pr__pfet_01v8_hvt
+ l='150m' w='420m'

xpfet_4
+ c b VPWR VPB
+ sky130_fd_pr__pfet_01v8_hvt
+ l='150m' w='750m'

xpfet_5
+ f CLKI c VPB
+ sky130_fd_pr__pfet_01v8_hvt
+ l='150m' w='420m'

xpfet_6
+ h Q_B VPWR VPB
+ sky130_fd_pr__pfet_01v8_hvt
+ l='150m' w='420m'

xpfet_7
+ f CLK h VPB
+ sky130_fd_pr__pfet_01v8_hvt
+ l='150m' w='420m'

xpfet_8
+ Q_B f VPWR VPB
+ sky130_fd_pr__pfet_01v8_hvt
+ l='150m' w='1000m'

xpfet_9
+ Q Q_B VPWR VPB
+ sky130_fd_pr__pfet_01v8_hvt
+ l='150m' w='1000m'

.ENDS

.SUBCKT LutB_lut_dfxtp_0_3
+ D CLK CLKI Q VPWR VGND VPB VNB
* No parameters

xnfet_0
+ a D VGND VNB
+ sky130_fd_pr__nfet_01v8
+ l='150m' w='420m'

xnfet_1
+ b CLKI a VNB
+ sky130_fd_pr__nfet_01v8
+ l='150m' w='360m'

xnfet_2
+ e c VGND VNB
+ sky130_fd_pr__nfet_01v8
+ l='150m' w='420m'

xnfet_3
+ b CLK e VNB
+ sky130_fd_pr__nfet_01v8
+ l='150m' w='360m'

xnfet_4
+ c b VGND VNB
+ sky130_fd_pr__nfet_01v8
+ l='150m' w='640m'

xnfet_5
+ f CLK c VNB
+ sky130_fd_pr__nfet_01v8
+ l='150m' w='360m'

xnfet_6
+ i Q_B VGND VNB
+ sky130_fd_pr__nfet_01v8
+ l='150m' w='420m'

xnfet_7
+ f CLKI i VNB
+ sky130_fd_pr__nfet_01v8
+ l='150m' w='360m'

xnfet_8
+ Q_B f VGND VNB
+ sky130_fd_pr__nfet_01v8
+ l='150m' w='650m'

xnfet_9
+ Q Q_B VGND VNB
+ sky130_fd_pr__nfet_01v8
+ l='150m' w='650m'

xpfet_0
+ a D VPWR VPB
+ sky130_fd_pr__pfet_01v8_hvt
+ l='150m' w='420m'

xpfet_1
+ b CLK a VPB
+ sky130_fd_pr__pfet_01v8_hvt
+ l='150m' w='420m'

xpfet_2
+ j c VPWR VPB
+ sky130_fd_pr__pfet_01v8_hvt
+ l='150m' w='420m'

xpfet_3
+ b CLKI j VPB
+ sky130_fd_pr__pfet_01v8_hvt
+ l='150m' w='420m'

xpfet_4
+ c b VPWR VPB
+ sky130_fd_pr__pfet_01v8_hvt
+ l='150m' w='750m'

xpfet_5
+ f CLKI c VPB
+ sky130_fd_pr__pfet_01v8_hvt
+ l='150m' w='420m'

xpfet_6
+ h Q_B VPWR VPB
+ sky130_fd_pr__pfet_01v8_hvt
+ l='150m' w='420m'

xpfet_7
+ f CLK h VPB
+ sky130_fd_pr__pfet_01v8_hvt
+ l='150m' w='420m'

xpfet_8
+ Q_B f VPWR VPB
+ sky130_fd_pr__pfet_01v8_hvt
+ l='150m' w='1000m'

xpfet_9
+ Q Q_B VPWR VPB
+ sky130_fd_pr__pfet_01v8_hvt
+ l='150m' w='1000m'

.ENDS

.SUBCKT LutB_lut_dfxtp_0_4
+ D CLK CLKI Q VPWR VGND VPB VNB
* No parameters

xnfet_0
+ a D VGND VNB
+ sky130_fd_pr__nfet_01v8
+ l='150m' w='420m'

xnfet_1
+ b CLKI a VNB
+ sky130_fd_pr__nfet_01v8
+ l='150m' w='360m'

xnfet_2
+ e c VGND VNB
+ sky130_fd_pr__nfet_01v8
+ l='150m' w='420m'

xnfet_3
+ b CLK e VNB
+ sky130_fd_pr__nfet_01v8
+ l='150m' w='360m'

xnfet_4
+ c b VGND VNB
+ sky130_fd_pr__nfet_01v8
+ l='150m' w='640m'

xnfet_5
+ f CLK c VNB
+ sky130_fd_pr__nfet_01v8
+ l='150m' w='360m'

xnfet_6
+ i Q_B VGND VNB
+ sky130_fd_pr__nfet_01v8
+ l='150m' w='420m'

xnfet_7
+ f CLKI i VNB
+ sky130_fd_pr__nfet_01v8
+ l='150m' w='360m'

xnfet_8
+ Q_B f VGND VNB
+ sky130_fd_pr__nfet_01v8
+ l='150m' w='650m'

xnfet_9
+ Q Q_B VGND VNB
+ sky130_fd_pr__nfet_01v8
+ l='150m' w='650m'

xpfet_0
+ a D VPWR VPB
+ sky130_fd_pr__pfet_01v8_hvt
+ l='150m' w='420m'

xpfet_1
+ b CLK a VPB
+ sky130_fd_pr__pfet_01v8_hvt
+ l='150m' w='420m'

xpfet_2
+ j c VPWR VPB
+ sky130_fd_pr__pfet_01v8_hvt
+ l='150m' w='420m'

xpfet_3
+ b CLKI j VPB
+ sky130_fd_pr__pfet_01v8_hvt
+ l='150m' w='420m'

xpfet_4
+ c b VPWR VPB
+ sky130_fd_pr__pfet_01v8_hvt
+ l='150m' w='750m'

xpfet_5
+ f CLKI c VPB
+ sky130_fd_pr__pfet_01v8_hvt
+ l='150m' w='420m'

xpfet_6
+ h Q_B VPWR VPB
+ sky130_fd_pr__pfet_01v8_hvt
+ l='150m' w='420m'

xpfet_7
+ f CLK h VPB
+ sky130_fd_pr__pfet_01v8_hvt
+ l='150m' w='420m'

xpfet_8
+ Q_B f VPWR VPB
+ sky130_fd_pr__pfet_01v8_hvt
+ l='150m' w='1000m'

xpfet_9
+ Q Q_B VPWR VPB
+ sky130_fd_pr__pfet_01v8_hvt
+ l='150m' w='1000m'

.ENDS

.SUBCKT LutB_buf_0
+ X P A VPWR VGND VPB VNB
* No parameters

xnfet_0
+ P A VGND VNB
+ sky130_fd_pr__nfet_01v8
+ l='150m' w='520m'

xpfet_0
+ P A VPWR VPB
+ sky130_fd_pr__pfet_01v8_hvt
+ l='150m' w='790m'

xnfet_1
+ X P VGND VNB
+ sky130_fd_pr__nfet_01v8
+ l='150m' w='520m'

xpfet_1
+ X P VPWR VPB
+ sky130_fd_pr__pfet_01v8_hvt
+ l='150m' w='790m'

.ENDS

.SUBCKT LutB_lut_dfxtp_0_5
+ D CLK CLKI Q VPWR VGND VPB VNB
* No parameters

xnfet_0
+ a D VGND VNB
+ sky130_fd_pr__nfet_01v8
+ l='150m' w='420m'

xnfet_1
+ b CLKI a VNB
+ sky130_fd_pr__nfet_01v8
+ l='150m' w='360m'

xnfet_2
+ e c VGND VNB
+ sky130_fd_pr__nfet_01v8
+ l='150m' w='420m'

xnfet_3
+ b CLK e VNB
+ sky130_fd_pr__nfet_01v8
+ l='150m' w='360m'

xnfet_4
+ c b VGND VNB
+ sky130_fd_pr__nfet_01v8
+ l='150m' w='640m'

xnfet_5
+ f CLK c VNB
+ sky130_fd_pr__nfet_01v8
+ l='150m' w='360m'

xnfet_6
+ i Q_B VGND VNB
+ sky130_fd_pr__nfet_01v8
+ l='150m' w='420m'

xnfet_7
+ f CLKI i VNB
+ sky130_fd_pr__nfet_01v8
+ l='150m' w='360m'

xnfet_8
+ Q_B f VGND VNB
+ sky130_fd_pr__nfet_01v8
+ l='150m' w='650m'

xnfet_9
+ Q Q_B VGND VNB
+ sky130_fd_pr__nfet_01v8
+ l='150m' w='650m'

xpfet_0
+ a D VPWR VPB
+ sky130_fd_pr__pfet_01v8_hvt
+ l='150m' w='420m'

xpfet_1
+ b CLK a VPB
+ sky130_fd_pr__pfet_01v8_hvt
+ l='150m' w='420m'

xpfet_2
+ j c VPWR VPB
+ sky130_fd_pr__pfet_01v8_hvt
+ l='150m' w='420m'

xpfet_3
+ b CLKI j VPB
+ sky130_fd_pr__pfet_01v8_hvt
+ l='150m' w='420m'

xpfet_4
+ c b VPWR VPB
+ sky130_fd_pr__pfet_01v8_hvt
+ l='150m' w='750m'

xpfet_5
+ f CLKI c VPB
+ sky130_fd_pr__pfet_01v8_hvt
+ l='150m' w='420m'

xpfet_6
+ h Q_B VPWR VPB
+ sky130_fd_pr__pfet_01v8_hvt
+ l='150m' w='420m'

xpfet_7
+ f CLK h VPB
+ sky130_fd_pr__pfet_01v8_hvt
+ l='150m' w='420m'

xpfet_8
+ Q_B f VPWR VPB
+ sky130_fd_pr__pfet_01v8_hvt
+ l='150m' w='1000m'

xpfet_9
+ Q Q_B VPWR VPB
+ sky130_fd_pr__pfet_01v8_hvt
+ l='150m' w='1000m'

.ENDS

.SUBCKT LutB_lut_dfxtp_0_6
+ D CLK CLKI Q VPWR VGND VPB VNB
* No parameters

xnfet_0
+ a D VGND VNB
+ sky130_fd_pr__nfet_01v8
+ l='150m' w='420m'

xnfet_1
+ b CLKI a VNB
+ sky130_fd_pr__nfet_01v8
+ l='150m' w='360m'

xnfet_2
+ e c VGND VNB
+ sky130_fd_pr__nfet_01v8
+ l='150m' w='420m'

xnfet_3
+ b CLK e VNB
+ sky130_fd_pr__nfet_01v8
+ l='150m' w='360m'

xnfet_4
+ c b VGND VNB
+ sky130_fd_pr__nfet_01v8
+ l='150m' w='640m'

xnfet_5
+ f CLK c VNB
+ sky130_fd_pr__nfet_01v8
+ l='150m' w='360m'

xnfet_6
+ i Q_B VGND VNB
+ sky130_fd_pr__nfet_01v8
+ l='150m' w='420m'

xnfet_7
+ f CLKI i VNB
+ sky130_fd_pr__nfet_01v8
+ l='150m' w='360m'

xnfet_8
+ Q_B f VGND VNB
+ sky130_fd_pr__nfet_01v8
+ l='150m' w='650m'

xnfet_9
+ Q Q_B VGND VNB
+ sky130_fd_pr__nfet_01v8
+ l='150m' w='650m'

xpfet_0
+ a D VPWR VPB
+ sky130_fd_pr__pfet_01v8_hvt
+ l='150m' w='420m'

xpfet_1
+ b CLK a VPB
+ sky130_fd_pr__pfet_01v8_hvt
+ l='150m' w='420m'

xpfet_2
+ j c VPWR VPB
+ sky130_fd_pr__pfet_01v8_hvt
+ l='150m' w='420m'

xpfet_3
+ b CLKI j VPB
+ sky130_fd_pr__pfet_01v8_hvt
+ l='150m' w='420m'

xpfet_4
+ c b VPWR VPB
+ sky130_fd_pr__pfet_01v8_hvt
+ l='150m' w='750m'

xpfet_5
+ f CLKI c VPB
+ sky130_fd_pr__pfet_01v8_hvt
+ l='150m' w='420m'

xpfet_6
+ h Q_B VPWR VPB
+ sky130_fd_pr__pfet_01v8_hvt
+ l='150m' w='420m'

xpfet_7
+ f CLK h VPB
+ sky130_fd_pr__pfet_01v8_hvt
+ l='150m' w='420m'

xpfet_8
+ Q_B f VPWR VPB
+ sky130_fd_pr__pfet_01v8_hvt
+ l='150m' w='1000m'

xpfet_9
+ Q Q_B VPWR VPB
+ sky130_fd_pr__pfet_01v8_hvt
+ l='150m' w='1000m'

.ENDS

.SUBCKT LutB_lut_dfxtp_0_7
+ D CLK CLKI Q VPWR VGND VPB VNB
* No parameters

xnfet_0
+ a D VGND VNB
+ sky130_fd_pr__nfet_01v8
+ l='150m' w='420m'

xnfet_1
+ b CLKI a VNB
+ sky130_fd_pr__nfet_01v8
+ l='150m' w='360m'

xnfet_2
+ e c VGND VNB
+ sky130_fd_pr__nfet_01v8
+ l='150m' w='420m'

xnfet_3
+ b CLK e VNB
+ sky130_fd_pr__nfet_01v8
+ l='150m' w='360m'

xnfet_4
+ c b VGND VNB
+ sky130_fd_pr__nfet_01v8
+ l='150m' w='640m'

xnfet_5
+ f CLK c VNB
+ sky130_fd_pr__nfet_01v8
+ l='150m' w='360m'

xnfet_6
+ i Q_B VGND VNB
+ sky130_fd_pr__nfet_01v8
+ l='150m' w='420m'

xnfet_7
+ f CLKI i VNB
+ sky130_fd_pr__nfet_01v8
+ l='150m' w='360m'

xnfet_8
+ Q_B f VGND VNB
+ sky130_fd_pr__nfet_01v8
+ l='150m' w='650m'

xnfet_9
+ Q Q_B VGND VNB
+ sky130_fd_pr__nfet_01v8
+ l='150m' w='650m'

xpfet_0
+ a D VPWR VPB
+ sky130_fd_pr__pfet_01v8_hvt
+ l='150m' w='420m'

xpfet_1
+ b CLK a VPB
+ sky130_fd_pr__pfet_01v8_hvt
+ l='150m' w='420m'

xpfet_2
+ j c VPWR VPB
+ sky130_fd_pr__pfet_01v8_hvt
+ l='150m' w='420m'

xpfet_3
+ b CLKI j VPB
+ sky130_fd_pr__pfet_01v8_hvt
+ l='150m' w='420m'

xpfet_4
+ c b VPWR VPB
+ sky130_fd_pr__pfet_01v8_hvt
+ l='150m' w='750m'

xpfet_5
+ f CLKI c VPB
+ sky130_fd_pr__pfet_01v8_hvt
+ l='150m' w='420m'

xpfet_6
+ h Q_B VPWR VPB
+ sky130_fd_pr__pfet_01v8_hvt
+ l='150m' w='420m'

xpfet_7
+ f CLK h VPB
+ sky130_fd_pr__pfet_01v8_hvt
+ l='150m' w='420m'

xpfet_8
+ Q_B f VPWR VPB
+ sky130_fd_pr__pfet_01v8_hvt
+ l='150m' w='1000m'

xpfet_9
+ Q Q_B VPWR VPB
+ sky130_fd_pr__pfet_01v8_hvt
+ l='150m' w='1000m'

.ENDS

.SUBCKT LutB_lut_dfxtp_1_0
+ D CLK CLKI Q VPWR VGND VPB VNB
* No parameters

xnfet_0
+ a D VGND VNB
+ sky130_fd_pr__nfet_01v8
+ l='150m' w='420m'

xnfet_1
+ b CLKI a VNB
+ sky130_fd_pr__nfet_01v8
+ l='150m' w='360m'

xnfet_2
+ e c VGND VNB
+ sky130_fd_pr__nfet_01v8
+ l='150m' w='420m'

xnfet_3
+ b CLK e VNB
+ sky130_fd_pr__nfet_01v8
+ l='150m' w='360m'

xnfet_4
+ c b VGND VNB
+ sky130_fd_pr__nfet_01v8
+ l='150m' w='640m'

xnfet_5
+ f CLK c VNB
+ sky130_fd_pr__nfet_01v8
+ l='150m' w='360m'

xnfet_6
+ i Q_B VGND VNB
+ sky130_fd_pr__nfet_01v8
+ l='150m' w='420m'

xnfet_7
+ f CLKI i VNB
+ sky130_fd_pr__nfet_01v8
+ l='150m' w='360m'

xnfet_8
+ Q_B f VGND VNB
+ sky130_fd_pr__nfet_01v8
+ l='150m' w='650m'

xnfet_9
+ Q Q_B VGND VNB
+ sky130_fd_pr__nfet_01v8
+ l='150m' w='650m'

xpfet_0
+ a D VPWR VPB
+ sky130_fd_pr__pfet_01v8_hvt
+ l='150m' w='420m'

xpfet_1
+ b CLK a VPB
+ sky130_fd_pr__pfet_01v8_hvt
+ l='150m' w='420m'

xpfet_2
+ j c VPWR VPB
+ sky130_fd_pr__pfet_01v8_hvt
+ l='150m' w='420m'

xpfet_3
+ b CLKI j VPB
+ sky130_fd_pr__pfet_01v8_hvt
+ l='150m' w='420m'

xpfet_4
+ c b VPWR VPB
+ sky130_fd_pr__pfet_01v8_hvt
+ l='150m' w='750m'

xpfet_5
+ f CLKI c VPB
+ sky130_fd_pr__pfet_01v8_hvt
+ l='150m' w='420m'

xpfet_6
+ h Q_B VPWR VPB
+ sky130_fd_pr__pfet_01v8_hvt
+ l='150m' w='420m'

xpfet_7
+ f CLK h VPB
+ sky130_fd_pr__pfet_01v8_hvt
+ l='150m' w='420m'

xpfet_8
+ Q_B f VPWR VPB
+ sky130_fd_pr__pfet_01v8_hvt
+ l='150m' w='1000m'

xpfet_9
+ Q Q_B VPWR VPB
+ sky130_fd_pr__pfet_01v8_hvt
+ l='150m' w='1000m'

.ENDS

.SUBCKT sky130_decap_1380x2720
+ VPWR VGND VPB VNB
* No parameters

xnfet
+ VGND VPWR VGND VNB
+ sky130_fd_pr__nfet_01v8
+ l='570m' w='550m'

xpfet
+ VPWR VGND VPWR VPB
+ sky130_fd_pr__pfet_01v8_hvt
+ l='570m' w='870m'

.ENDS

.SUBCKT LutB_combinational_select_hd_mux2_1
+ S A0 A1 X VPWR VGND VPB VNB
* No parameters

xn0
+ S_B S VGND VNB
+ sky130_fd_pr__nfet_01v8
+ l='150m' w='420m'

xn1
+ I1 S VGND VNB
+ sky130_fd_pr__nfet_01v8
+ l='150m' w='420m'

xn2
+ X_B A1 I1 VNB
+ sky130_fd_pr__nfet_01v8
+ l='150m' w='420m'

xn3
+ I3 S_B VGND VNB
+ sky130_fd_pr__nfet_01v8
+ l='150m' w='420m'

xn4
+ X_B A0 I3 VNB
+ sky130_fd_pr__nfet_01v8
+ l='150m' w='420m'

xn5
+ X X_B VGND VNB
+ sky130_fd_pr__nfet_01v8
+ l='150m' w='650m'

xp0
+ S_B S VPWR VPB
+ sky130_fd_pr__pfet_01v8_hvt
+ l='150m' w='420m'

xp1
+ I0 S VPWR VPB
+ sky130_fd_pr__pfet_01v8_hvt
+ l='150m' w='420m'

xp2
+ X_B A0 I0 VPB
+ sky130_fd_pr__pfet_01v8_hvt
+ l='150m' w='420m'

xp3
+ I2 S_B VPWR VPB
+ sky130_fd_pr__pfet_01v8_hvt
+ l='150m' w='420m'

xp4
+ X_B A1 I2 VPB
+ sky130_fd_pr__pfet_01v8_hvt
+ l='150m' w='420m'

xp5
+ X X_B VPWR VPB
+ sky130_fd_pr__pfet_01v8_hvt
+ l='150m' w='1000m'

.ENDS

.SUBCKT LutB_register_select_config_dfxtp
+ D CLK CLKI Q VPWR VGND VPB VNB
* No parameters

xnfet_0
+ a D VGND VNB
+ sky130_fd_pr__nfet_01v8
+ l='150m' w='420m'

xnfet_1
+ b CLKI a VNB
+ sky130_fd_pr__nfet_01v8
+ l='150m' w='360m'

xnfet_2
+ e c VGND VNB
+ sky130_fd_pr__nfet_01v8
+ l='150m' w='420m'

xnfet_3
+ b CLK e VNB
+ sky130_fd_pr__nfet_01v8
+ l='150m' w='360m'

xnfet_4
+ c b VGND VNB
+ sky130_fd_pr__nfet_01v8
+ l='150m' w='640m'

xnfet_5
+ f CLK c VNB
+ sky130_fd_pr__nfet_01v8
+ l='150m' w='360m'

xnfet_6
+ i Q_B VGND VNB
+ sky130_fd_pr__nfet_01v8
+ l='150m' w='420m'

xnfet_7
+ f CLKI i VNB
+ sky130_fd_pr__nfet_01v8
+ l='150m' w='360m'

xnfet_8
+ Q_B f VGND VNB
+ sky130_fd_pr__nfet_01v8
+ l='150m' w='650m'

xnfet_9
+ Q Q_B VGND VNB
+ sky130_fd_pr__nfet_01v8
+ l='150m' w='650m'

xpfet_0
+ a D VPWR VPB
+ sky130_fd_pr__pfet_01v8_hvt
+ l='150m' w='420m'

xpfet_1
+ b CLK a VPB
+ sky130_fd_pr__pfet_01v8_hvt
+ l='150m' w='420m'

xpfet_2
+ j c VPWR VPB
+ sky130_fd_pr__pfet_01v8_hvt
+ l='150m' w='420m'

xpfet_3
+ b CLKI j VPB
+ sky130_fd_pr__pfet_01v8_hvt
+ l='150m' w='420m'

xpfet_4
+ c b VPWR VPB
+ sky130_fd_pr__pfet_01v8_hvt
+ l='150m' w='750m'

xpfet_5
+ f CLKI c VPB
+ sky130_fd_pr__pfet_01v8_hvt
+ l='150m' w='420m'

xpfet_6
+ h Q_B VPWR VPB
+ sky130_fd_pr__pfet_01v8_hvt
+ l='150m' w='420m'

xpfet_7
+ f CLK h VPB
+ sky130_fd_pr__pfet_01v8_hvt
+ l='150m' w='420m'

xpfet_8
+ Q_B f VPWR VPB
+ sky130_fd_pr__pfet_01v8_hvt
+ l='150m' w='1000m'

xpfet_9
+ Q Q_B VPWR VPB
+ sky130_fd_pr__pfet_01v8_hvt
+ l='150m' w='1000m'

.ENDS

.SUBCKT LutB_lut_dfxtp_1_1
+ D CLK CLKI Q VPWR VGND VPB VNB
* No parameters

xnfet_0
+ a D VGND VNB
+ sky130_fd_pr__nfet_01v8
+ l='150m' w='420m'

xnfet_1
+ b CLKI a VNB
+ sky130_fd_pr__nfet_01v8
+ l='150m' w='360m'

xnfet_2
+ e c VGND VNB
+ sky130_fd_pr__nfet_01v8
+ l='150m' w='420m'

xnfet_3
+ b CLK e VNB
+ sky130_fd_pr__nfet_01v8
+ l='150m' w='360m'

xnfet_4
+ c b VGND VNB
+ sky130_fd_pr__nfet_01v8
+ l='150m' w='640m'

xnfet_5
+ f CLK c VNB
+ sky130_fd_pr__nfet_01v8
+ l='150m' w='360m'

xnfet_6
+ i Q_B VGND VNB
+ sky130_fd_pr__nfet_01v8
+ l='150m' w='420m'

xnfet_7
+ f CLKI i VNB
+ sky130_fd_pr__nfet_01v8
+ l='150m' w='360m'

xnfet_8
+ Q_B f VGND VNB
+ sky130_fd_pr__nfet_01v8
+ l='150m' w='650m'

xnfet_9
+ Q Q_B VGND VNB
+ sky130_fd_pr__nfet_01v8
+ l='150m' w='650m'

xpfet_0
+ a D VPWR VPB
+ sky130_fd_pr__pfet_01v8_hvt
+ l='150m' w='420m'

xpfet_1
+ b CLK a VPB
+ sky130_fd_pr__pfet_01v8_hvt
+ l='150m' w='420m'

xpfet_2
+ j c VPWR VPB
+ sky130_fd_pr__pfet_01v8_hvt
+ l='150m' w='420m'

xpfet_3
+ b CLKI j VPB
+ sky130_fd_pr__pfet_01v8_hvt
+ l='150m' w='420m'

xpfet_4
+ c b VPWR VPB
+ sky130_fd_pr__pfet_01v8_hvt
+ l='150m' w='750m'

xpfet_5
+ f CLKI c VPB
+ sky130_fd_pr__pfet_01v8_hvt
+ l='150m' w='420m'

xpfet_6
+ h Q_B VPWR VPB
+ sky130_fd_pr__pfet_01v8_hvt
+ l='150m' w='420m'

xpfet_7
+ f CLK h VPB
+ sky130_fd_pr__pfet_01v8_hvt
+ l='150m' w='420m'

xpfet_8
+ Q_B f VPWR VPB
+ sky130_fd_pr__pfet_01v8_hvt
+ l='150m' w='1000m'

xpfet_9
+ Q Q_B VPWR VPB
+ sky130_fd_pr__pfet_01v8_hvt
+ l='150m' w='1000m'

.ENDS

.SUBCKT LutB_clk_buf_0_template
+ X P A VPWR VGND VPB VNB
* No parameters

xnfet_0
+ P A VGND VNB
+ sky130_fd_pr__nfet_01v8
+ l='150m' w='520m'

xpfet_0
+ P A VPWR VPB
+ sky130_fd_pr__pfet_01v8_hvt
+ l='150m' w='790m'

xnfet_1
+ X P VGND VNB
+ sky130_fd_pr__nfet_01v8
+ l='150m' w='520m'

xpfet_1
+ X P VPWR VPB
+ sky130_fd_pr__pfet_01v8_hvt
+ l='150m' w='790m'

.ENDS

.SUBCKT LutB_lut_dfxtp_1_2
+ D CLK CLKI Q VPWR VGND VPB VNB
* No parameters

xnfet_0
+ a D VGND VNB
+ sky130_fd_pr__nfet_01v8
+ l='150m' w='420m'

xnfet_1
+ b CLKI a VNB
+ sky130_fd_pr__nfet_01v8
+ l='150m' w='360m'

xnfet_2
+ e c VGND VNB
+ sky130_fd_pr__nfet_01v8
+ l='150m' w='420m'

xnfet_3
+ b CLK e VNB
+ sky130_fd_pr__nfet_01v8
+ l='150m' w='360m'

xnfet_4
+ c b VGND VNB
+ sky130_fd_pr__nfet_01v8
+ l='150m' w='640m'

xnfet_5
+ f CLK c VNB
+ sky130_fd_pr__nfet_01v8
+ l='150m' w='360m'

xnfet_6
+ i Q_B VGND VNB
+ sky130_fd_pr__nfet_01v8
+ l='150m' w='420m'

xnfet_7
+ f CLKI i VNB
+ sky130_fd_pr__nfet_01v8
+ l='150m' w='360m'

xnfet_8
+ Q_B f VGND VNB
+ sky130_fd_pr__nfet_01v8
+ l='150m' w='650m'

xnfet_9
+ Q Q_B VGND VNB
+ sky130_fd_pr__nfet_01v8
+ l='150m' w='650m'

xpfet_0
+ a D VPWR VPB
+ sky130_fd_pr__pfet_01v8_hvt
+ l='150m' w='420m'

xpfet_1
+ b CLK a VPB
+ sky130_fd_pr__pfet_01v8_hvt
+ l='150m' w='420m'

xpfet_2
+ j c VPWR VPB
+ sky130_fd_pr__pfet_01v8_hvt
+ l='150m' w='420m'

xpfet_3
+ b CLKI j VPB
+ sky130_fd_pr__pfet_01v8_hvt
+ l='150m' w='420m'

xpfet_4
+ c b VPWR VPB
+ sky130_fd_pr__pfet_01v8_hvt
+ l='150m' w='750m'

xpfet_5
+ f CLKI c VPB
+ sky130_fd_pr__pfet_01v8_hvt
+ l='150m' w='420m'

xpfet_6
+ h Q_B VPWR VPB
+ sky130_fd_pr__pfet_01v8_hvt
+ l='150m' w='420m'

xpfet_7
+ f CLK h VPB
+ sky130_fd_pr__pfet_01v8_hvt
+ l='150m' w='420m'

xpfet_8
+ Q_B f VPWR VPB
+ sky130_fd_pr__pfet_01v8_hvt
+ l='150m' w='1000m'

xpfet_9
+ Q Q_B VPWR VPB
+ sky130_fd_pr__pfet_01v8_hvt
+ l='150m' w='1000m'

.ENDS

.SUBCKT LutB_lut_dfxtp_1_3
+ D CLK CLKI Q VPWR VGND VPB VNB
* No parameters

xnfet_0
+ a D VGND VNB
+ sky130_fd_pr__nfet_01v8
+ l='150m' w='420m'

xnfet_1
+ b CLKI a VNB
+ sky130_fd_pr__nfet_01v8
+ l='150m' w='360m'

xnfet_2
+ e c VGND VNB
+ sky130_fd_pr__nfet_01v8
+ l='150m' w='420m'

xnfet_3
+ b CLK e VNB
+ sky130_fd_pr__nfet_01v8
+ l='150m' w='360m'

xnfet_4
+ c b VGND VNB
+ sky130_fd_pr__nfet_01v8
+ l='150m' w='640m'

xnfet_5
+ f CLK c VNB
+ sky130_fd_pr__nfet_01v8
+ l='150m' w='360m'

xnfet_6
+ i Q_B VGND VNB
+ sky130_fd_pr__nfet_01v8
+ l='150m' w='420m'

xnfet_7
+ f CLKI i VNB
+ sky130_fd_pr__nfet_01v8
+ l='150m' w='360m'

xnfet_8
+ Q_B f VGND VNB
+ sky130_fd_pr__nfet_01v8
+ l='150m' w='650m'

xnfet_9
+ Q Q_B VGND VNB
+ sky130_fd_pr__nfet_01v8
+ l='150m' w='650m'

xpfet_0
+ a D VPWR VPB
+ sky130_fd_pr__pfet_01v8_hvt
+ l='150m' w='420m'

xpfet_1
+ b CLK a VPB
+ sky130_fd_pr__pfet_01v8_hvt
+ l='150m' w='420m'

xpfet_2
+ j c VPWR VPB
+ sky130_fd_pr__pfet_01v8_hvt
+ l='150m' w='420m'

xpfet_3
+ b CLKI j VPB
+ sky130_fd_pr__pfet_01v8_hvt
+ l='150m' w='420m'

xpfet_4
+ c b VPWR VPB
+ sky130_fd_pr__pfet_01v8_hvt
+ l='150m' w='750m'

xpfet_5
+ f CLKI c VPB
+ sky130_fd_pr__pfet_01v8_hvt
+ l='150m' w='420m'

xpfet_6
+ h Q_B VPWR VPB
+ sky130_fd_pr__pfet_01v8_hvt
+ l='150m' w='420m'

xpfet_7
+ f CLK h VPB
+ sky130_fd_pr__pfet_01v8_hvt
+ l='150m' w='420m'

xpfet_8
+ Q_B f VPWR VPB
+ sky130_fd_pr__pfet_01v8_hvt
+ l='150m' w='1000m'

xpfet_9
+ Q Q_B VPWR VPB
+ sky130_fd_pr__pfet_01v8_hvt
+ l='150m' w='1000m'

.ENDS

.SUBCKT LutB_lut_dfxtp_1_4
+ D CLK CLKI Q VPWR VGND VPB VNB
* No parameters

xnfet_0
+ a D VGND VNB
+ sky130_fd_pr__nfet_01v8
+ l='150m' w='420m'

xnfet_1
+ b CLKI a VNB
+ sky130_fd_pr__nfet_01v8
+ l='150m' w='360m'

xnfet_2
+ e c VGND VNB
+ sky130_fd_pr__nfet_01v8
+ l='150m' w='420m'

xnfet_3
+ b CLK e VNB
+ sky130_fd_pr__nfet_01v8
+ l='150m' w='360m'

xnfet_4
+ c b VGND VNB
+ sky130_fd_pr__nfet_01v8
+ l='150m' w='640m'

xnfet_5
+ f CLK c VNB
+ sky130_fd_pr__nfet_01v8
+ l='150m' w='360m'

xnfet_6
+ i Q_B VGND VNB
+ sky130_fd_pr__nfet_01v8
+ l='150m' w='420m'

xnfet_7
+ f CLKI i VNB
+ sky130_fd_pr__nfet_01v8
+ l='150m' w='360m'

xnfet_8
+ Q_B f VGND VNB
+ sky130_fd_pr__nfet_01v8
+ l='150m' w='650m'

xnfet_9
+ Q Q_B VGND VNB
+ sky130_fd_pr__nfet_01v8
+ l='150m' w='650m'

xpfet_0
+ a D VPWR VPB
+ sky130_fd_pr__pfet_01v8_hvt
+ l='150m' w='420m'

xpfet_1
+ b CLK a VPB
+ sky130_fd_pr__pfet_01v8_hvt
+ l='150m' w='420m'

xpfet_2
+ j c VPWR VPB
+ sky130_fd_pr__pfet_01v8_hvt
+ l='150m' w='420m'

xpfet_3
+ b CLKI j VPB
+ sky130_fd_pr__pfet_01v8_hvt
+ l='150m' w='420m'

xpfet_4
+ c b VPWR VPB
+ sky130_fd_pr__pfet_01v8_hvt
+ l='150m' w='750m'

xpfet_5
+ f CLKI c VPB
+ sky130_fd_pr__pfet_01v8_hvt
+ l='150m' w='420m'

xpfet_6
+ h Q_B VPWR VPB
+ sky130_fd_pr__pfet_01v8_hvt
+ l='150m' w='420m'

xpfet_7
+ f CLK h VPB
+ sky130_fd_pr__pfet_01v8_hvt
+ l='150m' w='420m'

xpfet_8
+ Q_B f VPWR VPB
+ sky130_fd_pr__pfet_01v8_hvt
+ l='150m' w='1000m'

xpfet_9
+ Q Q_B VPWR VPB
+ sky130_fd_pr__pfet_01v8_hvt
+ l='150m' w='1000m'

.ENDS

.SUBCKT LutB_lut_dfxtp_1_5
+ D CLK CLKI Q VPWR VGND VPB VNB
* No parameters

xnfet_0
+ a D VGND VNB
+ sky130_fd_pr__nfet_01v8
+ l='150m' w='420m'

xnfet_1
+ b CLKI a VNB
+ sky130_fd_pr__nfet_01v8
+ l='150m' w='360m'

xnfet_2
+ e c VGND VNB
+ sky130_fd_pr__nfet_01v8
+ l='150m' w='420m'

xnfet_3
+ b CLK e VNB
+ sky130_fd_pr__nfet_01v8
+ l='150m' w='360m'

xnfet_4
+ c b VGND VNB
+ sky130_fd_pr__nfet_01v8
+ l='150m' w='640m'

xnfet_5
+ f CLK c VNB
+ sky130_fd_pr__nfet_01v8
+ l='150m' w='360m'

xnfet_6
+ i Q_B VGND VNB
+ sky130_fd_pr__nfet_01v8
+ l='150m' w='420m'

xnfet_7
+ f CLKI i VNB
+ sky130_fd_pr__nfet_01v8
+ l='150m' w='360m'

xnfet_8
+ Q_B f VGND VNB
+ sky130_fd_pr__nfet_01v8
+ l='150m' w='650m'

xnfet_9
+ Q Q_B VGND VNB
+ sky130_fd_pr__nfet_01v8
+ l='150m' w='650m'

xpfet_0
+ a D VPWR VPB
+ sky130_fd_pr__pfet_01v8_hvt
+ l='150m' w='420m'

xpfet_1
+ b CLK a VPB
+ sky130_fd_pr__pfet_01v8_hvt
+ l='150m' w='420m'

xpfet_2
+ j c VPWR VPB
+ sky130_fd_pr__pfet_01v8_hvt
+ l='150m' w='420m'

xpfet_3
+ b CLKI j VPB
+ sky130_fd_pr__pfet_01v8_hvt
+ l='150m' w='420m'

xpfet_4
+ c b VPWR VPB
+ sky130_fd_pr__pfet_01v8_hvt
+ l='150m' w='750m'

xpfet_5
+ f CLKI c VPB
+ sky130_fd_pr__pfet_01v8_hvt
+ l='150m' w='420m'

xpfet_6
+ h Q_B VPWR VPB
+ sky130_fd_pr__pfet_01v8_hvt
+ l='150m' w='420m'

xpfet_7
+ f CLK h VPB
+ sky130_fd_pr__pfet_01v8_hvt
+ l='150m' w='420m'

xpfet_8
+ Q_B f VPWR VPB
+ sky130_fd_pr__pfet_01v8_hvt
+ l='150m' w='1000m'

xpfet_9
+ Q Q_B VPWR VPB
+ sky130_fd_pr__pfet_01v8_hvt
+ l='150m' w='1000m'

.ENDS

.SUBCKT LutB_lut_dfxtp_1_6
+ D CLK CLKI Q VPWR VGND VPB VNB
* No parameters

xnfet_0
+ a D VGND VNB
+ sky130_fd_pr__nfet_01v8
+ l='150m' w='420m'

xnfet_1
+ b CLKI a VNB
+ sky130_fd_pr__nfet_01v8
+ l='150m' w='360m'

xnfet_2
+ e c VGND VNB
+ sky130_fd_pr__nfet_01v8
+ l='150m' w='420m'

xnfet_3
+ b CLK e VNB
+ sky130_fd_pr__nfet_01v8
+ l='150m' w='360m'

xnfet_4
+ c b VGND VNB
+ sky130_fd_pr__nfet_01v8
+ l='150m' w='640m'

xnfet_5
+ f CLK c VNB
+ sky130_fd_pr__nfet_01v8
+ l='150m' w='360m'

xnfet_6
+ i Q_B VGND VNB
+ sky130_fd_pr__nfet_01v8
+ l='150m' w='420m'

xnfet_7
+ f CLKI i VNB
+ sky130_fd_pr__nfet_01v8
+ l='150m' w='360m'

xnfet_8
+ Q_B f VGND VNB
+ sky130_fd_pr__nfet_01v8
+ l='150m' w='650m'

xnfet_9
+ Q Q_B VGND VNB
+ sky130_fd_pr__nfet_01v8
+ l='150m' w='650m'

xpfet_0
+ a D VPWR VPB
+ sky130_fd_pr__pfet_01v8_hvt
+ l='150m' w='420m'

xpfet_1
+ b CLK a VPB
+ sky130_fd_pr__pfet_01v8_hvt
+ l='150m' w='420m'

xpfet_2
+ j c VPWR VPB
+ sky130_fd_pr__pfet_01v8_hvt
+ l='150m' w='420m'

xpfet_3
+ b CLKI j VPB
+ sky130_fd_pr__pfet_01v8_hvt
+ l='150m' w='420m'

xpfet_4
+ c b VPWR VPB
+ sky130_fd_pr__pfet_01v8_hvt
+ l='150m' w='750m'

xpfet_5
+ f CLKI c VPB
+ sky130_fd_pr__pfet_01v8_hvt
+ l='150m' w='420m'

xpfet_6
+ h Q_B VPWR VPB
+ sky130_fd_pr__pfet_01v8_hvt
+ l='150m' w='420m'

xpfet_7
+ f CLK h VPB
+ sky130_fd_pr__pfet_01v8_hvt
+ l='150m' w='420m'

xpfet_8
+ Q_B f VPWR VPB
+ sky130_fd_pr__pfet_01v8_hvt
+ l='150m' w='1000m'

xpfet_9
+ Q Q_B VPWR VPB
+ sky130_fd_pr__pfet_01v8_hvt
+ l='150m' w='1000m'

.ENDS

.SUBCKT LutB_lut_dfxtp_1_7
+ D CLK CLKI Q VPWR VGND VPB VNB
* No parameters

xnfet_0
+ a D VGND VNB
+ sky130_fd_pr__nfet_01v8
+ l='150m' w='420m'

xnfet_1
+ b CLKI a VNB
+ sky130_fd_pr__nfet_01v8
+ l='150m' w='360m'

xnfet_2
+ e c VGND VNB
+ sky130_fd_pr__nfet_01v8
+ l='150m' w='420m'

xnfet_3
+ b CLK e VNB
+ sky130_fd_pr__nfet_01v8
+ l='150m' w='360m'

xnfet_4
+ c b VGND VNB
+ sky130_fd_pr__nfet_01v8
+ l='150m' w='640m'

xnfet_5
+ f CLK c VNB
+ sky130_fd_pr__nfet_01v8
+ l='150m' w='360m'

xnfet_6
+ i Q_B VGND VNB
+ sky130_fd_pr__nfet_01v8
+ l='150m' w='420m'

xnfet_7
+ f CLKI i VNB
+ sky130_fd_pr__nfet_01v8
+ l='150m' w='360m'

xnfet_8
+ Q_B f VGND VNB
+ sky130_fd_pr__nfet_01v8
+ l='150m' w='650m'

xnfet_9
+ Q Q_B VGND VNB
+ sky130_fd_pr__nfet_01v8
+ l='150m' w='650m'

xpfet_0
+ a D VPWR VPB
+ sky130_fd_pr__pfet_01v8_hvt
+ l='150m' w='420m'

xpfet_1
+ b CLK a VPB
+ sky130_fd_pr__pfet_01v8_hvt
+ l='150m' w='420m'

xpfet_2
+ j c VPWR VPB
+ sky130_fd_pr__pfet_01v8_hvt
+ l='150m' w='420m'

xpfet_3
+ b CLKI j VPB
+ sky130_fd_pr__pfet_01v8_hvt
+ l='150m' w='420m'

xpfet_4
+ c b VPWR VPB
+ sky130_fd_pr__pfet_01v8_hvt
+ l='150m' w='750m'

xpfet_5
+ f CLKI c VPB
+ sky130_fd_pr__pfet_01v8_hvt
+ l='150m' w='420m'

xpfet_6
+ h Q_B VPWR VPB
+ sky130_fd_pr__pfet_01v8_hvt
+ l='150m' w='420m'

xpfet_7
+ f CLK h VPB
+ sky130_fd_pr__pfet_01v8_hvt
+ l='150m' w='420m'

xpfet_8
+ Q_B f VPWR VPB
+ sky130_fd_pr__pfet_01v8_hvt
+ l='150m' w='1000m'

xpfet_9
+ Q Q_B VPWR VPB
+ sky130_fd_pr__pfet_01v8_hvt
+ l='150m' w='1000m'

.ENDS

.SUBCKT LutB_buf_3
+ X P A VPWR VGND VPB VNB
* No parameters

xnfet_0
+ P A VGND VNB
+ sky130_fd_pr__nfet_01v8
+ l='150m' w='520m'

xpfet_0
+ P A VPWR VPB
+ sky130_fd_pr__pfet_01v8_hvt
+ l='150m' w='790m'

xnfet_1
+ X P VGND VNB
+ sky130_fd_pr__nfet_01v8
+ l='150m' w='520m'

xpfet_1
+ X P VPWR VPB
+ sky130_fd_pr__pfet_01v8_hvt
+ l='150m' w='790m'

.ENDS

.SUBCKT LutB_sky130_mux
+ S0 S0_B S1 S1_B S2 S2_B input_0 input_1 input_2 input_3 input_4 input_5 input_6 input_7 Z VPB VNB
* No parameters

xupper_left__fet0
+ upper_left__A0 S0_B input_2 VNB
+ sky130_fd_pr__nfet_01v8
+ w='480m' l='170m'

xupper_left__fet1
+ upper_left__A1 S0_B input_0 VNB
+ sky130_fd_pr__nfet_01v8
+ w='480m' l='170m'

xupper_left__fet2
+ input_3 S0 upper_left__A0 VNB
+ sky130_fd_pr__nfet_01v8
+ w='480m' l='170m'

xupper_left__fet3
+ input_1 S0 upper_left__A1 VNB
+ sky130_fd_pr__nfet_01v8
+ w='480m' l='170m'

xupper_left__fet4
+ A0 S1_B upper_left__A1 VNB
+ sky130_fd_pr__nfet_01v8
+ w='480m' l='170m'

xupper_left__fet5
+ upper_left__A0 S1 A0 VNB
+ sky130_fd_pr__nfet_01v8
+ w='480m' l='170m'

xlower_left__fet0
+ lower_left__A0 S0_B input_6 VNB
+ sky130_fd_pr__nfet_01v8
+ w='480m' l='170m'

xlower_left__fet1
+ lower_left__A1 S0_B input_4 VNB
+ sky130_fd_pr__nfet_01v8
+ w='480m' l='170m'

xlower_left__fet2
+ input_7 S0 lower_left__A0 VNB
+ sky130_fd_pr__nfet_01v8
+ w='480m' l='170m'

xlower_left__fet3
+ input_5 S0 lower_left__A1 VNB
+ sky130_fd_pr__nfet_01v8
+ w='480m' l='170m'

xlower_left__fet4
+ A1 S1_B lower_left__A1 VNB
+ sky130_fd_pr__nfet_01v8
+ w='480m' l='170m'

xlower_left__fet5
+ lower_left__A0 S1 A1 VNB
+ sky130_fd_pr__nfet_01v8
+ w='480m' l='170m'

xupper_right__fet0
+ upper_right__A0 S0 input_2 VPB
+ sky130_fd_pr__pfet_01v8
+ w='640m' l='170m'

xupper_right__fet1
+ upper_right__A1 S0 input_0 VPB
+ sky130_fd_pr__pfet_01v8
+ w='640m' l='170m'

xupper_right__fet2
+ input_3 S0_B upper_right__A0 VPB
+ sky130_fd_pr__pfet_01v8
+ w='640m' l='170m'

xupper_right__fet3
+ input_1 S0_B upper_right__A1 VPB
+ sky130_fd_pr__pfet_01v8
+ w='640m' l='170m'

xupper_right__fet4
+ A2 S1 upper_right__A1 VPB
+ sky130_fd_pr__pfet_01v8
+ w='640m' l='170m'

xupper_right__fet5
+ upper_right__A0 S1_B A2 VPB
+ sky130_fd_pr__pfet_01v8
+ w='640m' l='170m'

xlower_right__fet0
+ lower_right__A0 S0 input_6 VPB
+ sky130_fd_pr__pfet_01v8
+ w='640m' l='170m'

xlower_right__fet1
+ lower_right__A1 S0 input_4 VPB
+ sky130_fd_pr__pfet_01v8
+ w='640m' l='170m'

xlower_right__fet2
+ input_7 S0_B lower_right__A0 VPB
+ sky130_fd_pr__pfet_01v8
+ w='640m' l='170m'

xlower_right__fet3
+ input_5 S0_B lower_right__A1 VPB
+ sky130_fd_pr__pfet_01v8
+ w='640m' l='170m'

xlower_right__fet4
+ A3 S1 lower_right__A1 VPB
+ sky130_fd_pr__pfet_01v8
+ w='640m' l='170m'

xlower_right__fet5
+ lower_right__A0 S1_B A3 VPB
+ sky130_fd_pr__pfet_01v8
+ w='640m' l='170m'

xoutput_mux2__nfet0
+ Z S2_B A0 VNB
+ sky130_fd_pr__nfet_01v8
+ w='480m' l='170m'

xoutput_mux2__nfet1
+ A1 S2 Z VNB
+ sky130_fd_pr__nfet_01v8
+ w='480m' l='170m'

xoutput_mux2__pfet0
+ Z S2 A2 VPB
+ sky130_fd_pr__pfet_01v8
+ w='640m' l='170m'

xoutput_mux2__pfet1
+ A3 S2_B Z VPB
+ sky130_fd_pr__pfet_01v8
+ w='640m' l='170m'

.ENDS

.SUBCKT LutB_register_dfxtp
+ D CLK Q VPWR VGND VPB VNB
* No parameters

xnfet_0
+ a D VGND VNB
+ sky130_fd_pr__nfet_01v8
+ l='150m' w='420m'

xnfet_1
+ b CLKI a VNB
+ sky130_fd_pr__nfet_01v8
+ l='150m' w='360m'

xnfet_2
+ e c VGND VNB
+ sky130_fd_pr__nfet_01v8
+ l='150m' w='420m'

xnfet_3
+ b CLK_INT e VNB
+ sky130_fd_pr__nfet_01v8
+ l='150m' w='360m'

xnfet_4
+ c b VGND VNB
+ sky130_fd_pr__nfet_01v8
+ l='150m' w='640m'

xnfet_5
+ f CLK_INT c VNB
+ sky130_fd_pr__nfet_01v8
+ l='150m' w='360m'

xnfet_6
+ i Q_B VGND VNB
+ sky130_fd_pr__nfet_01v8
+ l='150m' w='420m'

xnfet_7
+ f CLKI i VNB
+ sky130_fd_pr__nfet_01v8
+ l='150m' w='360m'

xnfet_8
+ Q_B f VGND VNB
+ sky130_fd_pr__nfet_01v8
+ l='150m' w='650m'

xnfet_9
+ Q Q_B VGND VNB
+ sky130_fd_pr__nfet_01v8
+ l='150m' w='650m'

xpfet_0
+ a D VPWR VPB
+ sky130_fd_pr__pfet_01v8_hvt
+ l='150m' w='420m'

xpfet_1
+ b CLK_INT a VPB
+ sky130_fd_pr__pfet_01v8_hvt
+ l='150m' w='420m'

xpfet_2
+ j c VPWR VPB
+ sky130_fd_pr__pfet_01v8_hvt
+ l='150m' w='420m'

xpfet_3
+ b CLKI j VPB
+ sky130_fd_pr__pfet_01v8_hvt
+ l='150m' w='420m'

xpfet_4
+ c b VPWR VPB
+ sky130_fd_pr__pfet_01v8_hvt
+ l='150m' w='750m'

xpfet_5
+ f CLKI c VPB
+ sky130_fd_pr__pfet_01v8_hvt
+ l='150m' w='420m'

xpfet_6
+ h Q_B VPWR VPB
+ sky130_fd_pr__pfet_01v8_hvt
+ l='150m' w='420m'

xpfet_7
+ f CLK_INT h VPB
+ sky130_fd_pr__pfet_01v8_hvt
+ l='150m' w='420m'

xpfet_8
+ Q_B f VPWR VPB
+ sky130_fd_pr__pfet_01v8_hvt
+ l='150m' w='1000m'

xpfet_9
+ Q Q_B VPWR VPB
+ sky130_fd_pr__pfet_01v8_hvt
+ l='150m' w='1000m'

xnfet_10
+ CLKI CLK VGND VNB
+ sky130_fd_pr__nfet_01v8
+ l='150m' w='420m'

xnfet_11
+ CLK_INT CLKI VGND VNB
+ sky130_fd_pr__nfet_01v8
+ l='150m' w='420m'

xpfet_10
+ CLKI CLK VPWR VPB
+ sky130_fd_pr__pfet_01v8_hvt
+ l='150m' w='640m'

xpfet_11
+ CLK_INT CLKI VPWR VPB
+ sky130_fd_pr__pfet_01v8_hvt
+ l='150m' w='640m'

.ENDS

.SUBCKT LutB_combinational_config_dfxtp
+ D CLK CLKI Q VPWR VGND VPB VNB
* No parameters

xnfet_0
+ a D VGND VNB
+ sky130_fd_pr__nfet_01v8
+ l='150m' w='420m'

xnfet_1
+ b CLKI a VNB
+ sky130_fd_pr__nfet_01v8
+ l='150m' w='360m'

xnfet_2
+ e c VGND VNB
+ sky130_fd_pr__nfet_01v8
+ l='150m' w='420m'

xnfet_3
+ b CLK e VNB
+ sky130_fd_pr__nfet_01v8
+ l='150m' w='360m'

xnfet_4
+ c b VGND VNB
+ sky130_fd_pr__nfet_01v8
+ l='150m' w='640m'

xnfet_5
+ f CLK c VNB
+ sky130_fd_pr__nfet_01v8
+ l='150m' w='360m'

xnfet_6
+ i Q_B VGND VNB
+ sky130_fd_pr__nfet_01v8
+ l='150m' w='420m'

xnfet_7
+ f CLKI i VNB
+ sky130_fd_pr__nfet_01v8
+ l='150m' w='360m'

xnfet_8
+ Q_B f VGND VNB
+ sky130_fd_pr__nfet_01v8
+ l='150m' w='650m'

xnfet_9
+ Q Q_B VGND VNB
+ sky130_fd_pr__nfet_01v8
+ l='150m' w='650m'

xpfet_0
+ a D VPWR VPB
+ sky130_fd_pr__pfet_01v8_hvt
+ l='150m' w='420m'

xpfet_1
+ b CLK a VPB
+ sky130_fd_pr__pfet_01v8_hvt
+ l='150m' w='420m'

xpfet_2
+ j c VPWR VPB
+ sky130_fd_pr__pfet_01v8_hvt
+ l='150m' w='420m'

xpfet_3
+ b CLKI j VPB
+ sky130_fd_pr__pfet_01v8_hvt
+ l='150m' w='420m'

xpfet_4
+ c b VPWR VPB
+ sky130_fd_pr__pfet_01v8_hvt
+ l='150m' w='750m'

xpfet_5
+ f CLKI c VPB
+ sky130_fd_pr__pfet_01v8_hvt
+ l='150m' w='420m'

xpfet_6
+ h Q_B VPWR VPB
+ sky130_fd_pr__pfet_01v8_hvt
+ l='150m' w='420m'

xpfet_7
+ f CLK h VPB
+ sky130_fd_pr__pfet_01v8_hvt
+ l='150m' w='420m'

xpfet_8
+ Q_B f VPWR VPB
+ sky130_fd_pr__pfet_01v8_hvt
+ l='150m' w='1000m'

xpfet_9
+ Q Q_B VPWR VPB
+ sky130_fd_pr__pfet_01v8_hvt
+ l='150m' w='1000m'

.ENDS

.SUBCKT LutB_hd_mux2_1_0_template
+ S A0 A1 X VPWR VGND VPB VNB
* No parameters

xn0
+ S_B S VGND VNB
+ sky130_fd_pr__nfet_01v8
+ l='150m' w='420m'

xn1
+ I1 S VGND VNB
+ sky130_fd_pr__nfet_01v8
+ l='150m' w='420m'

xn2
+ X_B A1 I1 VNB
+ sky130_fd_pr__nfet_01v8
+ l='150m' w='420m'

xn3
+ I3 S_B VGND VNB
+ sky130_fd_pr__nfet_01v8
+ l='150m' w='420m'

xn4
+ X_B A0 I3 VNB
+ sky130_fd_pr__nfet_01v8
+ l='150m' w='420m'

xn5
+ X X_B VGND VNB
+ sky130_fd_pr__nfet_01v8
+ l='150m' w='650m'

xp0
+ S_B S VPWR VPB
+ sky130_fd_pr__pfet_01v8_hvt
+ l='150m' w='420m'

xp1
+ I0 S VPWR VPB
+ sky130_fd_pr__pfet_01v8_hvt
+ l='150m' w='420m'

xp2
+ X_B A0 I0 VPB
+ sky130_fd_pr__pfet_01v8_hvt
+ l='150m' w='420m'

xp3
+ I2 S_B VPWR VPB
+ sky130_fd_pr__pfet_01v8_hvt
+ l='150m' w='420m'

xp4
+ X_B A1 I2 VPB
+ sky130_fd_pr__pfet_01v8_hvt
+ l='150m' w='420m'

xp5
+ X X_B VPWR VPB
+ sky130_fd_pr__pfet_01v8_hvt
+ l='150m' w='1000m'

.ENDS

.SUBCKT LutB_clk_buf_1_template
+ X P A VPWR VGND VPB VNB
* No parameters

xnfet_0
+ P A VGND VNB
+ sky130_fd_pr__nfet_01v8
+ l='150m' w='520m'

xpfet_0
+ P A VPWR VPB
+ sky130_fd_pr__pfet_01v8_hvt
+ l='150m' w='790m'

xnfet_1
+ X P VGND VNB
+ sky130_fd_pr__nfet_01v8
+ l='150m' w='520m'

xpfet_1
+ X P VPWR VPB
+ sky130_fd_pr__pfet_01v8_hvt
+ l='150m' w='790m'

.ENDS

.SUBCKT LutB_buf_1
+ A P X VPWR VGND VPB VNB
* No parameters

xpfet_1
+ Xb A VPWR VPB
+ sky130_fd_pr__pfet_01v8_hvt
+ l='150m' w='1000m'

xnfet_1
+ Xb A VGND VNB
+ sky130_fd_pr__nfet_01v8
+ l='150m' w='600m'

xpfet_2a
+ X Xb VPWR VPB
+ sky130_fd_pr__pfet_01v8_hvt
+ l='150m' w='1000m'

xnfet_2a
+ X Xb VGND VNB
+ sky130_fd_pr__nfet_01v8
+ l='150m' w='600m'

xpfet_2b
+ X Xb VPWR VPB
+ sky130_fd_pr__pfet_01v8_hvt
+ l='150m' w='1000m'

xnfet_2b
+ X Xb VGND VNB
+ sky130_fd_pr__nfet_01v8
+ l='150m' w='600m'

xpfet_0a
+ P A VPWR VPB
+ sky130_fd_pr__pfet_01v8_hvt
+ l='150m' w='1000m'

xnfet_0a
+ P A VGND VNB
+ sky130_fd_pr__nfet_01v8
+ l='150m' w='600m'

xpfet_0b
+ P A VPWR VPB
+ sky130_fd_pr__pfet_01v8_hvt
+ l='150m' w='1000m'

xnfet_0b
+ P A VGND VNB
+ sky130_fd_pr__nfet_01v8
+ l='150m' w='600m'

.ENDS

.SUBCKT LutB
+ S0 S1 S2 S3 X MUX Q CONFIG_IN CONFIG_OUT CLK APP_CLK VPWR VGND
* No parameters

xlut_dfxtp_0_0_i
+ register_select_config_dfxtp_i.Q clk_0 clk_i_0 lut_dfxtp_0_0_i.Q VPWR VGND VPWR VGND
+ LutB_lut_dfxtp_0_0
* No parameters

xlut_dfxtp_0_1_i
+ lut_dfxtp_0_0_i.Q clk_0 clk_i_0 lut_dfxtp_0_1_i.Q VPWR VGND VPWR VGND
+ LutB_lut_dfxtp_0_1
* No parameters

xlut_dfxtp_0_2_i
+ lut_dfxtp_0_1_i.Q clk_0 clk_i_0 lut_dfxtp_0_2_i.Q VPWR VGND VPWR VGND
+ LutB_lut_dfxtp_0_2
* No parameters

xlut_dfxtp_0_3_i
+ lut_dfxtp_0_2_i.Q clk_0 clk_i_0 lut_dfxtp_0_3_i.Q VPWR VGND VPWR VGND
+ LutB_lut_dfxtp_0_3
* No parameters

xlut_dfxtp_0_4_i
+ lut_dfxtp_0_3_i.Q clk_0 clk_i_0 lut_dfxtp_0_4_i.Q VPWR VGND VPWR VGND
+ LutB_lut_dfxtp_0_4
* No parameters

xlut_dfxtp_0_5_i
+ lut_dfxtp_0_4_i.Q clk_0 clk_i_0 lut_dfxtp_0_5_i.Q VPWR VGND VPWR VGND
+ LutB_lut_dfxtp_0_5
* No parameters

xlut_dfxtp_0_6_i
+ lut_dfxtp_0_5_i.Q clk_0 clk_i_0 lut_dfxtp_0_6_i.Q VPWR VGND VPWR VGND
+ LutB_lut_dfxtp_0_6
* No parameters

xlut_dfxtp_0_7_i
+ lut_dfxtp_0_6_i.Q clk_0 clk_i_0 lut_dfxtp_0_7_i.Q VPWR VGND VPWR VGND
+ LutB_lut_dfxtp_0_7
* No parameters

xlut_dfxtp_1_0_i
+ lut_dfxtp_0_7_i.Q clk_1 clk_i_1 lut_dfxtp_1_0_i.Q VPWR VGND VPWR VGND
+ LutB_lut_dfxtp_1_0
* No parameters

xlut_dfxtp_1_1_i
+ lut_dfxtp_1_0_i.Q clk_1 clk_i_1 lut_dfxtp_1_1_i.Q VPWR VGND VPWR VGND
+ LutB_lut_dfxtp_1_1
* No parameters

xlut_dfxtp_1_2_i
+ lut_dfxtp_1_1_i.Q clk_1 clk_i_1 lut_dfxtp_1_2_i.Q VPWR VGND VPWR VGND
+ LutB_lut_dfxtp_1_2
* No parameters

xlut_dfxtp_1_3_i
+ lut_dfxtp_1_2_i.Q clk_1 clk_i_1 lut_dfxtp_1_3_i.Q VPWR VGND VPWR VGND
+ LutB_lut_dfxtp_1_3
* No parameters

xlut_dfxtp_1_4_i
+ lut_dfxtp_1_3_i.Q clk_1 clk_i_1 lut_dfxtp_1_4_i.Q VPWR VGND VPWR VGND
+ LutB_lut_dfxtp_1_4
* No parameters

xlut_dfxtp_1_5_i
+ lut_dfxtp_1_4_i.Q clk_1 clk_i_1 lut_dfxtp_1_5_i.Q VPWR VGND VPWR VGND
+ LutB_lut_dfxtp_1_5
* No parameters

xlut_dfxtp_1_6_i
+ lut_dfxtp_1_5_i.Q clk_1 clk_i_1 lut_dfxtp_1_6_i.Q VPWR VGND VPWR VGND
+ LutB_lut_dfxtp_1_6
* No parameters

xlut_dfxtp_1_7_i
+ lut_dfxtp_1_6_i.Q clk_1 clk_i_1 lut_dfxtp_1_7_i.Q VPWR VGND VPWR VGND
+ LutB_lut_dfxtp_1_7
* No parameters

xmux_0
+ mux_s0 mux_s0_b mux_s1 mux_s1_b mux_s2 mux_s2_b lut_dfxtp_0_1_i.Q lut_dfxtp_0_0_i.Q lut_dfxtp_0_2_i.Q lut_dfxtp_0_3_i.Q lut_dfxtp_1_5_i.Q lut_dfxtp_1_4_i.Q lut_dfxtp_1_6_i.Q lut_dfxtp_1_7_i.Q mux_z0 VPWR VGND
+ LutB_sky130_mux
* No parameters

xmux_1
+ mux_s0 mux_s0_b mux_s1 mux_s1_b mux_s2 mux_s2_b lut_dfxtp_1_2_i.Q lut_dfxtp_1_3_i.Q lut_dfxtp_1_1_i.Q lut_dfxtp_1_0_i.Q lut_dfxtp_0_6_i.Q lut_dfxtp_0_7_i.Q lut_dfxtp_0_5_i.Q lut_dfxtp_0_4_i.Q mux_z1 VPWR VGND
+ LutB_alt_sky130_mux
* No parameters

xbuf_0_i
+ mux_s2 mux_s2_b S2 VPWR VGND VPWR VGND
+ LutB_buf_0
* No parameters

xbuf_1_i
+ S1 mux_s1_b mux_s1 VPWR VGND VPWR VGND
+ LutB_buf_1
* No parameters

xbuf_2_i
+ S0 mux_s0_b mux_s0 VPWR VGND VPWR VGND
+ LutB_buf_2
* No parameters

xclk_buf_0
+ clk_0 clk_i_0 CLK VPWR VGND VPWR VGND
+ LutB_clk_buf_0_template
* No parameters

xbuf_3_i
+ mux_s3 n_0 S3 VPWR VGND VPWR VGND
+ LutB_buf_3
* No parameters

xclk_buf_1
+ clk_1 clk_i_1 CLK VPWR VGND VPWR VGND
+ LutB_clk_buf_1_template
* No parameters

xhd_mux2_1_0
+ mux_s3 mux_z0 mux_z1 Z VPWR VGND VPWR VGND
+ LutB_hd_mux2_1_0_template
* No parameters

xregister_select_hd_mux2_1_i
+ register_select_config_dfxtp_i.Q Z X reg_flop_in VPWR VGND VPWR VGND
+ LutB_register_select_hd_mux2_1
* No parameters

xregister_dfxtp_i
+ reg_flop_in APP_CLK Q VPWR VGND VPWR VGND
+ LutB_register_dfxtp
* No parameters

xregister_select_config_dfxtp_i
+ CONFIG_IN clk_0 clk_i_0 register_select_config_dfxtp_i.Q VPWR VGND VPWR VGND
+ LutB_register_select_config_dfxtp
* No parameters

xcombinational_select_hd_mux2_1_i
+ CONFIG_OUT Z X MUX VPWR VGND VPWR VGND
+ LutB_combinational_select_hd_mux2_1
* No parameters

xcombinational_config_dfxtp_i
+ lut_dfxtp_1_7_i.Q clk_1 clk_i_1 CONFIG_OUT VPWR VGND VPWR VGND
+ LutB_combinational_config_dfxtp
* No parameters

xsky130_decap_1380x2720_i0
+ VPWR VGND VPWR VGND
+ sky130_decap_1380x2720
* No parameters

.ENDS
