xnfet_0
+ a D VGND VNB
+ sky130_fd_pr__nfet_01v8
+ PARAMS: l={150m} w={420m}

xnfet_1
+ b CLKI a VNB
+ sky130_fd_pr__nfet_01v8
+ PARAMS: l={150m} w={360m}

xnfet_2
+ e c VGND VNB
+ sky130_fd_pr__nfet_01v8
+ PARAMS: l={150m} w={420m}

xnfet_3
+ b CLK e VNB
+ sky130_fd_pr__nfet_01v8
+ PARAMS: l={150m} w={360m}

xnfet_4
+ c b VGND VNB
+ sky130_fd_pr__nfet_01v8
+ PARAMS: l={150m} w={640m}

xnfet_5
+ f CLK c VNB
+ sky130_fd_pr__nfet_01v8
+ PARAMS: l={150m} w={360m}

xnfet_6
+ i Q_B VGND VNB
+ sky130_fd_pr__nfet_01v8
+ PARAMS: l={150m} w={420m}

xnfet_7
+ f CLKI i VNB
+ sky130_fd_pr__nfet_01v8
+ PARAMS: l={150m} w={360m}

xnfet_8
+ Q_B f VGND VNB
+ sky130_fd_pr__nfet_01v8
+ PARAMS: l={150m} w={650m}

xnfet_9
+ Q Q_B VGND VNB
+ sky130_fd_pr__nfet_01v8
+ PARAMS: l={150m} w={reg_out_nfet_width}

xpfet_0
+ a D VPWR VPB
+ sky130_fd_pr__pfet_01v8_hvt
+ PARAMS: l={150m} w={420m}

xpfet_1
+ b CLK a VPB
+ sky130_fd_pr__pfet_01v8_hvt
+ PARAMS: l={150m} w={420m}

xpfet_2
+ j c VPWR VPB
+ sky130_fd_pr__pfet_01v8_hvt
+ PARAMS: l={150m} w={420m}

xpfet_3
+ b CLKI j VPB
+ sky130_fd_pr__pfet_01v8_hvt
+ PARAMS: l={150m} w={420m}

xpfet_4
+ c b VPWR VPB
+ sky130_fd_pr__pfet_01v8_hvt
+ PARAMS: l={150m} w={750m}

xpfet_5
+ f CLKI c VPB
+ sky130_fd_pr__pfet_01v8_hvt
+ PARAMS: l={150m} w={420m}

xpfet_6
+ h Q_B VPWR VPB
+ sky130_fd_pr__pfet_01v8_hvt
+ PARAMS: l={150m} w={420m}

xpfet_7
+ f CLK h VPB
+ sky130_fd_pr__pfet_01v8_hvt
+ PARAMS: l={150m} w={420m}

xpfet_8
+ Q_B f VPWR VPB
+ sky130_fd_pr__pfet_01v8_hvt
+ PARAMS: l={150m} w={1000m}

xpfet_9
+ Q Q_B VPWR VPB
+ sky130_fd_pr__pfet_01v8_hvt
+ PARAMS: l={150m} w={reg_out_pfet_width}
