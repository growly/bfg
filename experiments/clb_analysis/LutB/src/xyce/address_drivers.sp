* This is 100 random addresses, chosen so that the output toggles at each
* transition.

va3_driver a3 VSS pat ({1.8} {0} {test_start} {50p} {50p} {read_clock / 2} b011101000100110001011010001010100010010001100001111111101011001000001110001011110011111000000010010000 0)
va2_driver a2 VSS pat ({1.8} {0} {test_start} {50p} {50p} {read_clock / 2} b001000101111111001000001001101001111110010010010001100001001111100011001110000011101011011010000101010 0)
va1_driver a1 VSS pat ({1.8} {0} {test_start} {50p} {50p} {read_clock / 2} b011100101110110101011010111000100111011010001110111101011000101111111111010001111011100011011100110100 0)
va0_driver a0 VSS pat ({1.8} {0} {test_start} {50p} {50p} {read_clock / 2} b001010101010101010101010101010101010101010101010101010101010101010101010101010101010101010101010101010 0)
