.param s2_pfet_width=790m
.param s2_nfet_width=510m
.param s0s1_pfet_width=800m
.param s0s1_nfet_width=620m
.param mux_nfet_width=640m
.param mux_pfet_width=480m
.param reg_out_nfet_width=650m
.param reg_out_pfet_width=1000m
