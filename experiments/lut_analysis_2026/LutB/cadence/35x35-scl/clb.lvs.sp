$ Spice netlist generated by v2lvs
$ v2024.3_16.10    Tue Jul 9 11:27:02 PDT 2024
*.BUSDELIMITER [

.SUBCKT clb clk addr[3] addr[2] addr[1] addr[0] x mux q scan_clk scan_en
+ scan_in[0] scan_out[0] VDD VSS
XFE_OFC1_scan_out_0 FE_OFN1_scan_out_0 scan_out[0] VDD VSS BUFX16
XFE_OFC0_q FE_OFN0_q q VDD VSS BUFX16
Xq_reg_reg clk n_15 FE_OFN0_q UNCONNECTED q_control x VDD VSS SDFFX1
Xg493__2398 n_15 x FE_OFN1_scan_out_0 mux VDD VSS MX2X4
Xg494__5107 n_13 n_14 addr[3] n_15 VDD VSS MX2X1
Xg495__6260 addr[2] n_5 n_12 n_9 n_11 n_3 n_14 VDD VSS OAI222X1
Xg496__4319 addr[2] n_6 n_12 n_10 n_11 n_4 n_13 VDD VSS OAI222X1
Xg497__8428 n_8 mem[4] addr[0] n_0 n_7 mem[6] n_10 VDD VSS AOI222X1
Xg498__5526 n_8 mem[12] addr[0] n_1 n_7 mem[14] n_9 VDD VSS AOI222X1
Xg509__6783 n_8 mem[0] n_7 mem[2] n_6 VDD VSS AOI22X1
Xg510__3680 n_8 mem[8] n_7 mem[10] n_5 VDD VSS AOI22X1
Xg521__1617 n_2 mem[1] addr[1] mem[3] n_4 VDD VSS AOI22X1
Xg522__2802 n_2 mem[9] addr[1] mem[11] n_3 VDD VSS AOI22X1
Xmem_reg[5] scan_clk mem[5] mem[5] UNCONNECTED0 scan_en mem[14] VDD VSS SDFFX1
Xmem_reg[2] scan_clk mem[2] mem[2] UNCONNECTED1 scan_en mem[0] VDD VSS SDFFX1
Xmux_control_reg scan_clk FE_OFN1_scan_out_0 FE_OFN1_scan_out_0 UNCONNECTED2
+ scan_en mem[11] VDD VSS SDFFX1
Xmem_reg[9] scan_clk mem[9] mem[9] UNCONNECTED3 scan_en mem[10] VDD VSS SDFFX1
Xmem_reg[12] scan_clk mem[12] mem[12] UNCONNECTED4 scan_en mem[6] VDD VSS
+ SDFFX1
Xmem_reg[13] scan_clk mem[13] mem[13] UNCONNECTED5 scan_en mem[15] VDD VSS
+ SDFFX1
Xmem_reg[14] scan_clk mem[14] mem[14] UNCONNECTED6 scan_en mem[12] VDD VSS
+ SDFFX1
Xmem_reg[15] scan_clk mem[15] mem[15] UNCONNECTED7 scan_en mem[7] VDD VSS
+ SDFFX1
Xmem_reg[3] scan_clk mem[3] mem[3] UNCONNECTED8 scan_en q_control VDD VSS
+ SDFFX1
Xmem_reg[0] scan_clk mem[0] mem[0] UNCONNECTED9 scan_en mem[13] VDD VSS SDFFX1
Xmem_reg[1] scan_clk mem[1] mem[1] UNCONNECTED10 scan_en mem[3] VDD VSS SDFFX1
Xq_control_reg scan_clk q_control q_control UNCONNECTED11 scan_en scan_in[0]
+ VDD VSS SDFFX1
Xmem_reg[6] scan_clk mem[6] mem[6] UNCONNECTED12 scan_en mem[4] VDD VSS SDFFX1
Xmem_reg[7] scan_clk mem[7] mem[7] UNCONNECTED13 scan_en mem[5] VDD VSS SDFFX1
Xmem_reg[8] scan_clk mem[8] mem[8] UNCONNECTED14 scan_en mem[2] VDD VSS SDFFX1
Xmem_reg[10] scan_clk mem[10] mem[10] UNCONNECTED15 scan_en mem[8] VDD VSS
+ SDFFX1
Xmem_reg[11] scan_clk mem[11] mem[11] UNCONNECTED16 scan_en mem[9] VDD VSS
+ SDFFX1
Xmem_reg[4] scan_clk mem[4] mem[4] UNCONNECTED17 scan_en mem[1] VDD VSS SDFFX1
Xg519__1705 mem[13] mem[15] addr[1] n_1 VDD VSS MX2X1
Xg520__5122 mem[5] mem[7] addr[1] n_0 VDD VSS MX2X1
Xg523__8246 addr[0] n_12 n_11 VDD VSS NAND2X1
Xg524__7098 addr[0] n_2 n_7 VDD VSS NOR2X1
Xg525__6131 addr[0] addr[1] n_8 VDD VSS NOR2X1
Xg527 addr[1] n_2 VDD VSS INVX1
Xg526 addr[2] n_12 VDD VSS INVX1
.ENDS
