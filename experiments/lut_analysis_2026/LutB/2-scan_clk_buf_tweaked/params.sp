; from collated results
.param cbn=590m
.param cbp=980m
