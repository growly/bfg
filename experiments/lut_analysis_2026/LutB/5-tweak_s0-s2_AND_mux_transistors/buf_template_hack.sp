xnfet_0
+ P A VGND VNB
+ sky130_fd_pr__nfet_01v8
+ PARAMS: l={150m} w={buffer_nfet_width}

xpfet_0
+ P A VPWR VPB
+ sky130_fd_pr__pfet_01v8_hvt
+ PARAMS: l={150m} w={buffer_pfet_width}

xnfet_1
+ X P VGND VNB
+ sky130_fd_pr__nfet_01v8
+ PARAMS: l={150m} w={buffer_nfet_width}

xpfet_1
+ X P VPWR VPB
+ sky130_fd_pr__pfet_01v8_hvt
+ PARAMS: l={150m} w={buffer_pfet_width}
